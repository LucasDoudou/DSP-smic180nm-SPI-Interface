//*Spectre Lib Format
simulator lang=spectre  insensitive=yes

library ms018_v1p7
// * This file contains 1.8V, 3.3V, BJT, resistor and MIM corner model parameters.
// * Five corners are supported: TT, FF, SS, SNFP, and FNSP.
// * This file should be used with the model parameter file 'ms018_v1p7_spe.mdl', 'ms018_v1p7_bjt_spe.mdl',
// * 'ms018_v1p7_res_spe.mdl' and 'ms018_v1p7_mim_spe.mdl'.
// * No part of this file can be released without the consent of SMIC.

section tt
// *1.8V core NMOS
parameters dtox_n18 = 0
parameters dxl_n18 = 0
parameters dxw_n18 = 0
parameters dvth_n18 = 0
parameters dcj_n18 = 0
parameters dcjsw_n18 = 0
parameters dcjswg_n18 = 0
parameters dcgdo_n18 = 0
parameters dcgso_n18 = 0
parameters dpvth0_n18 = 0
// *1.8V core PMOS
parameters dtox_p18 = 0
parameters dxl_p18 = 0
parameters dxw_p18 = 0
parameters dvth_p18 = 0
parameters dcj_p18 = 0
parameters dcjsw_p18 = 0
parameters dcjswg_p18 = 0
parameters dcgdo_p18 = 0
parameters dcgso_p18 = 0
parameters dpvth0_p18 = 0
// *3.3V IO NMOS
parameters dtox_n33 = 0
parameters dxl_n33 = 0
parameters dxw_n33 = 0
parameters dvth_n33 = 0
parameters dcj_n33 = 0
parameters dcjsw_n33 = 0
parameters dcjswg_n33 = 0
parameters dcgdo_n33 = 0
parameters dcgso_n33 = 0
parameters dpvth0_n33 = 0
// *3.3V IO PMOS
parameters dtox_p33 = 0
parameters dxl_p33 = 0
parameters dxw_p33 = 0
parameters dvth_p33 = 0
parameters dcj_p33 = 0
parameters dcjsw_p33 = 0
parameters dcjswg_p33 = 0
parameters dcgdo_p33 = 0
parameters dcgso_p33 = 0
parameters dpvth0_p33 = 0
// *1.8V CORE NATIVE NMOS
parameters dtox_nnt18 = 0
parameters dxl_nnt18 = 0
parameters dxw_nnt18 = 0
parameters dvth_nnt18 = 0
parameters dcj_nnt18 = 0
parameters dcjsw_nnt18 = 0
parameters dcjswg_nnt18 = 0
parameters dcgdo_nnt18 = 0
parameters dcgso_nnt18 = 0
parameters dpvth0_nnt18 = 0
// *3.3V IO NATIVE NMOS
parameters dtox_nnt33 = 0
parameters dxl_nnt33 = 0
parameters dxw_nnt33 = 0
parameters dvth_nnt33 = 0
parameters dcj_nnt33 = 0
parameters dcjsw_nnt33 = 0
parameters dcjswg_nnt33 = 0
parameters dcgdo_nnt33 = 0
parameters dcgso_nnt33 = 0
parameters dpvth0_nnt33 = 0
// *1.8V core MEDIUM NMOS
parameters dtox_nmvt18 = 0
parameters dxl_nmvt18 = 0
parameters dxw_nmvt18 = 0
parameters dvth_nmvt18 = 0
parameters dcj_nmvt18 = 0
parameters dcjsw_nmvt18 = 0
parameters dcjswg_nmvt18 = 0
parameters dcgdo_nmvt18 = 0
parameters dcgso_nmvt18 = 0
parameters dpvth0_nmvt18 = 0
// *1.8V core MEDIUM PMOS
parameters dtox_pmvt18 = 0
parameters dxl_pmvt18 = 0
parameters dxw_pmvt18 = 0
parameters dvth_pmvt18 = 0
parameters dcj_pmvt18 = 0
parameters dcjsw_pmvt18 = 0
parameters dcjswg_pmvt18 = 0
parameters dcgdo_pmvt18 = 0
parameters dcgso_pmvt18 = 0
parameters dpvth0_pmvt18 = 0
// *3.3V IO MEDIUM NMOS
parameters dtox_nmvt33 = 0
parameters dxl_nmvt33 = 0
parameters dxw_nmvt33 = 0
parameters dvth_nmvt33 = 0
parameters dcj_nmvt33 = 0
parameters dcjsw_nmvt33 = 0
parameters dcjswg_nmvt33 = 0
parameters dcgdo_nmvt33 = 0
parameters dcgso_nmvt33 = 0
parameters dpvth0_nmvt33 = 0
include "ms018_v1p7_spe.mdl"
endsection tt

section ff
// *1.8V core NMOS
parameters dtox_n18 = -1.0e-10
parameters dxl_n18 = -1.0e-8
parameters dxw_n18 = 2.2e-8
parameters dvth_n18 = -0.04
parameters dcj_n18 = -4.84e-5
parameters dcjsw_n18 = -3.975e-12
parameters dcjswg_n18 = -2.09e-11
parameters dcgdo_n18 = 1.85e-11
parameters dcgso_n18 = 1.85e-11
parameters dpvth0_n18 = -3e-15
// *1.8V core PMOS
parameters dtox_p18 = -1.0e-10
parameters dxl_p18 = -1.0e-8
parameters dxw_p18 = 2.2e-8
parameters dvth_p18 = 0.02
parameters dcj_p18 = -5.35e-5
parameters dcjsw_p18 = -4.945e-12
parameters dcjswg_p18 = -2.535e-11
parameters dcgdo_p18 = 2.1e-11
parameters dcgso_p18 = 2.1e-11
parameters dpvth0_p18 = 1e-15
// *3.3V IO NMOS
parameters dtox_n33 = -3.0e-10
parameters dxl_n33 = -1.4e-8
parameters dxw_n33 = 2.2e-8
parameters dvth_n33 = -0.05
parameters dcj_n33 = -4.225e-5
parameters dcjsw_n33 = -4.575e-12
parameters dcjswg_n33 = -1.705e-11
parameters dcgdo_n33 = 1.93e-11
parameters dcgso_n33 = 1.93e-11
parameters dpvth0_n33 = -3.5e-15
// *3.3V IO PMOS
parameters dtox_p33 = -3.0e-10
parameters dxl_p33 = -1.4e-8
parameters dxw_p33 = 2.2e-8
parameters dvth_p33 = 0.04
parameters dcj_p33 = -5.05e-5
parameters dcjsw_p33 = -4.48e-12
parameters dcjswg_p33 = -1.595e-11
parameters dcgdo_p33 = 1.615e-11
parameters dcgso_p33 = 1.615e-11
parameters dpvth0_p33 = 2e-15
// *1.8V CORE NATIVE NMOS
parameters dtox_nnt18 = -1.0e-10
parameters dxl_nnt18 = -1.0e-8
parameters dxw_nnt18 = 2.2e-8
parameters dvth_nnt18 = -0.095
parameters dcj_nnt18 = -7.25e-6
parameters dcjsw_nnt18 = -8.15e-12
parameters dcjswg_nnt18 = -5.0e-12
parameters dcgdo_nnt18 = 1.33e-11
parameters dcgso_nnt18 = 1.33e-11
parameters dpvth0_nnt18 = -1e-15
// *3.3V IO NATIVE NMOS
parameters dtox_nnt33 = -3.0e-10
parameters dxl_nnt33 = -1.4e-8
parameters dxw_nnt33 = 2.5e-8
parameters dvth_nnt33 = -0.093
parameters dcj_nnt33 = -7.4e-6
parameters dcjsw_nnt33 = -1.08e-11
parameters dcjswg_nnt33 = -6.0e-12
parameters dcgdo_nnt33 = 6.7e-12
parameters dcgso_nnt33 = 6.7e-12
parameters dpvth0_nnt33 = -6e-15
// *1.8V core MEDIUM NMOS
parameters dtox_nmvt18 = -1.0e-10
parameters dxl_nmvt18 = -1.0e-8
parameters dxw_nmvt18 = 2.2e-8
parameters dvth_nmvt18 = -0.083
parameters dcj_nmvt18 = -4.67e-5
parameters dcjsw_nmvt18 = -3.91e-12
parameters dcjswg_nmvt18 = -2.125e-11
parameters dcgdo_nmvt18 = 2.09e-11
parameters dcgso_nmvt18 = 2.09e-11
parameters dpvth0_nmvt18 = -3e-15
// *1.8V core MEDIUM PMOS
parameters dtox_pmvt18 = -1.0e-10
parameters dxl_pmvt18 = -1.0e-8
parameters dxw_pmvt18 = 2.2e-8
parameters dvth_pmvt18 = 0.06
parameters dcj_pmvt18 = -3.67e-5
parameters dcjsw_pmvt18 = -3.07e-12
parameters dcjswg_pmvt18 = -3.075e-11
parameters dcgdo_pmvt18 = 2.43e-11
parameters dcgso_pmvt18 = 2.43e-11
parameters dpvth0_pmvt18 = 1e-15
// *3.3V IO MEDIUM NMOS
parameters dtox_nmvt33 = -3.0e-10
parameters dxl_nmvt33 = -1.4e-8
parameters dxw_nmvt33 = 2.2e-8
parameters dvth_nmvt33 = -0.059
parameters dcj_nmvt33 = -4.285e-5
parameters dcjsw_nmvt33 = -5.5e-12
parameters dcjswg_nmvt33 = -1.725e-11
parameters dcgdo_nmvt33 = 2.495e-11
parameters dcgso_nmvt33 = 2.495e-11
parameters dpvth0_nmvt33 = -6e-15
include "ms018_v1p7_spe.mdl"
endsection ff

section ss
// *1.8V core NMOS
parameters dtox_n18 = 1.0e-10
parameters dxl_n18 = 1.0e-8
parameters dxw_n18 = -2.2e-8
parameters dvth_n18 = 0.045
parameters dcj_n18 = 4.84e-5
parameters dcjsw_n18 = 3.975e-12
parameters dcjswg_n18 = 2.09e-11
parameters dcgdo_n18 = -1.85e-11
parameters dcgso_n18 = -1.85e-11
parameters dpvth0_n18 = 3e-15
// *1.8V core PMOS
parameters dtox_p18 = 1.0e-10
parameters dxl_p18 = 1.0e-8
parameters dxw_p18 = -2.2e-8
parameters dvth_p18 = -0.02
parameters dcj_p18 = 5.35e-5
parameters dcjsw_p18 = 4.945e-12
parameters dcjswg_p18 = 2.535e-11
parameters dcgdo_p18 = -2.1e-11
parameters dcgso_p18 = -2.1e-11
parameters dpvth0_p18 = -1e-15
// *3.3V IO NMOS
parameters dtox_n33 = 3.0e-10
parameters dxl_n33 = 1.4e-8
parameters dxw_n33 = -2.2e-8
parameters dvth_n33 = 0.05
parameters dcj_n33 = 4.225e-5
parameters dcjsw_n33 = 4.575e-12
parameters dcjswg_n33 = 1.705e-11
parameters dcgdo_n33 = -1.93e-11
parameters dcgso_n33 = -1.93e-11
parameters dpvth0_n33 = 3.5e-15
// *3.3V IO PMOS
parameters dtox_p33 = 3.0e-10
parameters dxl_p33 = 1.4e-8
parameters dxw_p33 = -2.2e-8
parameters dvth_p33 = -0.04
parameters dcj_p33 = 5.05e-5
parameters dcjsw_p33 = 4.48e-12
parameters dcjswg_p33 = 1.595e-11
parameters dcgdo_p33 = -1.615e-11
parameters dcgso_p33 = -1.615e-11
parameters dpvth0_p33 = -2e-15
// *1.8V CORE NATIVE NMOS
parameters dtox_nnt18 = 1.0e-10
parameters dxl_nnt18 = 1.0e-8
parameters dxw_nnt18 = -2.2e-8
parameters dvth_nnt18 = 0.095
parameters dcj_nnt18 = 7.25e-6
parameters dcjsw_nnt18 = 8.15e-12
parameters dcjswg_nnt18 = 5.0e-12
parameters dcgdo_nnt18 = -1.33e-11
parameters dcgso_nnt18 = -1.33e-11
parameters dpvth0_nnt18 = 1e-15
// *3.3V IO NATIVE NMOS
parameters dtox_nnt33 = 3.0e-10
parameters dxl_nnt33 = 1.4e-8
parameters dxw_nnt33 = -2.5e-8
parameters dvth_nnt33 = 0.093
parameters dcj_nnt33 = 7.4e-6
parameters dcjsw_nnt33 = 1.08e-11
parameters dcjswg_nnt33 = 6.0e-12
parameters dcgdo_nnt33 = -6.7e-12
parameters dcgso_nnt33 = -6.7e-12
parameters dpvth0_nnt33 = 6e-15
// *1.8V core MEDIUM NMOS
parameters dtox_nmvt18 = 1.0e-10
parameters dxl_nmvt18 = 1.0e-8
parameters dxw_nmvt18 = -2.2e-8
parameters dvth_nmvt18 = 0.083
parameters dcj_nmvt18 = 4.67e-5
parameters dcjsw_nmvt18 = 3.91e-12
parameters dcjswg_nmvt18 = 2.125e-11
parameters dcgdo_nmvt18 = -2.09e-11
parameters dcgso_nmvt18 = -2.09e-11
parameters dpvth0_nmvt18 = 3e-15
// *1.8V core MEDIUM PMOS
parameters dtox_pmvt18 = 1.0e-10
parameters dxl_pmvt18 = 1.0e-8
parameters dxw_pmvt18 = -2.2e-8
parameters dvth_pmvt18 = -0.06
parameters dcj_pmvt18 = 3.67e-5
parameters dcjsw_pmvt18 = 3.07e-12
parameters dcjswg_pmvt18 = 3.075e-11
parameters dcgdo_pmvt18 = -2.43e-11
parameters dcgso_pmvt18 = -2.43e-11
parameters dpvth0_pmvt18 = -1e-15
// *3.3V IO MEDIUM NMOS
parameters dtox_nmvt33 = 3.0e-10
parameters dxl_nmvt33 = 1.4e-8
parameters dxw_nmvt33 = -2.2e-8
parameters dvth_nmvt33 = 0.059
parameters dcj_nmvt33 = 4.285e-5
parameters dcjsw_nmvt33 = 5.5e-12
parameters dcjswg_nmvt33 = 1.725e-11
parameters dcgdo_nmvt33 = -2.495e-11
parameters dcgso_nmvt33 = -2.495e-11
parameters dpvth0_nmvt33 = 6e-15
include "ms018_v1p7_spe.mdl"
endsection ss

section fnsp
// *1.8V core NMOS
parameters dtox_n18 = 0
parameters dxl_n18 = -1.00e-8
parameters dxw_n18 = 1.8e-8
parameters dvth_n18 = -0.04
parameters dcj_n18 = -4.84e-5
parameters dcjsw_n18 = -3.975e-12
parameters dcjswg_n18 = -2.09e-11
parameters dcgdo_n18 = 0
parameters dcgso_n18 = 0
parameters dpvth0_n18 = -3e-15
// *1.8V core PMOS
parameters dtox_p18 = 0
parameters dxl_p18 = 1.00e-8
parameters dxw_p18 = -1.8e-8
parameters dvth_p18 = -0.02
parameters dcj_p18 = 5.35e-5
parameters dcjsw_p18 = 4.945e-12
parameters dcjswg_p18 = 2.535e-11
parameters dcgdo_p18 = 0
parameters dcgso_p18 = 0
parameters dpvth0_p18 = -1e-15
// *3.3V IO NMOS
parameters dtox_n33 = 0
parameters dxl_n33 = -1.15e-8
parameters dxw_n33 = 1.8e-8
parameters dvth_n33 = -0.05
parameters dcj_n33 = -4.225e-5
parameters dcjsw_n33 = -4.575e-12
parameters dcjswg_n33 = -1.705e-11
parameters dcgdo_n33 = 0
parameters dcgso_n33 = 0
parameters dpvth0_n33 = -3.5e-15
// *3.3V IO PMOS
parameters dtox_p33 = 0
parameters dxl_p33 = 1.15e-8
parameters dxw_p33 = -1.8e-8
parameters dvth_p33 = -0.04
parameters dcj_p33 = 5.05e-5
parameters dcjsw_p33 = 4.48e-12
parameters dcjswg_p33 = 1.595e-11
parameters dcgdo_p33 = 0
parameters dcgso_p33 = 0
parameters dpvth0_p33 = -2e-15
// *1.8V core NATIVE NMOS
parameters dtox_nnt18 = 0
parameters dxl_nnt18 = -1.00e-8
parameters dxw_nnt18 = 1.8e-8
parameters dvth_nnt18 = -0.095
parameters dcj_nnt18 = -7.25e-6
parameters dcjsw_nnt18 = -8.15e-12
parameters dcjswg_nnt18 = -5e-12
parameters dcgdo_nnt18 = 0
parameters dcgso_nnt18 = 0
parameters dpvth0_nnt18 = -1e-15
// *3.3V IO NATIVE NMOS
parameters dtox_nnt33 = 0
parameters dxl_nnt33 = -1.15e-8
parameters dxw_nnt33 = 1.8e-8
parameters dvth_nnt33 = -0.093
parameters dcj_nnt33 = -7.4e-6
parameters dcjsw_nnt33 = -1.08e-11
parameters dcjswg_nnt33 = -6.0e-12
parameters dcgdo_nnt33 = 0
parameters dcgso_nnt33 = 0
parameters dpvth0_nnt33 = -6e-15
// *1.8V core MEDIUM NMOS
parameters dtox_nmvt18 = 0
parameters dxl_nmvt18 = -1.00e-8
parameters dxw_nmvt18 = 1.8e-8
parameters dvth_nmvt18 = -0.083
parameters dcj_nmvt18 = -4.67e-5
parameters dcjsw_nmvt18 = -3.91e-12
parameters dcjswg_nmvt18 = -2.125e-11
parameters dcgdo_nmvt18 = 0
parameters dcgso_nmvt18 = 0
parameters dpvth0_nmvt18 = -3e-15
// *1.8V core MEDIUM PMOS
parameters dtox_pmvt18 = 0
parameters dxl_pmvt18 = 1.00e-8
parameters dxw_pmvt18 = -1.8e-8
parameters dvth_pmvt18 = -0.06
parameters dcj_pmvt18 = 3.67e-5
parameters dcjsw_pmvt18 = 3.07e-12
parameters dcjswg_pmvt18 = 3.075e-11
parameters dcgdo_pmvt18 = 0
parameters dcgso_pmvt18 = 0
parameters dpvth0_pmvt18 = -1e-15
// *3.3V IO MEDIUM NMOS
parameters dtox_nmvt33 = 0
parameters dxl_nmvt33 = -1.15e-8
parameters dxw_nmvt33 = 1.8e-8
parameters dvth_nmvt33 = -0.059
parameters dcj_nmvt33 = -4.285e-5
parameters dcjsw_nmvt33 = -5.5e-12
parameters dcjswg_nmvt33 = -1.725e-11
parameters dcgdo_nmvt33 = 0
parameters dcgso_nmvt33 = 0
parameters dpvth0_nmvt33 = -6e-15
include "ms018_v1p7_spe.mdl"
endsection fnsp

section snfp
// *1.8V core NMOS
parameters dtox_n18 = 0
parameters dxl_n18 = 1.00e-8
parameters dxw_n18 = -1.8e-8
parameters dvth_n18 = 0.045
parameters dcj_n18 = 4.84e-5
parameters dcjsw_n18 = 3.975e-12
parameters dcjswg_n18 = 2.09e-11
parameters dcgdo_n18 = 0
parameters dcgso_n18 = 0
parameters dpvth0_n18 = 3e-15
// *1.8V core PMOS
parameters dtox_p18 = 0
parameters dxl_p18 = -1.00e-8
parameters dxw_p18 = 1.8e-8
parameters dvth_p18 = 0.02
parameters dcj_p18 = -5.35e-5
parameters dcjsw_p18 = -4.945e-12
parameters dcjswg_p18 = -2.535e-11
parameters dcgdo_p18 = 0
parameters dcgso_p18 = 0
parameters dpvth0_p18 = 1e-15
// *3.3V IO NMOS
parameters dtox_n33 = 0
parameters dxl_n33 = 1.15e-8
parameters dxw_n33 = -1.8e-8
parameters dvth_n33 = 0.05
parameters dcj_n33 = 4.225e-5
parameters dcjsw_n33 = 4.575e-12
parameters dcjswg_n33 = 1.705e-11
parameters dcgdo_n33 = 0
parameters dcgso_n33 = 0
parameters dpvth0_n33 = 3.5e-15
// *3.3V IO PMOS
parameters dtox_p33 = 0
parameters dxl_p33 = -1.15e-8
parameters dxw_p33 = 1.8e-8
parameters dvth_p33 = 0.04
parameters dcj_p33 = -5.05e-5
parameters dcjsw_p33 = -4.48e-12
parameters dcjswg_p33 = -1.595e-11
parameters dcgdo_p33 = 0
parameters dcgso_p33 = 0
parameters dpvth0_p33 = 2e-15
// *1.8V core NATIVE NMOS
parameters dtox_nnt18 = 0
parameters dxl_nnt18 = 1.00e-8
parameters dxw_nnt18 = -1.8e-8
parameters dvth_nnt18 = 0.095
parameters dcj_nnt18 = 7.25e-6
parameters dcjsw_nnt18 = 8.15e-12
parameters dcjswg_nnt18 = 5e-12
parameters dcgdo_nnt18 = 0
parameters dcgso_nnt18 = 0
parameters dpvth0_nnt18 = 1e-15
// *3.3V IO NATIVE NMOS
parameters dtox_nnt33 = 0
parameters dxl_nnt33 = 1.15e-8
parameters dxw_nnt33 = -1.8e-8
parameters dvth_nnt33 = 0.093
parameters dcj_nnt33 = 7.4e-6
parameters dcjsw_nnt33 = 1.08e-11
parameters dcjswg_nnt33 = 6.0e-12
parameters dcgdo_nnt33 = 0
parameters dcgso_nnt33 = 0
parameters dpvth0_nnt33 = 6e-15
// *1.8V core MEDIUM NMOS
parameters dtox_nmvt18 = 0
parameters dxl_nmvt18 = 1.00e-8
parameters dxw_nmvt18 = -1.8e-8
parameters dvth_nmvt18 = 0.083
parameters dcj_nmvt18 = 4.67e-5
parameters dcjsw_nmvt18 = 3.91e-12
parameters dcjswg_nmvt18 = 2.125e-11
parameters dcgdo_nmvt18 = 0
parameters dcgso_nmvt18 = 0
parameters dpvth0_nmvt18 = 3e-15
// *1.8V core MEDIUM PMOS
parameters dtox_pmvt18 = 0
parameters dxl_pmvt18 = -1.00e-8
parameters dxw_pmvt18 = 1.8e-8
parameters dvth_pmvt18 = 0.06
parameters dcj_pmvt18 = -3.67e-5
parameters dcjsw_pmvt18 = -3.07e-12
parameters dcjswg_pmvt18 = -3.075e-11
parameters dcgdo_pmvt18 = 0
parameters dcgso_pmvt18 = 0
parameters dpvth0_pmvt18 = 1e-15
// *3.3V IO MEDIUM NMOS
parameters dtox_nmvt33 = 0
parameters dxl_nmvt33 = 1.15e-8
parameters dxw_nmvt33 = -1.8e-8
parameters dvth_nmvt33 = 0.059
parameters dcj_nmvt33 = 4.285e-5
parameters dcjsw_nmvt33 = 5.5e-12
parameters dcjswg_nmvt33 = 1.725e-11
parameters dcgdo_nmvt33 = 0
parameters dcgso_nmvt33 = 0
parameters dpvth0_nmvt33 = 6e-15
include "ms018_v1p7_spe.mdl"
endsection snfp

// ******************************
// * PNP and NPN BJT Corner model
// ******************************

section bjt_tt
// *1.8V CORE PNP
parameters dbf_pnp18a100 = 0.00
parameters dis_pnp18a100 = 0.00
parameters dnf_pnp18a100 = 0.00
parameters dbf_pnp18a25 = 0.00
parameters dis_pnp18a25 = 0.00
parameters dnf_pnp18a25 = 0.00
parameters dbf_pnp18a4 = 0.00
parameters dis_pnp18a4 = 0.00
parameters dnf_pnp18a4 = 0.00
parameters dcje_pnp18a100 = 0.00
parameters dcje_pnp18a25 = 0.00
parameters dcje_pnp18a4 = 0.00
parameters dcjc_pnp18a100 = 0.00
parameters dcjc_pnp18a25 = 0.00
parameters dcjc_pnp18a4 = 0.00
// *1.8V CORE NPN
parameters dbf_npn18a100 = 0.00
parameters dis_npn18a100 = 0.00
parameters dnf_npn18a100 = 0.00
parameters dbf_npn18a25 = 0.00
parameters dis_npn18a25 = 0.00
parameters dnf_npn18a25 = 0.00
parameters dbf_npn18a4 = 0.00
parameters dis_npn18a4 = 0.00
parameters dnf_npn18a4 = 0.00
parameters dcje_npn18a100 = 0.00
parameters dcje_npn18a25 = 0.00
parameters dcje_npn18a4 = 0.00
parameters dcjc_npn18a100 = 0.00
parameters dcjc_npn18a25 = 0.00
parameters dcjc_npn18a4 = 0.00
// *3.3V IO PNP
parameters dbf_pnp33a100 = 0.00
parameters dis_pnp33a100 = 0.00
parameters dnf_pnp33a100 = 0.00
parameters dbf_pnp33a25 = 0.00
parameters dis_pnp33a25 = 0.00
parameters dnf_pnp33a25 = 0.00
parameters dbf_pnp33a4 = 0.00
parameters dis_pnp33a4 = 0.00
parameters dnf_pnp33a4 = 0.00
parameters dcje_pnp33a100 = 0.00
parameters dcje_pnp33a25 = 0.00
parameters dcje_pnp33a4 = 0.00
parameters dcjc_pnp33a100 = 0.00
parameters dcjc_pnp33a25 = 0.00
parameters dcjc_pnp33a4 = 0.00
// *3.3V IO NPN
parameters dbf_npn33a100 = 0.00
parameters dis_npn33a100 = 0.00
parameters dnf_npn33a100 = 0.00
parameters dbf_npn33a25 = 0.00
parameters dis_npn33a25 = 0.00
parameters dnf_npn33a25 = 0.00
parameters dbf_npn33a4 = 0.00
parameters dis_npn33a4 = 0.00
parameters dnf_npn33a4 = 0.00
parameters dcje_npn33a100 = 0.00
parameters dcje_npn33a25 = 0.00
parameters dcje_npn33a4 = 0.00
parameters dcjc_npn33a100 = 0.00
parameters dcjc_npn33a25 = 0.00
parameters dcjc_npn33a4 = 0.00
include "ms018_v1p7_bjt_spe.mdl"
endsection bjt_tt

section bjt_ff
// *1.8V CORE PNP
parameters dbf_pnp18a100 = 4.20e-1
parameters dis_pnp18a100 = -1.756e-18
parameters dnf_pnp18a100 = 0.008
parameters dbf_pnp18a25 = 5.20e-1
parameters dis_pnp18a25 = -7.751e-19
parameters dnf_pnp18a25 = 0.008
parameters dbf_pnp18a4 = 6.90e-1
parameters dis_pnp18a4 = -1.950e-19
parameters dnf_pnp18a4 = 0.008
parameters dcjc_pnp18a100 = -1.86e-15
parameters dcjc_pnp18a25 = -8.75e-16
parameters dcjc_pnp18a4 = -4.64e-16
parameters dcje_pnp18a100 = -5.35e-15
parameters dcje_pnp18a25 = -1.34e-15
parameters dcje_pnp18a4 = -2.14e-16
// *1.8V CORE NPN
parameters dbf_npn18a100 = 3.02e+00
parameters dis_npn18a100 = -9.640e-18
parameters dnf_npn18a100 = 0.0101
parameters dbf_npn18a25 = 3.83e+00
parameters dis_npn18a25 = -4.800e-18
parameters dnf_npn18a25 = 0.0101
parameters dbf_npn18a4 = 5.76e+00
parameters dis_npn18a4 = -1.920e-18
parameters dnf_npn18a4 = 0.0101
parameters dcjc_npn18a100 = -7.2e-15
parameters dcjc_npn18a25 = -3.405e-15
parameters dcjc_npn18a4 = -1.8e-15
parameters dcje_npn18a100 = -4.84e-15
parameters dcje_npn18a25 = -1.21e-15
parameters dcje_npn18a4 = -1.935e-16
// *3.3V IO PNP
parameters dbf_pnp33a100 = 4.20e-1
parameters dis_pnp33a100 = -1.756e-18
parameters dnf_pnp33a100 = 0.008
parameters dbf_pnp33a25 = 5.20e-1
parameters dis_pnp33a25 = -7.751e-19
parameters dnf_pnp33a25 = 0.008
parameters dbf_pnp33a4 = 6.90e-1
parameters dis_pnp33a4 = -1.950e-19
parameters dnf_pnp33a4 = 0.008
parameters dcjc_pnp33a100 = -1.86e-15
parameters dcjc_pnp33a25 = -8.75e-16
parameters dcjc_pnp33a4 = -4.64e-16
parameters dcje_pnp33a100 = -5.35e-15
parameters dcje_pnp33a25 = -1.34e-15
parameters dcje_pnp33a4 = -2.14e-16
// *3.3V IO NPN
parameters dbf_npn33a100 = 3.60e+00
parameters dis_npn33a100 = -9.680e-18
parameters dnf_npn33a100 = 0.0101
parameters dbf_npn33a25 = 4.35e+00
parameters dis_npn33a25 = -5.200e-18
parameters dnf_npn33a25 = 0.0101
parameters dbf_npn33a4 = 6.54e+00
parameters dis_npn33a4 = -1.920e-18
parameters dnf_npn33a4 = 0.0101
parameters dcjc_npn33a100 = -7.2e-15
parameters dcjc_npn33a25 = -3.405e-15
parameters dcjc_npn33a4 = -1.8e-15
parameters dcje_npn33a100 = -4.225e-15
parameters dcje_npn33a25 = -1.055e-15
parameters dcje_npn33a4 = -1.69e-16
include "ms018_v1p7_bjt_spe.mdl"
endsection bjt_ff

section bjt_ss
// *1.8V CORE PNP
parameters dbf_pnp18a100 = -4.20e-1
parameters dis_pnp18a100 = 1.756e-18
parameters dnf_pnp18a100 = -0.008
parameters dbf_pnp18a25 = -5.20e-1
parameters dis_pnp18a25 = 7.751e-19
parameters dnf_pnp18a25 = -0.008
parameters dbf_pnp18a4 = -6.90e-1
parameters dis_pnp18a4 = 1.950e-19
parameters dnf_pnp18a4 = -0.008
parameters dcjc_pnp18a100 = 1.86e-15
parameters dcjc_pnp18a25 = 8.75e-16
parameters dcjc_pnp18a4 = 4.64e-16
parameters dcje_pnp18a100 = 5.35e-15
parameters dcje_pnp18a25 = 1.34e-15
parameters dcje_pnp18a4 = 2.14e-16
// *1.8V CORE NPN
parameters dbf_npn18a100 = -3.02e+00
parameters dis_npn18a100 = 9.640e-18
parameters dnf_npn18a100 = -0.0101
parameters dbf_npn18a25 = -3.83e+00
parameters dis_npn18a25 = 4.800e-18
parameters dnf_npn18a25 = -0.0101
parameters dbf_npn18a4 = -5.76e+00
parameters dis_npn18a4 = 1.920e-18
parameters dnf_npn18a4 = -0.0101
parameters dcjc_npn18a100 = 7.2e-15
parameters dcjc_npn18a25 = 3.405e-15
parameters dcjc_npn18a4 = 1.8e-15
parameters dcje_npn18a100 = 4.84e-15
parameters dcje_npn18a25 = 1.21e-15
parameters dcje_npn18a4 = 1.935e-16
// *3.3V IO PNP
parameters dbf_pnp33a100 = -4.20e-1
parameters dis_pnp33a100 = 1.756e-18
parameters dnf_pnp33a100 = -0.008
parameters dbf_pnp33a25 = -5.20e-1
parameters dis_pnp33a25 = 7.751e-19
parameters dnf_pnp33a25 = -0.008
parameters dbf_pnp33a4 = -6.90e-1
parameters dis_pnp33a4 = 1.950e-19
parameters dnf_pnp33a4 = -0.008
parameters dcjc_pnp33a100 = 1.86e-15
parameters dcjc_pnp33a25 = 8.75e-16
parameters dcjc_pnp33a4 = 4.64e-16
parameters dcje_pnp33a100 = 5.35e-15
parameters dcje_pnp33a25 = 1.34e-15
parameters dcje_pnp33a4 = 2.14e-16
// *3.3V IO NPN
parameters dbf_npn33a100 = -3.60e+00
parameters dis_npn33a100 = 9.680e-18
parameters dnf_npn33a100 = -0.0101
parameters dbf_npn33a25 = -4.35e+00
parameters dis_npn33a25 = 5.200e-18
parameters dnf_npn33a25 = -0.0101
parameters dbf_npn33a4 = -6.54e+00
parameters dis_npn33a4 = 1.920e-18
parameters dnf_npn33a4 = -0.0101
parameters dcjc_npn33a100 = 7.2e-15
parameters dcjc_npn33a25 = 3.405e-15
parameters dcjc_npn33a4 = 1.8e-15
parameters dcje_npn33a100 = 4.225e-15
parameters dcje_npn33a25 = 1.055e-15
parameters dcje_npn33a4 = 1.69e-16
include "ms018_v1p7_bjt_spe.mdl"
endsection bjt_ss

// *******************
// * RES Corner model
// *******************

section res_tt
// *Resistor
parameters drsh_rndif = 0
parameters drsh_rpdif = 0
parameters drsh_rnpo = 0
parameters drsh_rnpo_3t = 0
parameters drsh_rppo = 0
parameters drsh_rppo_3t = 0
parameters drsh_rnwsti = 0
parameters drsh_rnwaa = 0
parameters drsh_rndifsab = 0
parameters drsh_rpdifsab = 0
parameters drsh_rnposab = 0
parameters drsh_rnposab_3t = 0
parameters drsh_rpposab = 0
parameters drsh_rpposab_3t = 0
parameters drsh_rm1 = 0
parameters drsh_rm2 = 0
parameters drsh_rm3 = 0
parameters drsh_rm4 = 0
parameters drsh_rm5 = 0
parameters drsh_rm6 = 0
parameters drsh_rpdifsab_nstd = 0
parameters drsh_rnposab_nstd = 0
parameters drsh_rnposab_nstd_3t = 0
parameters drsh_rndifsab_nstd = 0
parameters drsh_rpposab_nstd = 0
parameters drsh_rpposab_nstd_3t = 0
parameters drsh_rhrpo = 0
parameters drsh_rhrpo_3t = 0
parameters ddw_rndif = 0
parameters ddw_rpdif = 0
parameters ddw_rnpo = 0
parameters ddw_rnpo_3t = 0
parameters ddw_rppo = 0
parameters ddw_rppo_3t = 0
parameters ddw_rnwsti = 0
parameters ddw_rnwaa = 0
parameters ddw_rndifsab = 0
parameters ddw_rpdifsab = 0
parameters ddw_rnposab = 0
parameters ddw_rnposab_3t = 0
parameters ddw_rpposab = 0
parameters ddw_rpposab_3t = 0
parameters ddw_rm1 = 0
parameters ddw_rm2 = 0
parameters ddw_rm3 = 0
parameters ddw_rm4 = 0
parameters ddw_rm5 = 0
parameters ddw_rm6 = 0
parameters ddw_rpdifsab_nstd = 0
parameters ddw_rnposab_nstd = 0
parameters ddw_rnposab_nstd_3t = 0
parameters ddw_rndifsab_nstd = 0
parameters ddw_rpposab_nstd = 0
parameters ddw_rpposab_nstd_3t = 0
parameters ddw_rhrpo = 0
parameters ddw_rhrpo_3t = 0
include "ms018_v1p7_res_spe.mdl"
endsection res_tt

section res_ff
// *Resistor
parameters drsh_rndif = -2.78
parameters drsh_rpdif = -3.63
parameters drsh_rnpo = -2.34
parameters drsh_rnpo_3t = -2.34
parameters drsh_rppo = -2.88
parameters drsh_rppo_3t = -2.88
parameters drsh_rnwsti = -95
parameters drsh_rnwaa = -101
parameters drsh_rndifsab = -20.6
parameters drsh_rpdifsab = -40.1
parameters drsh_rnposab = -38.1
parameters drsh_rnposab_3t = -38.1
parameters drsh_rpposab = -48.7
parameters drsh_rpposab_3t = -48.7
parameters drsh_rm1 = -0.023
parameters drsh_rm2 = -0.023
parameters drsh_rm3 = -0.023
parameters drsh_rm4 = -0.023
parameters drsh_rm5 = -0.023
parameters drsh_rm6 = -0.009
parameters drsh_rpdifsab_nstd = -40.1
parameters drsh_rnposab_nstd = -38.1
parameters drsh_rnposab_nstd_3t = -38.1
parameters drsh_rndifsab_nstd = -20.6
parameters drsh_rpposab_nstd = -48.7
parameters drsh_rpposab_nstd_3t = -48.7
parameters drsh_rhrpo = -200
parameters drsh_rhrpo_3t = -200
parameters ddw_rndif = 0
parameters ddw_rpdif = 0
parameters ddw_rnpo = 0
parameters ddw_rnpo_3t = 0
parameters ddw_rppo = 0
parameters ddw_rppo_3t = 0
parameters ddw_rnwsti = 0
parameters ddw_rnwaa = 0
parameters ddw_rndifsab = 0
parameters ddw_rpdifsab = 0
parameters ddw_rnposab = 0
parameters ddw_rnposab_3t = 0
parameters ddw_rpposab = 0
parameters ddw_rpposab_3t = 0
parameters ddw_rm1 = 0
parameters ddw_rm2 = 0
parameters ddw_rm3 = 0
parameters ddw_rm4 = 0
parameters ddw_rm5 = 0
parameters ddw_rm6 = 0
parameters ddw_rpdifsab_nstd = 0
parameters ddw_rnposab_nstd = 0
parameters ddw_rnposab_nstd_3t = 0
parameters ddw_rndifsab_nstd = 0
parameters ddw_rpposab_nstd = 0
parameters ddw_rpposab_nstd_3t = 0
parameters ddw_rhrpo = 0
parameters ddw_rhrpo_3t = 0
include "ms018_v1p7_res_spe.mdl"
endsection res_ff

section res_ss
// *Resistor
parameters drsh_rndif = 2.22
parameters drsh_rpdif = 2.37
parameters drsh_rnpo = 1.66
parameters drsh_rnpo_3t = 1.66
parameters drsh_rppo = 2.12
parameters drsh_rppo_3t = 2.12
parameters drsh_rnwsti = 169
parameters drsh_rnwaa = 99
parameters drsh_rndifsab = 20.5
parameters drsh_rpdifsab = 40
parameters drsh_rnposab = 38.1
parameters drsh_rnposab_3t = 38.1
parameters drsh_rpposab = 48.6
parameters drsh_rpposab_3t = 48.6
parameters drsh_rm1 = 0.023
parameters drsh_rm2 = 0.023
parameters drsh_rm3 = 0.023
parameters drsh_rm4 = 0.023
parameters drsh_rm5 = 0.023
parameters drsh_rm6 = 0.009
parameters drsh_rpdifsab_nstd = 40
parameters drsh_rnposab_nstd = 38.1
parameters drsh_rnposab_nstd_3t = 38.1
parameters drsh_rndifsab_nstd = 20.5
parameters drsh_rpposab_nstd = 48.6
parameters drsh_rpposab_nstd_3t = 48.6
parameters drsh_rhrpo = 200
parameters drsh_rhrpo_3t = 200
parameters ddw_rndif = 0
parameters ddw_rpdif = 0
parameters ddw_rnpo = 0
parameters ddw_rnpo_3t = 0
parameters ddw_rppo = 0
parameters ddw_rppo_3t = 0
parameters ddw_rnwsti = 0
parameters ddw_rnwaa = 0
parameters ddw_rndifsab = 0
parameters ddw_rpdifsab = 0
parameters ddw_rnposab = 0
parameters ddw_rnposab_3t = 0
parameters ddw_rpposab = 0
parameters ddw_rpposab_3t = 0
parameters ddw_rm1 = 0
parameters ddw_rm2 = 0
parameters ddw_rm3 = 0
parameters ddw_rm4 = 0
parameters ddw_rm5 = 0
parameters ddw_rm6 = 0
parameters ddw_rpdifsab_nstd = 0
parameters ddw_rnposab_nstd = 0
parameters ddw_rnposab_nstd_3t = 0
parameters ddw_rndifsab_nstd = 0
parameters ddw_rpposab_nstd = 0
parameters ddw_rpposab_nstd_3t = 0
parameters ddw_rhrpo = 0
parameters ddw_rhrpo_3t = 0
include "ms018_v1p7_res_spe.mdl"
endsection res_ss

// ******************************
// * MIM capacitance Corner model
// ******************************

section mim_tt
// *MIM
parameters dmim = 0
include "ms018_v1p7_mim_spe.mdl"
endsection mim_tt

section mim_ff
// *MIM
parameters dmim = -2e-4
include "ms018_v1p7_mim_spe.mdl"
endsection mim_ff

section mim_ss
// *MIM
parameters dmim = 2e-4
include "ms018_v1p7_mim_spe.mdl"
endsection mim_ss

endlibrary ms018_v1p7
