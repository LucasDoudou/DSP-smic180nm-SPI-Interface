//
simulator lang=spectre insensitive=yes
library tsmclib
//   **********************************************
//   *             TSMC SPICE MODEL               *
//   **********************************************
//
//     PROCESS :  90nm LOGIC SALICIDE (1P9M, 1.0V/1.8V/3.3V) (CLN90G)
//     MODEL   :  BSIM4/BSIM3 ( V4.5/V3.2.4 )
//     DOC. NO.:  T-N90-CL-SP-005
//     VERSION :  V1.5
//     DATE    :  July 30th, 2006
//     SPECTRE VERSION : 6.0.2.247
//
//
//  ****************************************************************************
//                                                                             *
//        THIS MODEL LIB CONTAINS :                                            *
//                                                                             *
//        1.LIB TT                                                             *
//              SS                                                             *
//              FF                                                             *
//              SF                                                             *
//              FS                                                             *
//    ( 1.0V Standard-Vt devices with different geometric and corner models)   *
//                                                                             *
//        2.LIB TT_hvt                                                         *
//              SS_hvt                                                         *
//              FF_hvt                                                         *
//              SF_hvt                                                         *
//              FS_hvt                                                         *
//    ( 1.0V High-Vt devices with different geometric and corner models)       *
//                                                                             *
//        3.LIB TT_lvt                                                         *
//              SS_lvt                                                         *
//              FF_lvt                                                         *
//              SF_lvt                                                         *
//              FS_lvt                                                         *
//    ( 1.0V Low-Vt devices with different geometric and corner models)        *
//                                                                             *
//        4.LIB TT_18                                                          *
//              SS_18                                                          *
//              FF_18                                                          *
//              SF_18                                                          *
//              FS_18                                                          *
//    ( 1.8V devices with different geometric and corner models)               *
//                                                                             *
//        5.LIB TT_33                                                          *
//              SS_33                                                          *
//              FF_33                                                          *
//              SF_33                                                          *
//              FS_33                                                          *
//    ( 3.3V devices with different geometric and corner models)               *
//                                                                             *
//        6.LIB TT_na                                                          *
//              SS_na                                                          *
//              FF_na                                                          *
//              SF_na                                                          *
//              FS_na                                                          *
//    ( 1.0V Native NMOS devices with different geometric and corner models)   *
//                                                                             *
//        7.LIB TT_na18                                                        *
//              SS_na18                                                        *
//              FF_na18                                                        *
//              SF_na18                                                        *
//              FS_na18                                                        *
//    ( 1.8V Native NMOS devices with different geometric and corner models)   *
//                                                                             *
//        8.LIB TT_na33                                                        *
//              SS_na33                                                        *
//              FF_na33                                                        *
//              SF_na33                                                        *
//              FS_na33                                                        *
//    ( 3.3V Native NMOS devices with different geometric and corner models)   *
//                                                                             *
//        9.LIB TT_BIP                                                         *
//              SS_BIP                                                         *
//              FF_BIP                                                         *
//         ( 1.0V P+/NW/PSUB 10x10, 5x5, and 2x2 vertical PNP bipolar )        *
//                                                                             *
//       10.LIB TT_BIP_NPN                                                     *
//              SS_BIP_NPN                                                     *
//              FF_BIP_NPN                                                     *
//         ( 1.0V N+/PW/DNW 10x10, 5x5, and 2x2 vertical NPN bipolar )         *
//                                                                             *
//       11.LIB TT_DIO                                                         *
//              SS_DIO                                                         *
//              FF_DIO                                                         *
//         ( 1.0V Standard-Vt P+/NW, N+/PW, and NW/PSUB diode )                *
//                                                                             *
//       12.LIB TT_DIO_hvt                                                     *
//              SS_DIO_hvt                                                     *
//              FF_DIO_hvt                                                     *
//         ( 1.0V High-Vt P+/NW, and N+/PW diode )                             *
//                                                                             *
//       13.LIB TT_DIO_lvt                                                     *
//              SS_DIO_lvt                                                     *
//              FF_DIO_lvt                                                     *
//         ( 1.0V Low-Vt P+/NW, and N+/PW diode )                              *
//                                                                             *
//       14.LIB TT_DIO_18                                                      *
//              SS_DIO_18                                                      *
//              FF_DIO_18                                                      *
//         ( 1.8V P+/NW, and N+/PW diode )                                     *
//                                                                             *
//       15.LIB TT_DIO_33                                                      *
//              SS_DIO_33                                                      *
//              FF_DIO_33                                                      *
//         ( 3.3V P+/NW, and N+/PW diode )                                     *
//                                                                             *
//       16.LIB TT_DIO_na                                                      *
//              SS_DIO_na                                                      *
//              FF_DIO_na                                                      *
//         ( 1.0V Native NMOS N+/PSUB diode )                                  *
//                                                                             *
//       17.LIB TT_DIO_na18                                                    *
//              SS_DIO_na18                                                    *
//              FF_DIO_na18                                                    *
//         ( 1.8V Native NMOS N+/PSUB diode )                                  *
//                                                                             *
//       18.LIB TT_DIO_na33                                                    *
//              SS_DIO_na33                                                    *
//              FF_DIO_na33                                                    *
//         ( 3.3V Native NMOS N+/PSUB diode )                                  *
//                                                                             *
//       19.LIB TT_DIO_dnw                                                     *
//              SS_DIO_dnw                                                     *
//              FF_DIO_dnw                                                     *
//         ( PW/DNW and DNW/PSUB diode )                                       *
//                                                                             *
//       20.LIB TT_DIO_esd                                                     *
//              SS_DIO_esd                                                     *
//              FF_DIO_esd                                                     *
//         ( ESD diode )                                                       *
//                                                                             *
//       21.LIB MOS_CAP                                                        *
//         ( 1.0V Standard-Vt NMOS in N-Well varactor )                        *
//                                                                             *
//       22.LIB MOS_CAP_33                                                     *
//         ( 3.3V IO NMOS in N-Well varactor )                                 *
//                                                                             *
//       23.LIB RES                                                            *
//         ( resistance )                                                      *
//                                                                             *
//  ****************************************************************************
//  ***************************************************************************************
//
//           *
//  1) To use these models directly by programming in this style:
//           *
//
//           *
//      .lib 'lib_path/lib_name' model_name
//           *
//
//           *
//     EX: .lib '/home/user/tsmc/LOGIC/cln90g_lk.scs' TT
//           *
//         for typical 1.0V Standard Vt N,PMOS
//           *
//     note:
//           *
//       corner_name
//           *
//        TT : typical model for 1.0V standard-Vt devices
//           *
//        SS : Slow NMOS Slow PMOS model for 1.0V standard-Vt devices
//           *
//        FF : Fast NMOS Fast PMOS model for 1.0V standard-Vt devices
//           *
//        SF : Slow NMOS Fast PMOS model for 1.0V standard-Vt devices
//           *
//        FS : Fast NMOS Slow PMOS model for 1.0V standard-Vt devices
//           *
//       corner_name
//           *
//        TT_hvt : typical model for 1.0V high-Vt devices
//           *
//        SS_hvt : Slow NMOS Slow PMOS model for 1.0V high-Vt devices
//           *
//        FF_hvt : Fast NMOS Fast PMOS model for 1.0V high-Vt devices
//           *
//        SF_hvt : Slow NMOS Fast PMOS model for 1.0V high-Vt devices
//           *
//        FS_hvt : Fast NMOS Slow PMOS model for 1.0V high-Vt devices
//           *
//       corner_name
//           *
//        TT_lvt : typical model for 1.0V low-Vt devices
//           *
//        SS_lvt : Slow NMOS Slow PMOS model for 1.0V low-Vt devices
//           *
//        FF_lvt : Fast NMOS Fast PMOS model for 1.0V low-Vt devices
//           *
//        SF_lvt : Slow NMOS Fast PMOS model for 1.0V low-Vt devices
//           *
//        FS_lvt : Fast NMOS Slow PMOS model for 1.0V low-Vt devices
//           *
//       corner_name
//           *
//        TT_18 : typical model for 1.8V devices
//           *
//        SS_18 : Slow NMOS Slow PMOS model for 1.8V devices
//           *
//        FF_18 : Fast NMOS Fast PMOS model for 1.8V devices
//           *
//        SF_18 : Slow NMOS Fast PMOS model for 1.8V devices
//           *
//        FS_18 : Fast NMOS Slow PMOS model for 1.8V devices
//           *
//       corner_name
//           *
//        TT_33 : typical model for 3.3V devices
//           *
//        SS_33 : Slow NMOS Slow PMOS model for 3.3V devices
//           *
//        FF_33 : Fast NMOS Fast PMOS model for 3.3V devices
//           *
//        SF_33 : Slow NMOS Fast PMOS model for 3.3V devices
//           *
//        FS_33 : Fast NMOS Slow PMOS model for 3.3V devices
//           *
//       corner_name
//           *
//        TT_na : typical model for 1.0V Native NMOS devices
//           *
//        SS_na : Slow NMOS Slow PMOS model for 1.0V Native NMOS devices
//           *
//        FF_na : Fast NMOS Fast PMOS model for 1.0V Native NMOS devices
//           *
//        SF_na : Slow NMOS Fast PMOS model for 1.0V Native NMOS devices
//           *
//        FS_na : Fast NMOS Slow PMOS model for 1.0V Native NMOS devices
//           *
//       corner_name
//           *
//        TT_na18 : typical model for 1.8V Native NMOS devices
//           *
//        SS_na18 : Slow NMOS Slow PMOS model for 1.8V Native NMOS devices
//           *
//        FF_na18 : Fast NMOS Fast PMOS model for 1.8V Native NMOS devices
//           *
//        SF_na18 : Slow NMOS Fast PMOS model for 1.8V Native NMOS devices
//           *
//        FS_na18 : Fast NMOS Slow PMOS model for 1.8V Native NMOS devices
//           *
//       corner_name
//           *
//        TT_na33 : typical model for 3.3V Native NMOS devices
//           *
//        SS_na33 : Slow NMOS Slow PMOS model for 3.3V Native NMOS devices
//           *
//        FF_na33 : Fast NMOS Fast PMOS model for 3.3V Native NMOS devices
//           *
//        SF_na33 : Slow NMOS Fast PMOS model for 3.3V Native NMOS devices
//           *
//        FS_na33 : Fast NMOS Slow PMOS model for 3.3V Native NMOS devices
//           *
//
//           *
//  2) HDIF depends on your layout poly spacer to contact center distance.
//           *
//     The value listed here is TSMC minimum-rule value. You can change it
//           *
//     according to your layout.
//           *
//
//           *
//  ***************************************************************************************
//
//
//  **********************    FLAG FOR CONTACT-POLY CAPACITANCE    ******************************
//
//  NOTE:
//   1. The default value of ccoflag is 0, which means that the model will exclude
// contact-to-poly
//      capacitance.  LPE tools should extract this capacitance during post-layout
// simulation.
//   2. Users could set ccoflag to 1 for pre-layout simulation where contact-to-poly
// capacitance
//      with maximum contact density is required.
//   3. Recommend customer to follow the WPE design rule, If customer need to run
// the WPE simulation,
//      users could set wpeflag to 1 for WPE simulation.
//  *********************************************************************************************
//
//
//
//

section cco_pre_simu
parameters ccoflag=0
endsection cco_pre_simu

section cco_pre_simu_hvt
parameters ccoflag_hvt=0
endsection cco_pre_simu_hvt

section cco_pre_simu_lvt
parameters ccoflag_lvt=0
endsection cco_pre_simu_lvt

section cco_pre_simu_18
parameters ccoflag_18=0
endsection cco_pre_simu_18

section cco_pre_simu_33
parameters ccoflag_33=0
endsection cco_pre_simu_33

section cco_pre_simu_na
parameters ccoflag_na=0
endsection cco_pre_simu_na

section cco_pre_simu_na18
parameters ccoflag_na18=0
endsection cco_pre_simu_na18

section cco_pre_simu_na33
parameters ccoflag_na33=0
endsection cco_pre_simu_na33

section wpe_pre_simu
parameters wpeflag=0
endsection wpe_pre_simu

section wpe_pre_simu_hvt
parameters wpeflag_hvt=0
endsection wpe_pre_simu_hvt

section wpe_pre_simu_lvt
parameters wpeflag_lvt=0
endsection wpe_pre_simu_lvt

section wpe_pre_simu_18
parameters wpeflag_18=0
endsection wpe_pre_simu_18

section wpe_pre_simu_33
parameters wpeflag_33=0
endsection wpe_pre_simu_33

//  *************************************************************
//                                                              *
//                1.0V STANDARD VT DEVICE LIB                   *
//                                                              *
//  *************************************************************
//
//  ****************************    LIBRARY OF TYPICAL CASE    ******************************

section tt
include "cln90g_lk.scs" section=cco_pre_simu
include "cln90g_lk.scs" section=wpe_pre_simu
parameters toxn=2.33e-09
parameters cjn=9.8000e-04
parameters cjswn=4.0000e-11
parameters cjswgn=3.7000e-10
parameters cgon=1.209e-10
parameters cgln=6.5143e-11
parameters dvthn=0
parameters dpvthn=0
parameters dxln=0
parameters dxwn=-0.5e-8
parameters dlvthn=0
parameters dwvthn=0
parameters dk2n=0
parameters dpvoffn=0
parameters dpvsatn=0
parameters dpeta0n=0
parameters dxlp=0
parameters dxwp=-0.5e-8
parameters toxp=2.50e-09
parameters cjp=1.1400e-03
parameters cjswp=6.0000e-11
parameters cjswgp=3.6000e-10
parameters cgop=2.568e-11
parameters cglp=1.8957e-10
parameters dvthp=0
parameters dlvthp=0
parameters dwvthp=0
parameters dpvthp=0
parameters dlcdscdp=0
parameters drdswp=0
parameters ntoxn=1
parameters ntoxp=1
parameters dlvoffp=0
parameters dk2p=0
parameters cfn=1.38e-10 + 3.1e-11 * ccoflag
parameters cfp=1.38e-10 + 3.1e-11 * ccoflag
include "cln90g_lk.scs" section=mos
endsection tt

//  ****************************  LIBRARY OF SNSP CORNER CASE  ******************************

section ss
include "cln90g_lk.scs" section=cco_pre_simu
include "cln90g_lk.scs" section=wpe_pre_simu
parameters toxn=2.39e-09
parameters cjn=1.0486e-03
parameters cjswn=4.2800e-11
parameters cjswgn=3.9590e-10
parameters cgon=1.1244e-10
parameters cgln=6.058e-11
parameters dvthn=3.500e-02
parameters dpvthn=1.4e-016
parameters dxln=5.000e-09
parameters dxwn= - 8.000e-09 - 0.5e-8
parameters dlvthn=1.3e-09
parameters dwvthn=3.0e-09
parameters dk2n=8e-3
parameters dpvoffn=0
parameters dpvsatn=0
parameters dpeta0n=0
parameters dxlp=5.000e-09
parameters dxwp= - 8.000e-09 - 0.5e-8
parameters toxp=2.560e-09
parameters cjp=1.2198e-03
parameters cjswp=6.4200e-11
parameters cjswgp=3.8520e-10
parameters cgop=2.3882e-11
parameters cglp=1.7630e-10
parameters dvthp=-3.000e-02
parameters dlvthp=-1.3e-09
parameters dwvthp=-1.0e-9
parameters dpvthp=-1.4e-16
parameters dlcdscdp=0
parameters drdswp=-50
parameters ntoxn=-0.8
parameters ntoxp=-3.0
parameters dlvoffp=0
parameters dk2p=4.5e-3
parameters cfn=1.283e-10 + 3.1e-11 * ccoflag
parameters cfp=1.283e-10 + 3.1e-11 * ccoflag
include "cln90g_lk.scs" section=mos
endsection ss

//  ****************************  LIBRARY OF FNFP CORNER CASE  ******************************

section ff
include "cln90g_lk.scs" section=cco_pre_simu
include "cln90g_lk.scs" section=wpe_pre_simu
parameters toxn=2.27e-09
parameters cjn=9.1140e-04
parameters cjswn=3.7200e-11
parameters cjswgn=3.4410e-10
parameters cgon=1.2936e-10
parameters cgln=6.970e-11
parameters dvthn=-3.500e-02
parameters dpvthn=-1.3e-016
parameters dxln=-5.000e-09
parameters dxwn=8.000e-09 - 0.5e-8
parameters dlvthn=-1.7e-09
parameters dwvthn=-3.0e-09
parameters dk2n=-8e-3
parameters dpvoffn=-4e-17
parameters dpvsatn=-5e-11
parameters dpeta0n=3.0e-16
parameters dxlp=-5.000e-09
parameters dxwp=8.000e-09 - 0.5e-8
parameters toxp=2.44e-09
parameters cjp=1.0602e-03
parameters cjswp=5.5800e-11
parameters cjswgp=3.3480e-10
parameters cgop=2.7478e-11
parameters cglp=2.0284e-10
parameters dvthp=3.000e-02
parameters dlvthp=16.4e-10
parameters dwvthp=1.0e-9
parameters dpvthp=0.7e-16
parameters dlcdscdp=0
parameters drdswp=50
parameters ntoxn=2.7
parameters ntoxp=5.0
parameters dlvoffp=-5.5e-10
parameters dk2p=-4.5e-3
parameters cfn=1.477e-10 + 3.1e-11 * ccoflag
parameters cfp=1.477e-10 + 3.1e-11 * ccoflag
include "cln90g_lk.scs" section=mos
endsection ff

//  ****************************  LIBRARY OF SNFP CORNER CASE  ******************************

section sf
include "cln90g_lk.scs" section=cco_pre_simu
include "cln90g_lk.scs" section=wpe_pre_simu
parameters a4np=0
parameters a1n=0.8
parameters a1p=-0.8
parameters a2n=0
parameters a3n=-1
parameters a2p=0
parameters a3p=1
parameters toxn=2.33e-09 + 6.0000e-11 * a4np
parameters cjn=9.8000e-04 * (1 + 0.070 * a1n)
parameters cjswn=4.0000e-11 * (1 + 0.070 * a1n)
parameters cjswgn=3.7000e-10 * (1 + 0.070 * a1n)
parameters cgon=1.209e-10 * (1 - 0.070 * a4np)
parameters cgln=6.5143e-11 * (1 - 0.070 * a4np)
parameters dvthn=0.035 * a1n
parameters dpvthn=1.3e-16 * a1n
parameters dxln=5e-09 * a2n
parameters dxwn=0.8e-08 * a3n - 0.5e-08
parameters dlvthn=1.7e-09 * a1n
parameters dwvthn=3e-09 * a1n
parameters dk2n=0.008 * a1n
parameters dpvoffn=4e-17 * a1n
parameters dpvsatn=5e-11 * a1n
parameters dpeta0n= - 3e-16 * a1n
parameters dxlp=5e-09 * a2p
parameters dxwp=0.8e-08 * a3p - 0.5e-08
parameters toxp=2.50e-09 + 6.0000e-11 * a4np
parameters cjp=1.1400e-03 * (1 + 0.070 * a1p)
parameters cjswp=6.0000e-11 * (1 + 0.070 * a1p)
parameters cjswgp=3.6000e-10 * (1 + 0.070 * a1p)
parameters cgop=2.568e-11 * (1 - 0.070 * a4np)
parameters cglp=1.8957e-10 * (1 - 0.070 * a4np)
parameters dvthp= - 0.03 * a1p
parameters dlvthp= - 1.64e-09 * a1p
parameters dwvthp= - 1e-09 * a1p
parameters dpvthp= - 7e-17 * a1p
parameters dlcdscdp=0
parameters drdswp= - 50 * a1p
parameters ntoxn=1 - 1.7 * a4np
parameters ntoxp=1 - 4 * a4np
parameters dlvoffp=5.5e-10 * a1p
parameters dk2p=0.0045 * a1p
parameters cfn=1.38e-10 * (1 - 0.070 * a4np) + 3.1e-11 * ccoflag
parameters cfp=1.38e-10 * (1 - 0.070 * a4np) + 3.1e-11 * ccoflag
include "cln90g_lk.scs" section=mos
endsection sf

//  ****************************  LIBRARY OF FNSP CORNER CASE  ******************************

section fs
include "cln90g_lk.scs" section=cco_pre_simu
include "cln90g_lk.scs" section=wpe_pre_simu
parameters a4np=0
parameters a1n=-0.8
parameters a1p=0.8
parameters a2n=0
parameters a3n=1
parameters a2p=0
parameters a3p=-1
parameters toxn=2.33e-09 + 6.0000e-11 * a4np
parameters cjn=9.8000e-04 * (1 + 0.070 * a1n)
parameters cjswn=4.0000e-11 * (1 + 0.070 * a1n)
parameters cjswgn=3.7000e-10 * (1 + 0.070 * a1n)
parameters cgon=1.209e-10 * (1 - 0.070 * a4np)
parameters cgln=6.5143e-11 * (1 - 0.070 * a4np)
parameters dvthn=0.035 * a1n
parameters dpvthn=1.3e-16 * a1n
parameters dxln=5e-09 * a2n
parameters dxwn=0.8e-08 * a3n - 0.5e-08
parameters dlvthn=1.7e-09 * a1n
parameters dwvthn=3e-09 * a1n
parameters dk2n=0.008 * a1n
parameters dpvoffn=4e-17 * a1n
parameters dpvsatn=5e-11 * a1n
parameters dpeta0n= - 3e-16 * a1n
parameters dxlp=5e-09 * a2p
parameters dxwp=0.8e-08 * a3p - 0.5e-08
parameters toxp=2.50e-09 + 6.0000e-11 * a4np
parameters cjp=1.1400e-03 * (1 + 0.070 * a1p)
parameters cjswp=6.0000e-11 * (1 + 0.070 * a1p)
parameters cjswgp=3.6000e-10 * (1 + 0.070 * a1p)
parameters cgop=2.568e-11 * (1 - 0.070 * a4np)
parameters cglp=1.8957e-10 * (1 - 0.070 * a4np)
parameters dvthp= - 0.03 * a1p
parameters dlvthp= - 1.64e-09 * a1p
parameters dwvthp= - 1e-09 * a1p
parameters dpvthp= - 7e-17 * a1p
parameters dlcdscdp=0
parameters drdswp= - 50 * a1p
parameters ntoxn=1 - 1.7 * a4np
parameters ntoxp=1 - 4 * a4np
parameters dlvoffp=5.5e-10 * a1p
parameters dk2p=0.0045 * a1p
parameters cfn=1.38e-10 * (1 - 0.070 * a4np) + 3.1e-11 * ccoflag
parameters cfp=1.38e-10 * (1 - 0.070 * a4np) + 3.1e-11 * ccoflag
include "cln90g_lk.scs" section=mos
endsection fs

//  *************************************************************
//                                                              *
//                  1.0V HIGH VT DEVICE LIB                     *
//                                                              *
//  *************************************************************

//  ****************************    LIBRARY OF TYPICAL CASE    ******************************

section tt_hvt
include "cln90g_lk.scs" section=cco_pre_simu_hvt
include "cln90g_lk.scs" section=wpe_pre_simu_hvt
parameters toxn_hvt=2.33e-09
parameters dxln_hvt=0
parameters dxwn_hvt=-0.5e-8
parameters dvthn_hvt=0
parameters dlvthn_hvt=0
parameters dwvthn_hvt=0
parameters dpvthn_hvt=0
parameters dlcdscdn_hvt=0
parameters deta0n_hvt=0
parameters cjn_hvt=1.09e-03
parameters cjswn_hvt=2.0e-11
parameters cjswgn_hvt=4.2e-10
parameters cgon_hvt=1.122e-10
parameters ntoxn_hvt=1
parameters dlcitn_hvt=0
parameters dlvoffn_hvt=0
parameters dpvsatn_hvt=0
parameters cgln_hvt=5.953e-11
parameters dk2n_hvt=0
parameters dpvoffn_hvt=0
parameters toxp_hvt=2.50e-09
parameters dxlp_hvt=0
parameters dxwp_hvt=-0.5e-8
parameters dvthp_hvt=0
parameters dlvthp_hvt=0
parameters dwvthp_hvt=0
parameters dpvthp_hvt=0
parameters cjp_hvt=1.17e-03
parameters cjswp_hvt=6.00e-11
parameters cjswgp_hvt=4.10e-10
parameters cgop_hvt=1.96e-11
parameters cglp_hvt=1.77e-10
parameters dk2p_hvt=0
parameters dpvoffp_hvt=0
parameters drdswp_hvt=0
parameters ntoxp_hvt=1
parameters dpvsatp_hvt=0
parameters cfn_hvt=1.38e-10 + 3.1e-11 * ccoflag_hvt
parameters cfp_hvt=1.38e-10 + 3.1e-11 * ccoflag_hvt
include "cln90g_lk.scs" section=mos_hvt
endsection tt_hvt

//  ****************************  LIBRARY OF SNSP CORNER CASE  ******************************

section ss_hvt
include "cln90g_lk.scs" section=cco_pre_simu_hvt
include "cln90g_lk.scs" section=wpe_pre_simu_hvt
parameters toxn_hvt=2.39e-09
parameters dxln_hvt=5.0e-09
parameters dxwn_hvt= - 8.0e-09 - 0.5e-8
parameters dvthn_hvt=0.03
parameters dlvthn_hvt=5.0e-10
parameters dwvthn_hvt=3.5e-09
parameters dpvthn_hvt=1.2e-16
parameters dlcdscdn_hvt=0
parameters deta0n_hvt=0
parameters cjn_hvt=1.166e-03
parameters cjswn_hvt=2.14e-11
parameters cjswgn_hvt=4.494e-10
parameters cgon_hvt=1.0435e-10
parameters ntoxn_hvt=-0.8
parameters dlcitn_hvt=0
parameters dlvoffn_hvt=0
parameters dpvsatn_hvt=0
parameters cgln_hvt=5.536e-11
parameters dk2n_hvt=1e-2
parameters dpvoffn_hvt=0
parameters toxp_hvt=2.56e-09
parameters dxlp_hvt=5.0e-09
parameters dxwp_hvt= - 8.0e-09 - 0.5e-8
parameters dvthp_hvt=-0.03
parameters dlvthp_hvt=-8.5e-10
parameters dwvthp_hvt=-5.0e-10
parameters dpvthp_hvt=-1.0e-16
parameters cjp_hvt=1.252e-03
parameters cjswp_hvt=6.42e-11
parameters cjswgp_hvt=4.387e-10
parameters cgop_hvt=1.8228e-11
parameters cglp_hvt=1.646e-10
parameters dk2p_hvt=4.5e-3
parameters dpvoffp_hvt=0
parameters drdswp_hvt=-110
parameters ntoxp_hvt=-3.0
parameters dpvsatp_hvt=0
parameters cfn_hvt=1.283e-10 + 3.1e-11 * ccoflag_hvt
parameters cfp_hvt=1.283e-10 + 3.1e-11 * ccoflag_hvt
include "cln90g_lk.scs" section=mos_hvt
endsection ss_hvt

//  ****************************  LIBRARY OF FNFP CORNER CASE  ******************************

section ff_hvt
include "cln90g_lk.scs" section=cco_pre_simu_hvt
include "cln90g_lk.scs" section=wpe_pre_simu_hvt
parameters toxn_hvt=2.27e-09
parameters dxln_hvt=-5.0e-09
parameters dxwn_hvt=8.0e-09 - 0.5e-8
parameters dvthn_hvt=-0.03
parameters dlvthn_hvt=-1.3e-09
parameters dwvthn_hvt=-3.5e-09
parameters dpvthn_hvt=-1.1e-16
parameters dlcdscdn_hvt=0
parameters deta0n_hvt=0.01
parameters cjn_hvt=1.014e-03
parameters cjswn_hvt=1.86e-11
parameters cjswgn_hvt=3.906e-10
parameters cgon_hvt=1.2005e-10
parameters ntoxn_hvt=2.7
parameters dlcitn_hvt=6.0e-11
parameters dlvoffn_hvt=-4.0e-10
parameters dpvsatn_hvt=-1.0e-11
parameters cgln_hvt=6.37e-11
parameters dk2n_hvt=-1e-2
parameters dpvoffn_hvt=-1.5e-17
parameters toxp_hvt=2.44e-09
parameters dxlp_hvt=-5.0e-09
parameters dxwp_hvt=8.0e-09 - 0.5e-8
parameters dvthp_hvt=0.03
parameters dlvthp_hvt=1.2e-09
parameters dwvthp_hvt=5.0e-10
parameters dpvthp_hvt=3.0e-17
parameters cjp_hvt=1.088e-03
parameters cjswp_hvt=5.58e-11
parameters cjswgp_hvt=3.813e-10
parameters cgop_hvt=2.0972e-11
parameters cglp_hvt=1.894e-10
parameters dk2p_hvt=-4.50e-3
parameters dpvoffp_hvt=0
parameters drdswp_hvt=90
parameters ntoxp_hvt=5.0
parameters dpvsatp_hvt=-8e-11
parameters cfn_hvt=1.477e-10 + 3.1e-11 * ccoflag_hvt
parameters cfp_hvt=1.477e-10 + 3.1e-11 * ccoflag_hvt
include "cln90g_lk.scs" section=mos_hvt
endsection ff_hvt

//  ****************************  LIBRARY OF SNFP CORNER CASE  ******************************

section sf_hvt
include "cln90g_lk.scs" section=cco_pre_simu_hvt
include "cln90g_lk.scs" section=wpe_pre_simu_hvt
parameters a4np_hvt=0
parameters a1n_hvt=0.8
parameters a1p_hvt=-0.8
parameters a2n_hvt=0
parameters a2p_hvt=0
parameters a3n_hvt=-1
parameters a3p_hvt=1
parameters toxn_hvt=2.33e-09 + 6.0000e-11 * a4np_hvt
parameters dxln_hvt=5e-09 * a2n_hvt
parameters dxwn_hvt=0.8e-08 * a3n_hvt - 0.5e-8
parameters dvthn_hvt=0.03 * a1n_hvt
parameters dlvthn_hvt=1.3e-09 * a1n_hvt
parameters dwvthn_hvt=3.5e-09 * a1n_hvt
parameters dpvthn_hvt=1.1e-16 * a1n_hvt
parameters dlcdscdn_hvt=0 * a1n_hvt
parameters deta0n_hvt= - 0.01 * a1n_hvt
parameters cjn_hvt=1.09e-03 * (1 + 0.070 * a1n_hvt)
parameters cjswn_hvt=2.0e-11 * (1 + 0.070 * a1n_hvt)
parameters cjswgn_hvt=4.2e-10 * (1 + 0.070 * a1n_hvt)
parameters cgon_hvt=1.122e-10 * (1 - 0.070 * a4np_hvt)
parameters ntoxn_hvt=1 +  - 1.7000e+00 * a4np_hvt
parameters cgln_hvt=5.953e-11 * (1 - 0.070 * a4np_hvt)
parameters dk2n_hvt=0.01 * a1n_hvt
parameters dpvoffn_hvt=1.5e-17 * a1n_hvt
parameters dlcitn_hvt= - 6e-11 * a1n_hvt
parameters dlvoffn_hvt=4e-10 * a1n_hvt
parameters dpvsatn_hvt=1.0e-11 * a1n_hvt
parameters toxp_hvt=2.50e-09 + 6.0000e-11 * a4np_hvt
parameters dxlp_hvt=5e-09 * a2p_hvt
parameters dxwp_hvt=0.8e-08 * a3p_hvt - 0.5e-8
parameters dvthp_hvt= - 0.03 * a1p_hvt
parameters dlvthp_hvt= - 1.2e-09 * a1p_hvt
parameters dwvthp_hvt= - 5e-10 * a1p_hvt
parameters dpvthp_hvt= - 3e-17 * a1p_hvt
parameters cjp_hvt=1.17e-03 * (1 + 0.070 * a1p_hvt)
parameters cjswp_hvt=6.00e-11 * (1 + 0.070 * a1p_hvt)
parameters cjswgp_hvt=4.10e-10 * (1 + 0.070 * a1p_hvt)
parameters cgop_hvt=1.96e-11 * (1 - 0.070 * a4np_hvt)
parameters cglp_hvt=1.77e-10 * (1 - 0.070 * a4np_hvt)
parameters dk2p_hvt=0.0045 * a1p_hvt
parameters dpvoffp_hvt=0
parameters drdswp_hvt= - 90 * a1p_hvt
parameters ntoxp_hvt=1 +  - 4.0000e+00 * a4np_hvt
parameters dpvsatp_hvt=8e-11 * a1p_hvt
parameters cfn_hvt=1.38e-10 * (1 - 0.070 * a4np_hvt) + 3.1e-11 * ccoflag_hvt
parameters cfp_hvt=1.38e-10 * (1 - 0.070 * a4np_hvt) + 3.1e-11 * ccoflag_hvt

include "cln90g_lk.scs" section=mos_hvt
endsection sf_hvt

//  ****************************  LIBRARY OF FNSP CORNER CASE  ******************************

section fs_hvt
include "cln90g_lk.scs" section=cco_pre_simu_hvt
include "cln90g_lk.scs" section=wpe_pre_simu_hvt
parameters a4np_hvt=0
parameters a1n_hvt=-0.8
parameters a1p_hvt=0.8
parameters a2n_hvt=0
parameters a2p_hvt=0
parameters a3n_hvt=1
parameters a3p_hvt=-1
parameters toxn_hvt=2.33e-09 + 6.0000e-11 * a4np_hvt
parameters dxln_hvt=5e-09 * a2n_hvt
parameters dxwn_hvt=0.8e-08 * a3n_hvt - 0.5e-8
parameters dvthn_hvt=0.03 * a1n_hvt
parameters dlvthn_hvt=1.3e-09 * a1n_hvt
parameters dwvthn_hvt=3.5e-09 * a1n_hvt
parameters dpvthn_hvt=1.1e-16 * a1n_hvt
parameters dlcdscdn_hvt=0 * a1n_hvt
parameters deta0n_hvt= - 0.01 * a1n_hvt
parameters cjn_hvt=1.09e-03 * (1 + 0.070 * a1n_hvt)
parameters cjswn_hvt=2.0e-11 * (1 + 0.070 * a1n_hvt)
parameters cjswgn_hvt=4.2e-10 * (1 + 0.070 * a1n_hvt)
parameters cgon_hvt=1.122e-10 * (1 - 0.070 * a4np_hvt)
parameters ntoxn_hvt=1 +  - 1.7000e+00 * a4np_hvt
parameters cgln_hvt=5.953e-11 * (1 - 0.070 * a4np_hvt)
parameters dk2n_hvt=0.01 * a1n_hvt
parameters dpvoffn_hvt=1.5e-17 * a1n_hvt
parameters dlcitn_hvt= - 6e-11 * a1n_hvt
parameters dlvoffn_hvt=4e-10 * a1n_hvt
parameters dpvsatn_hvt=1.0e-11 * a1n_hvt
parameters toxp_hvt=2.50e-09 + 6.0000e-11 * a4np_hvt
parameters dxlp_hvt=5e-09 * a2p_hvt
parameters dxwp_hvt=0.8e-08 * a3p_hvt - 0.5e-8
parameters dvthp_hvt= - 0.03 * a1p_hvt
parameters dlvthp_hvt= - 1.2e-09 * a1p_hvt
parameters dwvthp_hvt= - 5e-10 * a1p_hvt
parameters dpvthp_hvt= - 3e-17 * a1p_hvt
parameters cjp_hvt=1.17e-03 * (1 + 0.070 * a1p_hvt)
parameters cjswp_hvt=6.00e-11 * (1 + 0.070 * a1p_hvt)
parameters cjswgp_hvt=4.10e-10 * (1 + 0.070 * a1p_hvt)
parameters cgop_hvt=1.96e-11 * (1 - 0.070 * a4np_hvt)
parameters cglp_hvt=1.77e-10 * (1 - 0.070 * a4np_hvt)
parameters dk2p_hvt=0.0045 * a1p_hvt
parameters dpvoffp_hvt=0
parameters drdswp_hvt= - 90 * a1p_hvt
parameters ntoxp_hvt=1 +  - 4.0000e+00 * a4np_hvt
parameters dpvsatp_hvt=8e-11 * a1p_hvt
parameters cfn_hvt=1.38e-10 * (1 - 0.070 * a4np_hvt) + 3.1e-11 * ccoflag_hvt
parameters cfp_hvt=1.38e-10 * (1 - 0.070 * a4np_hvt) + 3.1e-11 * ccoflag_hvt

include "cln90g_lk.scs" section=mos_hvt
endsection fs_hvt

//  *************************************************************
//                                                              *
//                   1.0V LOW VT DEVICE LIB                     *
//                                                              *
//  *************************************************************

//  ****************************    LIBRARY OF TYPICAL CASE    ******************************

section tt_lvt
include "cln90g_lk.scs" section=cco_pre_simu_lvt
include "cln90g_lk.scs" section=wpe_pre_simu_lvt
parameters toxn_lvt=2.33e-09
parameters cjn_lvt=9.87e-04
parameters cjswn_lvt=3.5e-11
parameters cjswgn_lvt=3.38e-10
parameters cgon_lvt=1.16e-10
parameters cgln_lvt=7.52e-11
parameters dvthn_lvt=0
parameters dpvthn_lvt=0
parameters dxln_lvt=0
parameters dxwn_lvt=-0.5e-8
parameters dlvthn_lvt=0
parameters dwvthn_lvt=0
parameters drdswn_lvt=0
parameters dlcdscdn_lvt=0
parameters deta0n_lvt=0
parameters ntoxn_lvt=1
parameters dk2n_lvt=0
parameters dlvoffn_lvt=0
parameters dlcitn_lvt=0
parameters dpvoffn_lvt=0
parameters dpeta0n_lvt=0
parameters dpvsatn_lvt=0
parameters dppclmn_lvt=0
parameters toxp_lvt=2.50e-09
parameters ddsubn_lvt=0
parameters dlvsatn_lvt=0
parameters dxlp_lvt=0
parameters dxwp_lvt=-0.5e-8
parameters dvthp_lvt=0
parameters dlvthp_lvt=0
parameters dwvthp_lvt=0
parameters dpvthp_lvt=0
parameters cjp_lvt=1.13e-03
parameters cjswp_lvt=5.8e-11
parameters cjswgp_lvt=3.05e-10
parameters cgop_lvt=4.16e-11
parameters cglp_lvt=1.72e-10
parameters dlvoffp_lvt=0
parameters dpvoffp_lvt=0
parameters dk2p_lvt=0
parameters ntoxp_lvt=1
parameters deta0p_lvt=0
parameters dpeta0p_lvt=0
parameters dpvsatp_lvt=0
parameters dlvsatp_lvt=0
parameters cfn_lvt=1.38e-10 + 3.1e-11 * ccoflag_lvt
parameters cfp_lvt=1.38e-10 + 3.1e-11 * ccoflag_lvt
include "cln90g_lk.scs" section=mos_lvt
endsection tt_lvt

//  ****************************  LIBRARY OF SNSP CORNER CASE  ******************************

section ss_lvt
include "cln90g_lk.scs" section=cco_pre_simu_lvt
include "cln90g_lk.scs" section=wpe_pre_simu_lvt
parameters toxn_lvt=2.39e-09
parameters cjn_lvt=1.0561e-03
parameters cjswn_lvt=3.745e-11
parameters cjswgn_lvt=3.6166e-10
parameters cgon_lvt=1.079e-10
parameters cgln_lvt=6.99e-11
parameters dvthn_lvt=3.5e-02
parameters dpvthn_lvt=5.5e-017
parameters dxln_lvt=5.0e-09
parameters dxwn_lvt= - 8.0e-09 - 0.5e-8
parameters dlvthn_lvt=1.6e-09
parameters dwvthn_lvt=3.6e-09
parameters drdswn_lvt=5
parameters dlcdscdn_lvt=0
parameters deta0n_lvt=0
parameters ntoxn_lvt=-0.8
parameters dk2n_lvt=8e-3
parameters dlvoffn_lvt=0
parameters dlcitn_lvt=0
parameters dpvoffn_lvt=0
parameters dpeta0n_lvt=0
parameters dpvsatn_lvt=0
parameters dppclmn_lvt=0
parameters toxp_lvt=2.56e-09
parameters ddsubn_lvt=0
parameters dlvsatn_lvt=0
parameters dxlp_lvt=5.0e-09
parameters dxwp_lvt= - 8.0e-09 - 0.5e-8
parameters dvthp_lvt=-3.0e-02
parameters dlvthp_lvt=-9.0e-10
parameters dwvthp_lvt=-9.0e-10
parameters dpvthp_lvt=-1.0e-16
parameters cjp_lvt=1.209e-03
parameters cjswp_lvt=6.206e-11
parameters cjswgp_lvt=3.264e-10
parameters cgop_lvt=3.869e-11
parameters cglp_lvt=1.6e-10
parameters dlvoffp_lvt=2.5e-10
parameters dpvoffp_lvt=1.0e-16
parameters dk2p_lvt=3e-3
parameters ntoxp_lvt=-3.0
parameters deta0p_lvt=0
parameters dpeta0p_lvt=0
parameters dpvsatp_lvt=0
parameters dlvsatp_lvt=0
parameters cfn_lvt=1.283e-10 + 3.1e-11 * ccoflag_lvt
parameters cfp_lvt=1.283e-10 + 3.1e-11 * ccoflag_lvt
include "cln90g_lk.scs" section=mos_lvt
endsection ss_lvt

//  ****************************  LIBRARY OF FNFP CORNER CASE  ******************************

section ff_lvt
include "cln90g_lk.scs" section=cco_pre_simu_lvt
include "cln90g_lk.scs" section=wpe_pre_simu_lvt
parameters toxn_lvt=2.27e-09
parameters cjn_lvt=9.1791e-04
parameters cjswn_lvt=3.255e-11
parameters cjswgn_lvt=3.1434e-10
parameters cgon_lvt=1.241e-10
parameters cgln_lvt=8.05e-11
parameters dvthn_lvt=-3.5e-02
parameters dpvthn_lvt=-1.2e-016
parameters dxln_lvt=-5.0e-09
parameters dxwn_lvt=8.0e-09 - 0.5e-8
parameters dlvthn_lvt=-1.1e-09
parameters dwvthn_lvt=-4.0e-09
parameters drdswn_lvt=0
parameters dlcdscdn_lvt=0
parameters deta0n_lvt=-0.025
parameters ntoxn_lvt=2.7
parameters dk2n_lvt=-5e-3
parameters dlvoffn_lvt=1e-9
parameters dlcitn_lvt=0e-10
parameters dpvoffn_lvt=1e-16
parameters dpeta0n_lvt=7.0e-16
parameters dpvsatn_lvt=-5.0e-11
parameters dppclmn_lvt=-2e-16
parameters toxp_lvt=2.44e-09
parameters ddsubn_lvt=-0.09
parameters dlvsatn_lvt=-2.5e-4
parameters dxlp_lvt=-5.0e-09
parameters dxwp_lvt=8.0e-09 - 0.5e-8
parameters dvthp_lvt=3.0e-02
parameters dlvthp_lvt=1.0e-9
parameters dwvthp_lvt=1.5e-9
parameters dpvthp_lvt=1.3e-16
parameters cjp_lvt=1.051e-03
parameters cjswp_lvt=5.394e-11
parameters cjswgp_lvt=2.836e-10
parameters cgop_lvt=4.451e-11
parameters cglp_lvt=1.84e-10
parameters dlvoffp_lvt=-1.0e-10
parameters dpvoffp_lvt=-0.3e-16
parameters dk2p_lvt=-3e-3
parameters ntoxp_lvt=5.0
parameters deta0p_lvt=0.020
parameters dpeta0p_lvt=1e-16
parameters dpvsatp_lvt=-1.3e-10
parameters dlvsatp_lvt=-6.5e-4
parameters cfn_lvt=1.477e-10 + 3.1e-11 * ccoflag_lvt
parameters cfp_lvt=1.477e-10 + 3.1e-11 * ccoflag_lvt
include "cln90g_lk.scs" section=mos_lvt
endsection ff_lvt

//  ****************************  LIBRARY OF SNFP CORNER CASE  ******************************

section sf_lvt
include "cln90g_lk.scs" section=cco_pre_simu_lvt
include "cln90g_lk.scs" section=wpe_pre_simu_lvt
parameters a4np_lvt=0
parameters a1n_lvt=0.8
parameters a1p_lvt=-0.8
parameters a2n_lvt=0
parameters a2p_lvt=0
parameters a3n_lvt=0
parameters a3p_lvt=0
parameters toxn_lvt=2.33e-09 + 6.0000e-11 * a4np_lvt
parameters cjn_lvt=9.87e-04 * (1 + 0.070 * a1n_lvt)
parameters cjswn_lvt=3.5e-11 * (1 + 0.070 * a1n_lvt)
parameters cjswgn_lvt=3.38e-10 * (1 + 0.070 * a1n_lvt)
parameters cgon_lvt=1.16e-10 * (1 - 0.070 * a4np_lvt)
parameters cgln_lvt=7.52e-11 * (1 - 0.070 * a4np_lvt)
parameters dvthn_lvt=0.035 * a1n_lvt
parameters dpvthn_lvt=1.2e-16 * a1n_lvt
parameters dxln_lvt=5e-09 * a2n_lvt
parameters dxwn_lvt=0.8e-08 * a3n_lvt - 0.5e-08
parameters dlvthn_lvt=1.1e-09 * a1n_lvt
parameters dwvthn_lvt=4e-09 * a1n_lvt
parameters drdswn_lvt=0
parameters dlcdscdn_lvt=0
parameters deta0n_lvt=0.025 * a1n_lvt
parameters ntoxn_lvt=1 +  - 1.7000e+00 * a4np_lvt
parameters dk2n_lvt=0.005 * a1n_lvt
parameters dlvoffn_lvt= - 1e-9 * a1n_lvt
parameters dlcitn_lvt=0 * a1n_lvt
parameters dpvoffn_lvt= - 1e-16 * a1n_lvt
parameters dpeta0n_lvt= - 6e-16 * a1n_lvt
parameters dpvsatn_lvt=5e-11 * a1n_lvt
parameters dppclmn_lvt=2e-16 * a1n_lvt
parameters toxp_lvt=2.50e-09 + 6.0000e-11 * a4np_lvt
parameters ddsubn_lvt=0.09 * a1n_lvt
parameters dlvsatn_lvt=0.00025 * a1n_lvt
parameters dxlp_lvt=5e-09 * a2p_lvt
parameters dxwp_lvt=0.8e-08 * a3p_lvt - 0.5e-08
parameters dvthp_lvt= - 0.03 * a1p_lvt
parameters dlvthp_lvt= - 1e-09 * a1p_lvt
parameters dwvthp_lvt= - 1.5e-09 * a1p_lvt
parameters dpvthp_lvt= - 1.3e-16 * a1p_lvt
parameters cjp_lvt=1.13e-03 * (1 + 0.070 * a1p_lvt)
parameters cjswp_lvt=5.8e-11 * (1 + 0.070 * a1p_lvt)
parameters cjswgp_lvt=3.05e-10 * (1 + 0.070 * a1p_lvt)
parameters cgop_lvt=4.16e-11 * (1 - 0.070 * a4np_lvt)
parameters cglp_lvt=1.72e-10 * (1 - 0.070 * a4np_lvt)
parameters dlvoffp_lvt=1e-10 * a1p_lvt
parameters dpvoffp_lvt=0.3e-16 * a1p_lvt
parameters dk2p_lvt=0.003 * a1p_lvt
parameters ntoxp_lvt=1 +  - 4.0000e+00 * a4np_lvt
parameters deta0p_lvt= - 0.01 * a1p_lvt
parameters dpeta0p_lvt= - 1e-16 * a1p_lvt
parameters dpvsatp_lvt=1.3e-10 * a1p_lvt
parameters dlvsatp_lvt=0.00065 * a1p_lvt
parameters cfn_lvt=1.38e-10 * (1 - 0.070 * a4np_lvt) + 3.1e-11 * ccoflag_lvt
parameters cfp_lvt=1.38e-10 * (1 - 0.070 * a4np_lvt) + 3.1e-11 * ccoflag_lvt

include "cln90g_lk.scs" section=mos_lvt
endsection sf_lvt

//  ****************************  LIBRARY OF FNSP CORNER CASE  ******************************

section fs_lvt
include "cln90g_lk.scs" section=cco_pre_simu_lvt
include "cln90g_lk.scs" section=wpe_pre_simu_lvt
parameters a4np_lvt=0
parameters a1n_lvt=-0.8
parameters a1p_lvt=0.8
parameters a2n_lvt=0
parameters a2p_lvt=0
parameters a3n_lvt=0
parameters a3p_lvt=0
parameters toxn_lvt=2.33e-09 + 6.0000e-11 * a4np_lvt
parameters cjn_lvt=9.87e-04 * (1 + 0.070 * a1n_lvt)
parameters cjswn_lvt=3.5e-11 * (1 + 0.070 * a1n_lvt)
parameters cjswgn_lvt=3.38e-10 * (1 + 0.070 * a1n_lvt)
parameters cgon_lvt=1.16e-10 * (1 - 0.070 * a4np_lvt)
parameters cgln_lvt=7.52e-11 * (1 - 0.070 * a4np_lvt)
parameters dvthn_lvt=0.035 * a1n_lvt
parameters dpvthn_lvt=1.2e-16 * a1n_lvt
parameters dxln_lvt=5e-09 * a2n_lvt
parameters dxwn_lvt=0.8e-08 * a3n_lvt - 0.5e-08
parameters dlvthn_lvt=1.1e-09 * a1n_lvt
parameters dwvthn_lvt=4e-09 * a1n_lvt
parameters drdswn_lvt=0
parameters dlcdscdn_lvt=0
parameters deta0n_lvt=0.025 * a1n_lvt
parameters ntoxn_lvt=1 +  - 1.7000e+00 * a4np_lvt
parameters dk2n_lvt=0.005 * a1n_lvt
parameters dlvoffn_lvt= - 1e-9 * a1n_lvt
parameters dlcitn_lvt=0 * a1n_lvt
parameters dpvoffn_lvt= - 1e-16 * a1n_lvt
parameters dpeta0n_lvt= - 6e-16 * a1n_lvt
parameters dpvsatn_lvt=5e-11 * a1n_lvt
parameters dppclmn_lvt=2e-16 * a1n_lvt
parameters toxp_lvt=2.50e-09 + 6.0000e-11 * a4np_lvt
parameters ddsubn_lvt=0.09 * a1n_lvt
parameters dlvsatn_lvt=0.00025 * a1n_lvt
parameters dxlp_lvt=5e-09 * a2p_lvt
parameters dxwp_lvt=0.8e-08 * a3p_lvt - 0.5e-08
parameters dvthp_lvt= - 0.03 * a1p_lvt
parameters dlvthp_lvt= - 1e-09 * a1p_lvt
parameters dwvthp_lvt= - 1.5e-09 * a1p_lvt
parameters dpvthp_lvt= - 1.3e-16 * a1p_lvt
parameters cjp_lvt=1.13e-03 * (1 + 0.070 * a1p_lvt)
parameters cjswp_lvt=5.8e-11 * (1 + 0.070 * a1p_lvt)
parameters cjswgp_lvt=3.05e-10 * (1 + 0.070 * a1p_lvt)
parameters cgop_lvt=4.16e-11 * (1 - 0.070 * a4np_lvt)
parameters cglp_lvt=1.72e-10 * (1 - 0.070 * a4np_lvt)
parameters dlvoffp_lvt=1e-10 * a1p_lvt
parameters dpvoffp_lvt=0.3e-16 * a1p_lvt
parameters dk2p_lvt=0.003 * a1p_lvt
parameters ntoxp_lvt=1 +  - 4.0000e+00 * a4np_lvt
parameters deta0p_lvt= - 0.01 * a1p_lvt
parameters dpeta0p_lvt= - 1e-16 * a1p_lvt
parameters dpvsatp_lvt=1.3e-10 * a1p_lvt
parameters dlvsatp_lvt=0.00065 * a1p_lvt
parameters cfn_lvt=1.38e-10 * (1 - 0.070 * a4np_lvt) + 3.1e-11 * ccoflag_lvt
parameters cfp_lvt=1.38e-10 * (1 - 0.070 * a4np_lvt) + 3.1e-11 * ccoflag_lvt

include "cln90g_lk.scs" section=mos_lvt
endsection fs_lvt

//  *************************************************************
//                                                              *
//                       1.8V DEVICE LIB                        *
//                                                              *
//  *************************************************************
//  ****************************     LIBRARY OF TYPICAL CASE     *******************************

section tt_18
include "cln90g_lk.scs" section=cco_pre_simu_18
include "cln90g_lk.scs" section=wpe_pre_simu_18
parameters toxn_18=3.45e-09
parameters dxln_18=0
parameters dxwn_18=0
parameters dvthn_18=0
parameters dlvthn_18=0
parameters dwvthn_18=0
parameters dlvsatn_18=0
parameters dk2n_18=0
parameters dlpclmn_18=0
parameters drdswn_18=0
parameters dlnfactorn_18=0
parameters cjn_18=0.000966
parameters cjswn_18=5.42e-11
parameters cjswgn_18=2.9e-10
parameters cgon_18=1.090e-10
parameters cgln_18=7.492e-11
parameters dlcn_18=2.153e-08
parameters cfn_18=1.350e-10 + 2.4e-11 * ccoflag_18
parameters toxp_18=3.7e-09
parameters dxlp_18=0
parameters dxwp_18=0
parameters dvthp_18=0
parameters dlvthp_18=0
parameters dwvthp_18=0
parameters dlvsatp_18=0
parameters dk2p_18=0
parameters dlpclmp_18=0
parameters dlnfactorp_18=0
parameters dwnfactorp_18=0
parameters cjp_18=0.001078
parameters cjswp_18=7e-11
parameters cjswgp_18=3.09e-10
parameters cgop_18=7.286e-11
parameters cglp_18=1.045e-10
parameters dlcp_18=2.689e-08
parameters cfp_18=1.35e-10 + 2.4e-11 * ccoflag_18
include "cln90g_lk.scs" section=mos_18
endsection tt_18

//  ****************************   LIBRARY OF SNSP CORNER CASE   *******************************

section ss_18
include "cln90g_lk.scs" section=cco_pre_simu_18
include "cln90g_lk.scs" section=wpe_pre_simu_18
parameters toxn_18=3.5833e-09
parameters dxln_18=8e-09
parameters dxwn_18=-1.2e-08
parameters dvthn_18=0.05
parameters dlvthn_18=1.8e-09
parameters dwvthn_18=6e-09
parameters dlvsatn_18=0.0003
parameters dk2n_18=0.01
parameters dlpclmn_18=-0.15e-07
parameters drdswn_18=30
parameters dlnfactorn_18=0
parameters cjn_18=0.001034
parameters cjswn_18=5.799e-11
parameters cjswgn_18=3.103e-10
parameters cgon_18=1.014e-10
parameters cgln_18=6.968e-11
parameters dlcn_18=2.153e-08
parameters cfn_18=1.256e-10 + 2.4e-11 * ccoflag_18
parameters toxp_18=3.8333e-09
parameters dxlp_18=8e-09
parameters dxwp_18=-1.2e-08
parameters dvthp_18=-0.05
parameters dlvthp_18=-1.86e-09
parameters dwvthp_18=-7e-09
parameters dlvsatp_18=0.0007
parameters dk2p_18=0.012
parameters dlpclmp_18=-1.5e-08
parameters dlnfactorp_18=0
parameters dwnfactorp_18=0
parameters cjp_18=0.001153
parameters cjswp_18=7.49e-11
parameters cjswgp_18=3.306e-10
parameters cgop_18=6.78e-11
parameters cglp_18=9.72250e-11
parameters dlcp_18=2.689e-08
parameters cfp_18=1.256e-10 + 2.4e-11 * ccoflag_18
include "cln90g_lk.scs" section=mos_18
endsection ss_18

//  ****************************   LIBRARY OF FNFP CORNER CASE   *******************************

section ff_18
include "cln90g_lk.scs" section=cco_pre_simu_18
include "cln90g_lk.scs" section=wpe_pre_simu_18
parameters toxn_18=3.3167e-09
parameters dxln_18=-8e-09
parameters dxwn_18=1.2e-08
parameters dvthn_18=-0.05
parameters dlvthn_18=-1.8e-09
parameters dwvthn_18=-4e-09
parameters dlvsatn_18=-0.0008
parameters dk2n_18=-0.01
parameters dlpclmn_18=0.4e-07
parameters drdswn_18=-25
parameters dlnfactorn_18=0
parameters cjn_18=0.0008984
parameters cjswn_18=5.041e-11
parameters cjswgn_18=2.7e-10
parameters cgon_18=1.167e-10
parameters cgln_18=8.016e-11
parameters dlcn_18=2.153e-08
parameters cfn_18=1.445e-10 + 2.4e-11 * ccoflag_18
parameters toxp_18=3.5667e-09
parameters dxlp_18=-8e-09
parameters dxwp_18=1.2e-08
parameters dvthp_18=0.05
parameters dlvthp_18=1.24e-09
parameters dwvthp_18=5e-09
parameters dlvsatp_18=-0.0007
parameters dk2p_18=-0.012
parameters dlpclmp_18=3e-08
parameters dlnfactorp_18=0
parameters dwnfactorp_18=0
parameters cjp_18=0.001003
parameters cjswp_18=6.51e-11
parameters cjswgp_18=2.874e-10
parameters cgop_18=7.80e-11
parameters cglp_18=1.11861e-10
parameters dlcp_18=2.689e-08
parameters cfp_18=1.445e-10 + 2.4e-11 * ccoflag_18
include "cln90g_lk.scs" section=mos_18
endsection ff_18

//  ****************************   LIBRARY OF SNFP CORNER CASE   *******************************

section sf_18
include "cln90g_lk.scs" section=cco_pre_simu_18
include "cln90g_lk.scs" section=wpe_pre_simu_18
parameters a1n_18=0.8
parameters a1p_18=-0.8
parameters a2n_18=0
parameters a2p_18=0
parameters a3n_18=-1
parameters a3p_18=1
parameters a4n_18=1
parameters a4p_18=-1
parameters a5n_18=0
parameters a5p_18=0
parameters toxn_18=3.45e-09 + 1.3330e-10 * a4n_18
parameters dxln_18=8e-09 * a2n_18
parameters dxwn_18=1.2e-08 * a3n_18
parameters dvthn_18=0.05 * a1n_18
parameters dlvthn_18=1.8e-09 * a1n_18
parameters dwvthn_18=4e-09 * a1n_18
parameters dlvsatn_18=0.0008 * a1n_18 + 5e-4 * a5n_18
parameters dk2n_18=0.01 * a1n_18
parameters dlpclmn_18= - 4e-08 * a1n_18
parameters drdswn_18=25 * a1n_18
parameters dlnfactorn_18= - 6e-08 * a5p_18
parameters cjn_18=0.000966 * (1 + 0.070 * a1n_18)
parameters cjswn_18=5.42e-11 * (1 + 0.070 * a1n_18)
parameters cjswgn_18=2.9e-10 * (1 + 0.069 * a1n_18)
parameters cgon_18=1.090e-10 * (1 - 0.071 * a4n_18)
parameters cgln_18=7.492e-11 * (1 - 0.070 * a4n_18)
parameters dlcn_18=2.153e-08
parameters cfn_18=1.350e-10 * (1 - 0.070 * a4n_18) + 2.4e-11 * ccoflag_18
parameters toxp_18=3.7e-09 + 1.3330e-10 * a4p_18
parameters dxlp_18=8e-09 * a2p_18
parameters dxwp_18=1.2e-08 * a3p_18
parameters dvthp_18= - 0.05 * a1p_18
parameters dlvthp_18= - 1.24e-09 * a1p_18
parameters dwvthp_18= - 5e-09 * a1p_18
parameters dlvsatp_18=0.0007 * a1p_18
parameters dk2p_18=0.012 * a1p_18
parameters dlpclmp_18= - 3e-08 * a1p_18
parameters dlnfactorp_18= - 1.5e-08 * a5p_18
parameters dwnfactorp_18= - 7e-08 * a5p_18
parameters cjp_18=0.001078 * (1 + 0.070 * a1p_18)
parameters cjswp_18=7e-11 * (1 + 0.070 * a1p_18)
parameters cjswgp_18=3.09e-10 * (1 + 0.070 * a1p_18)
parameters cgop_18=7.286e-11 * (1 - 0.071 * a4p_18)
parameters cglp_18=1.045e-10 * (1 - 0.070 * a4p_18)
parameters dlcp_18=2.689e-08
parameters cfp_18=1.35e-10 * (1 - 0.070 * a4p_18) + 2.4e-11 * ccoflag_18
include "cln90g_lk.scs" section=mos_18
endsection sf_18

//  ****************************   LIBRARY OF FNSP CORNER CASE   *******************************

section fs_18
include "cln90g_lk.scs" section=cco_pre_simu_18
include "cln90g_lk.scs" section=wpe_pre_simu_18
parameters a1n_18=-0.8
parameters a1p_18=0.8
parameters a2n_18=0
parameters a2p_18=0
parameters a3n_18=1
parameters a3p_18=-1
parameters a4n_18=-1
parameters a4p_18=1
parameters a5n_18=0
parameters a5p_18=0
parameters toxn_18=3.45e-09 + 1.3330e-10 * a4n_18
parameters dxln_18=8e-09 * a2n_18
parameters dxwn_18=1.2e-08 * a3n_18
parameters dvthn_18=0.05 * a1n_18
parameters dlvthn_18=1.8e-09 * a1n_18
parameters dwvthn_18=4e-09 * a1n_18
parameters dlvsatn_18=0.0008 * a1n_18 + 5e-4 * a5n_18
parameters dk2n_18=0.01 * a1n_18
parameters dlpclmn_18= - 4e-08 * a1n_18
parameters drdswn_18=25 * a1n_18
parameters dlnfactorn_18= - 6e-08 * a5p_18
parameters cjn_18=0.000966 * (1 + 0.070 * a1n_18)
parameters cjswn_18=5.42e-11 * (1 + 0.070 * a1n_18)
parameters cjswgn_18=2.9e-10 * (1 + 0.069 * a1n_18)
parameters cgon_18=1.090e-10 * (1 - 0.071 * a4n_18)
parameters cgln_18=7.492e-11 * (1 - 0.070 * a4n_18)
parameters dlcn_18=2.153e-08
parameters cfn_18=1.350e-10 * (1 - 0.070 * a4n_18) + 2.4e-11 * ccoflag_18
parameters toxp_18=3.7e-09 + 1.3330e-10 * a4p_18
parameters dxlp_18=8e-09 * a2p_18
parameters dxwp_18=1.2e-08 * a3p_18
parameters dvthp_18= - 0.05 * a1p_18
parameters dlvthp_18= - 1.24e-09 * a1p_18
parameters dwvthp_18= - 5e-09 * a1p_18
parameters dlvsatp_18=0.0007 * a1p_18
parameters dk2p_18=0.012 * a1p_18
parameters dlpclmp_18= - 3e-08 * a1p_18
parameters dlnfactorp_18= - 1.5e-08 * a5p_18
parameters dwnfactorp_18= - 7e-08 * a5p_18
parameters cjp_18=0.001078 * (1 + 0.070 * a1p_18)
parameters cjswp_18=7e-11 * (1 + 0.070 * a1p_18)
parameters cjswgp_18=3.09e-10 * (1 + 0.070 * a1p_18)
parameters cgop_18=7.286e-11 * (1 - 0.071 * a4p_18)
parameters cglp_18=1.045e-10 * (1 - 0.070 * a4p_18)
parameters dlcp_18=2.689e-08
parameters cfp_18=1.35e-10 * (1 - 0.070 * a4p_18) + 2.4e-11 * ccoflag_18
include "cln90g_lk.scs" section=mos_18
endsection fs_18

//  *************************************************************
//                                                              *
//                       3.3V DEVICE LIB                        *
//                                                              *
//  *************************************************************

//  ****************************     LIBRARY OF TYPICAL CASE     *******************************

section tt_33
include "cln90g_lk.scs" section=cco_pre_simu_33
include "cln90g_lk.scs" section=wpe_pre_simu_33
parameters toxn_33=7.2e-09
parameters dxln_33=0
parameters dxwn_33=0
parameters dvthn_33=0
parameters dlvthn_33=0
parameters dwvthn_33=0
parameters du0n_33=0
parameters dlu0n_33=0
parameters drdswn_33=0
parameters dk2n_33=0
parameters cjn_33=9.620e-04
parameters cjswn_33=1.38e-10
parameters cjswgn_33=2.48e-10
parameters cgon_33=8.516e-12
parameters cgln_33=2.108e-10
parameters cfn_33=1.110e-10 + 3.5e-11 * ccoflag_33
parameters toxp_33=7.5e-09
parameters dxlp_33=0
parameters dxwp_33=0
parameters dvthp_33=0
parameters dlvthp_33=0
parameters dwvthp_33=0
parameters du0p_33=0
parameters dlu0p_33=0
parameters drdswp_33=0
parameters dk2p_33=0
parameters cjp_33=1.040e-03
parameters cjswp_33=7.00e-11
parameters cjswgp_33=1.53e-10
parameters cgop_33=2.48e-11
parameters cglp_33=1.716e-10
parameters cfp_33=1.110e-10 + 3.5e-11 * ccoflag_33
include "cln90g_lk.scs" section=mos_33
endsection tt_33

//  ****************************   LIBRARY OF SNSP CORNER CASE   *******************************

section ss_33
include "cln90g_lk.scs" section=cco_pre_simu_33
include "cln90g_lk.scs" section=wpe_pre_simu_33
parameters toxn_33=7.5e-09
parameters dxln_33=1.2e-08
parameters dxwn_33=-1.2e-08
parameters dvthn_33=0.041
parameters dlvthn_33=7e-09
parameters dwvthn_33=3e-09
parameters du0n_33=-8
parameters dlu0n_33=-5e-6
parameters drdswn_33=90
parameters dk2n_33=0.01
parameters cjn_33=1.029e-03
parameters cjswn_33=1.477e-10
parameters cjswgn_33=2.654e-10
parameters cgon_33=7.920e-12
parameters cgln_33=1.960e-10
parameters cfn_33=1.032e-10 + 3.5e-11 * ccoflag_33
parameters toxp_33=7.8e-09
parameters dxlp_33=1.2e-08
parameters dxwp_33=-1.2e-08
parameters dvthp_33=-0.056
parameters dlvthp_33=-5e-10
parameters dwvthp_33=-2e-09
parameters du0p_33=-1
parameters dlu0p_33=-1e-8
parameters drdswp_33=70
parameters dk2p_33=0.01
parameters cjp_33=1.113e-03
parameters cjswp_33=7.490e-11
parameters cjswgp_33=1.637e-10
parameters cgop_33=2.31e-11
parameters cglp_33=1.59588e-10
parameters cfp_33=1.032e-10 + 3.5e-11 * ccoflag_33
include "cln90g_lk.scs" section=mos_33
endsection ss_33

//  ****************************   LIBRARY OF FNFP CORNER CASE   *******************************

section ff_33
include "cln90g_lk.scs" section=cco_pre_simu_33
include "cln90g_lk.scs" section=wpe_pre_simu_33
parameters toxn_33=6.9e-09
parameters dxln_33=-1.2e-08
parameters dxwn_33=1.2e-08
parameters dvthn_33=-0.041
parameters dlvthn_33=-7e-09
parameters dwvthn_33=-3e-09
parameters du0n_33=8
parameters dlu0n_33=5e-6
parameters drdswn_33=-60
parameters dk2n_33=-0.01
parameters cjn_33=8.947e-04
parameters cjswn_33=1.283e-10
parameters cjswgn_33=2.306e-10
parameters cgon_33=9.112e-12
parameters cgln_33=2.256e-10
parameters cfn_33=1.188e-10 + 3.5e-11 * ccoflag_33
parameters toxp_33=7.2e-09
parameters dxlp_33=-1.2e-08
parameters dxwp_33=1.2e-08
parameters dvthp_33=0.056
parameters dlvthp_33=1e-10
parameters dwvthp_33=2e-09
parameters du0p_33=1
parameters dlu0p_33=1e-8
parameters drdswp_33=0
parameters dk2p_33=-0.01
parameters cjp_33=9.672e-04
parameters cjswp_33=6.510e-11
parameters cjswgp_33=1.423e-10
parameters cgop_33=2.65e-11
parameters cglp_33=1.83612e-10
parameters cfp_33=1.188e-10 + 3.5e-11 * ccoflag_33
include "cln90g_lk.scs" section=mos_33
endsection ff_33

//  ****************************   LIBRARY OF SNFP CORNER CASE   *******************************

section sf_33
include "cln90g_lk.scs" section=cco_pre_simu_33
include "cln90g_lk.scs" section=wpe_pre_simu_33
parameters a1n_33=0.8
parameters a1p_33=-0.8
parameters a2n_33=0
parameters a2p_33=0
parameters a3n_33=-1
parameters a3p_33=1
parameters a4np_33=0
parameters toxn_33=7.2e-09 + 3.0000e-10 * a4np_33
parameters dxln_33=1.2e-08 * a2n_33
parameters dxwn_33=1.2e-08 * a3n_33
parameters dvthn_33=0.041 * a1n_33
parameters dlvthn_33=7e-09 * a1n_33
parameters dwvthn_33=3e-09 * a1n_33
parameters du0n_33= - 8 * a1n_33
parameters dlu0n_33= - 5e-06 * a1n_33
parameters drdswn_33=60 * a1n_33
parameters dk2n_33=0.01 * a1n_33
parameters cjn_33=9.620e-04 * (1 + 0.070 * a1n_33)
parameters cjswn_33=1.38e-10 * (1 + 0.070 * a1n_33)
parameters cjswgn_33=2.48e-10 * (1 + 0.070 * a1n_33)
parameters cgon_33=8.516e-12 * (1 - 0.070 * a4np_33)
parameters cgln_33=2.108e-10 * (1 - 0.070 * a4np_33)
parameters cfn_33=1.110e-10 * (1 - 0.070 * a4np_33) + 3.5e-11 * ccoflag_33
parameters toxp_33=7.5e-09 + 3.0000e-10 * a4np_33
parameters dxlp_33=1.2e-08 * a2p_33
parameters dxwp_33=1.2e-08 * a3p_33
parameters dvthp_33= - 0.056 * a1p_33
parameters dlvthp_33= - 1e-10 * a1p_33
parameters dwvthp_33= - 2e-09 * a1p_33
parameters du0p_33= - 1 * a1p_33
parameters dlu0p_33= - 1e-08 * a1p_33
parameters drdswp_33=0
parameters dk2p_33=0.01 * a1p_33
parameters cjp_33=1.040e-03 * (1 + 0.070 * a1p_33)
parameters cjswp_33=7.00e-11 * (1 + 0.070 * a1p_33)
parameters cjswgp_33=1.53e-10 * (1 + 0.070 * a1p_33)
parameters cgop_33=2.48e-11 * (1 - 0.069 * a4np_33)
parameters cglp_33=1.716e-10 * (1 - 0.070 * a4np_33)
parameters cfp_33=1.110e-10 * (1 - 0.070 * a4np_33) + 3.5e-11 * ccoflag_33
include "cln90g_lk.scs" section=mos_33
endsection sf_33

//  ****************************   LIBRARY OF FNSP CORNER CASE   *******************************

section fs_33
include "cln90g_lk.scs" section=cco_pre_simu_33
include "cln90g_lk.scs" section=wpe_pre_simu_33
parameters a1n_33=-0.8
parameters a1p_33=0.8
parameters a2n_33=0
parameters a2p_33=0
parameters a3n_33=1
parameters a3p_33=-1
parameters a4np_33=0
parameters toxn_33=7.2e-09 + 3.0000e-10 * a4np_33
parameters dxln_33=1.2e-08 * a2n_33
parameters dxwn_33=1.2e-08 * a3n_33
parameters dvthn_33=0.041 * a1n_33
parameters dlvthn_33=7e-09 * a1n_33
parameters dwvthn_33=3e-09 * a1n_33
parameters du0n_33= - 8 * a1n_33
parameters dlu0n_33= - 5e-06 * a1n_33
parameters drdswn_33=60 * a1n_33
parameters dk2n_33=0.01 * a1n_33
parameters cjn_33=9.620e-04 * (1 + 0.070 * a1n_33)
parameters cjswn_33=1.38e-10 * (1 + 0.070 * a1n_33)
parameters cjswgn_33=2.48e-10 * (1 + 0.070 * a1n_33)
parameters cgon_33=8.516e-12 * (1 - 0.070 * a4np_33)
parameters cgln_33=2.108e-10 * (1 - 0.070 * a4np_33)
parameters cfn_33=1.110e-10 * (1 - 0.070 * a4np_33) + 3.5e-11 * ccoflag_33
parameters toxp_33=7.5e-09 + 3.0000e-10 * a4np_33
parameters dxlp_33=1.2e-08 * a2p_33
parameters dxwp_33=1.2e-08 * a3p_33
parameters dvthp_33= - 0.056 * a1p_33
parameters dlvthp_33= - 1e-10 * a1p_33
parameters dwvthp_33= - 2e-09 * a1p_33
parameters du0p_33= - 1 * a1p_33
parameters dlu0p_33= - 1e-08 * a1p_33
parameters drdswp_33=0
parameters dk2p_33=0.01 * a1p_33
parameters cjp_33=1.040e-03 * (1 + 0.070 * a1p_33)
parameters cjswp_33=7.00e-11 * (1 + 0.070 * a1p_33)
parameters cjswgp_33=1.53e-10 * (1 + 0.070 * a1p_33)
parameters cgop_33=2.48e-11 * (1 - 0.069 * a4np_33)
parameters cglp_33=1.716e-10 * (1 - 0.070 * a4np_33)
parameters cfp_33=1.110e-10 * (1 - 0.070 * a4np_33) + 3.5e-11 * ccoflag_33
include "cln90g_lk.scs" section=mos_33
endsection fs_33

//  *************************************************************
//                                                              *
//                1.0V NATIVE NMOS DEVICE LIB                   *
//                                                              *
//  *************************************************************
//
//  ****************************    LIBRARY OF TYPICAL CASE    ******************************

section tt_na
include "cln90g_lk.scs" section=cco_pre_simu_na
parameters toxn_na=2.33e-09
parameters cjn_na=1.4400e-04
parameters cjswn_na=1.6000e-10
parameters cjswgn_na=1.3900e-10
parameters cgon_na=8.54e-11
parameters cgln_na=1.3600e-10
parameters dvthn_na=0
parameters dpvthn_na=0
parameters dxl_na=0
parameters dxw_na=-5.0e-09
parameters dlvthn_na=0
parameters dwvthn_na=0
parameters ntoxn_na=1
parameters cfn_na=1.38e-10 + 3.1e-11 * ccoflag_na
include "cln90g_lk.scs" section=mos_na
endsection tt_na

//  ****************************  LIBRARY OF SNSP CORNER CASE  ******************************

section ss_na
include "cln90g_lk.scs" section=cco_pre_simu_na
parameters toxn_na=2.39e-09
parameters cjn_na=1.541e-04
parameters cjswn_na=1.712e-10
parameters cjswgn_na=1.4873e-10
parameters cgon_na=7.9422e-11
parameters cgln_na=1.2648e-10
parameters dvthn_na=3.500e-02
parameters dpvthn_na=1.9e-016
parameters dxl_na=5.000e-09
parameters dxw_na= - 8.000e-09 - 5.0e-09
parameters dlvthn_na=3.0e-09
parameters dwvthn_na=3.0e-09
parameters ntoxn_na=-0.8
parameters cfn_na=1.283e-10 + 3.1e-11 * ccoflag_na
include "cln90g_lk.scs" section=mos_na
endsection ss_na

//  ****************************  LIBRARY OF FNFP CORNER CASE  ******************************

section ff_na
include "cln90g_lk.scs" section=cco_pre_simu_na
parameters toxn_na=2.27e-09
parameters cjn_na=1.339e-04
parameters cjswn_na=1.488e-10
parameters cjswgn_na=1.293e-10
parameters cgon_na=9.1378e-11
parameters cgln_na=1.4552e-10
parameters dvthn_na=-3.500e-02
parameters dpvthn_na=-1.15e-016
parameters dxl_na=-5.000e-09
parameters dxw_na=8.000e-09 - 5.0e-09
parameters dlvthn_na=-3.5e-09
parameters dwvthn_na=-3.0e-09
parameters ntoxn_na=2.7
parameters cfn_na=1.477e-10 + 3.1e-11 * ccoflag_na
include "cln90g_lk.scs" section=mos_na
endsection ff_na

//  ****************************  LIBRARY OF SNFP CORNER CASE  ******************************

section sf_na
include "cln90g_lk.scs" section=cco_pre_simu_na
parameters toxn_na=2.33e-09
parameters cjn_na=1.541e-04
parameters cjswn_na=1.712e-10
parameters cjswgn_na=1.4873e-10
parameters cgon_na=8.54e-11
parameters cgln_na=1.3600e-10
parameters dvthn_na=3.500e-02
parameters dpvthn_na=1.9e-016
parameters dxl_na=0
parameters dxw_na=-5.0e-09
parameters dlvthn_na=2.8e-09
parameters dwvthn_na=1.0e-09
parameters ntoxn_na=1
parameters cfn_na=1.38e-10 + 3.1e-11 * ccoflag_na
include "cln90g_lk.scs" section=mos_na
endsection sf_na

//  ****************************  LIBRARY OF FNSP CORNER CASE  ******************************

section fs_na
include "cln90g_lk.scs" section=cco_pre_simu_na
parameters toxn_na=2.33e-09
parameters cjn_na=1.339e-04
parameters cjswn_na=1.488e-10
parameters cjswgn_na=1.293e-10
parameters cgon_na=8.54e-11
parameters cgln_na=1.3600e-10
parameters dvthn_na=-3.500e-02
parameters dpvthn_na=-1.15e-016
parameters dxl_na=0
parameters dxw_na=-5.0e-09
parameters dlvthn_na=-3.4e-09
parameters dwvthn_na=-1.0e-09
parameters ntoxn_na=1
parameters cfn_na=1.38e-10 + 3.1e-11 * ccoflag_na
include "cln90g_lk.scs" section=mos_na
endsection fs_na

//  *****************************************************************************************
//
//
//  *************************************************************
//                                                              *
//                1.8V NATIVE NMOS DEVICE LIB                   *
//                                                              *
//  *************************************************************
//
//  ****************************    LIBRARY OF TYPICAL CASE    ******************************

section tt_na18
include "cln90g_lk.scs" section=cco_pre_simu_na18
parameters toxn_na18=3.45e-09
parameters dxl_na18=0
parameters dxw_na18=0
parameters dvthn_na18=0
parameters dlvthn_na18=0
parameters dwvthn_na18=0
parameters cjn_na18=1.42e-04
parameters cjswn_na18=2.54e-10
parameters cjswgn_na18=1.08e-10
parameters cgon_na18=3.78e-11
parameters cgln_na18=2.816e-10
parameters cfn_na18=1.35e-10 + 2.4e-11 * ccoflag_na18
include "cln90g_lk.scs" section=mos_na18
endsection tt_na18

//  ****************************  LIBRARY OF SNSP CORNER CASE  ******************************

section ss_na18
include "cln90g_lk.scs" section=cco_pre_simu_na18
parameters toxn_na18=3.5833e-09
parameters dxl_na18=8.00e-09
parameters dxw_na18=-1.20e-08
parameters dvthn_na18=0.05
parameters dlvthn_na18=1.5e-08
parameters dwvthn_na18=5.0e-09
parameters cjn_na18=1.5194e-04
parameters cjswn_na18=2.7178e-10
parameters cjswgn_na18=1.1556e-10
parameters cgon_na18=3.5154e-11
parameters cgln_na18=2.619e-10
parameters cfn_na18=1.255e-10 + 2.4e-11 * ccoflag_na18
include "cln90g_lk.scs" section=mos_na18
endsection ss_na18

//  ****************************  LIBRARY OF FNFP CORNER CASE  ******************************

section ff_na18
include "cln90g_lk.scs" section=cco_pre_simu_na18
parameters toxn_na18=3.3167e-09
parameters dxl_na18=-8.00e-09
parameters dxw_na18=1.20e-08
parameters dvthn_na18=-0.05
parameters dlvthn_na18=-1.5e-08
parameters dwvthn_na18=-5.0e-09
parameters cjn_na18=1.3206e-04
parameters cjswn_na18=2.3622e-10
parameters cjswgn_na18=1.0044e-10
parameters cgon_na18=4.0446e-11
parameters cgln_na18=3.013e-10
parameters cfn_na18=1.445e-10 + 2.4e-11 * ccoflag_na18
include "cln90g_lk.scs" section=mos_na18
endsection ff_na18

//  ****************************  LIBRARY OF SNFP CORNER CASE  ******************************

section sf_na18
include "cln90g_lk.scs" section=cco_pre_simu_na18
parameters toxn_na18=3.45e-09
parameters dxl_na18=0
parameters dxw_na18=0
parameters dvthn_na18=0.05
parameters dlvthn_na18=1.0e-08
parameters dwvthn_na18=5.0e-09
parameters cjn_na18=1.5194e-04
parameters cjswn_na18=2.7178e-10
parameters cjswgn_na18=1.1556e-10
parameters cgon_na18=3.78e-11
parameters cgln_na18=2.816e-10
parameters cfn_na18=1.35e-10 + 2.4e-11 * ccoflag_na18
include "cln90g_lk.scs" section=mos_na18
endsection sf_na18

//  ****************************  LIBRARY OF FNSP CORNER CASE  ******************************

section fs_na18
include "cln90g_lk.scs" section=cco_pre_simu_na18
parameters toxn_na18=3.45e-09
parameters dxl_na18=0
parameters dxw_na18=0
parameters dvthn_na18=-0.05
parameters dlvthn_na18=-1.0e-08
parameters dwvthn_na18=-5.0e-09
parameters cjn_na18=1.3206e-04
parameters cjswn_na18=2.3622e-10
parameters cjswgn_na18=1.0044e-10
parameters cgon_na18=3.78e-11
parameters cgln_na18=2.816e-10
parameters cfn_na18=1.35e-10 + 2.4e-11 * ccoflag_na18
include "cln90g_lk.scs" section=mos_na18
endsection fs_na18

//  *****************************************************************************************
//
//
//  *************************************************************
//                                                              *
//                3.3V NATIVE NMOS DEVICE LIB                   *
//                                                              *
//  *************************************************************
//
//  ****************************    LIBRARY OF TYPICAL CASE    ******************************

section tt_na33
include "cln90g_lk.scs" section=cco_pre_simu_na33
parameters toxn_na33=72e-10
parameters cjn_na33=1.39e-04
parameters cjswn_na33=1.97e-10
parameters cjswgn_na33=1.26e-10
parameters cgon_na33=3.0e-11
parameters cgln_na33=1.60e-10
parameters du0n_na33=0
parameters dvthn_na33=0
parameters dlvthn_na33=0
parameters hdifn_na33=1.275e-07
parameters dxl_na33=0
parameters dxw_na33=0
parameters rshn_na33=10.5
parameters cfn_na33=1.11e-10 + 3.5e-11 * ccoflag_na33
include "cln90g_lk.scs" section=mos_na33
endsection tt_na33

//  ****************************  LIBRARY OF SNSP CORNER CASE  ******************************

section ss_na33
include "cln90g_lk.scs" section=cco_pre_simu_na33
parameters toxn_na33=75e-10
parameters cjn_na33=1.4873e-04
parameters cjswn_na33=2.1079e-10
parameters cjswgn_na33=1.3482e-10
parameters cgon_na33=2.79e-11
parameters cgln_na33=1.488e-10
parameters du0n_na33=-1.5e-03
parameters dvthn_na33=0.045
parameters dlvthn_na33=3.5e-8
parameters hdifn_na33=1.275e-07
parameters dxl_na33=1.2e-08
parameters dxw_na33=-1.2e-08
parameters rshn_na33=10.5
parameters cfn_na33=1.032e-10 + 3.5e-11 * ccoflag_na33
include "cln90g_lk.scs" section=mos_na33
endsection ss_na33

//  ****************************  LIBRARY OF FNFP CORNER CASE  ******************************

section ff_na33
include "cln90g_lk.scs" section=cco_pre_simu_na33
parameters toxn_na33=69e-10
parameters cjn_na33=1.2927e-04
parameters cjswn_na33=1.8321e-10
parameters cjswgn_na33=1.1718e-10
parameters cgon_na33=3.21e-11
parameters cgln_na33=1.712e-10
parameters du0n_na33=1.5e-03
parameters dvthn_na33=-0.045
parameters dlvthn_na33=-3.5e-8
parameters hdifn_na33=1.275e-07
parameters dxl_na33=-1.2e-08
parameters dxw_na33=1.2e-08
parameters rshn_na33=10.5
parameters cfn_na33=1.188e-10 + 3.5e-11 * ccoflag_na33
include "cln90g_lk.scs" section=mos_na33
endsection ff_na33

//  ****************************  LIBRARY OF SNFP CORNER CASE  ******************************

section sf_na33
include "cln90g_lk.scs" section=cco_pre_simu_na33
parameters toxn_na33=72e-10
parameters cjn_na33=1.4873e-04
parameters cjswn_na33=2.1079e-10
parameters cjswgn_na33=1.3482e-10
parameters cgon_na33=3.0e-11
parameters cgln_na33=1.60e-10
parameters du0n_na33=-1.5e-03
parameters dvthn_na33=0.045
parameters dlvthn_na33=2.5e-8
parameters hdifn_na33=1.275e-07
parameters dxl_na33=0
parameters dxw_na33=0
parameters rshn_na33=10.5
parameters cfn_na33=1.11e-10 + 3.5e-11 * ccoflag_na33
include "cln90g_lk.scs" section=mos_na33
endsection sf_na33

//  ****************************  LIBRARY OF FNSP CORNER CASE  ******************************

section fs_na33
include "cln90g_lk.scs" section=cco_pre_simu_na33
parameters toxn_na33=72e-10
parameters cjn_na33=1.2927e-04
parameters cjswn_na33=1.8321e-10
parameters cjswgn_na33=1.1718e-10
parameters cgon_na33=3.0e-11
parameters cgln_na33=1.60e-10
parameters du0n_na33=1.5e-03
parameters dvthn_na33=-0.045
parameters dlvthn_na33=-2.5e-8
parameters hdifn_na33=1.275e-07
parameters dxl_na33=0
parameters dxw_na33=0
parameters rshn_na33=10.5
parameters cfn_na33=1.11e-10 + 3.5e-11 * ccoflag_na33
include "cln90g_lk.scs" section=mos_na33
endsection fs_na33

//  *************************************************************
//                                                              *
//                1.0V STANDARD VT DEVICE LIB                   *
//                                                              *
//  *************************************************************
//

section mos
//
//  *****************************************************************************************
//
//             *
//                             1.0V STANDARD VT NMOS DEVICE MODELS
//             *
//
//             *
//  *****************************************************************************************

model nch bsim4  {
     1: type=n
+ lmin=1.0000e-05-dxln      lmax=2.001e-05            wmin=1.0000e-05-dxwn
+ wmax=9.001e-04            version=4.5               binunit=2
+ paramchk=1                mobmod=0                  capmod=2
+ igcmod=1                  igbmod=1                  diomod=1
+ rdsmod=0                  rbodymod=0                rgatemod=0
+ permod=1                  acnqsmod=0                trnqsmod=0
+ tnom=25                   toxe=toxn                 toxm=toxn
+ dtox=3e-010               epsrox=3.9                wint=6e-009
+ lint=2.5e-009             ll=0                      wl=0
+ lln=1                     wln=1                     lw=0
+ ww=0                      lwn=1                     wwn=1
+ lwl=0                     wwl=0                     llc=0
+ wlc=0                     lwc=0                     wwc=0
+ lwlc=0                    wwlc=0                    dlc=1.172e-008
+ dwc=0                     xpart=1                   toxref=3e-009
+ dlcig=2.5e-009            xl=-3.5e-08+dxln          xw=1.5e-8+dxwn
+ vth0=0.228+dvthn          wvth0=0+dwvthn            lvth0=0+dlvthn
+ pvth0=0+dpvthn            k1=0.3231                 k2=0.008228+dk2n
+ k3=-2.7                   k3b=1.2                   w0=-5e-008
+ dvt0=13.9                 dvt1=1.25                 dvt2=0
+ dvt0w=0                   dvt1w=0                   dvt2w=0
+ dsub=0.5                  minv=0                    voffl=0
+ dvtp0=4e-007              dvtp1=2                   lpe0=4.45e-008
+ lpeb=0                    xj=1.5e-007               ngate=4e020
+ ndep=8.3687e017           nsd=1e020                 phin=0
+ cdsc=0                    cdscb=0                   cdscd=0
+ cit=0                     voff=-0.1059              nfactor=0.5
+ eta0=0.22                 peta0=0+dpeta0n           pvoff=0+dpvoffn
+ etab=-0.1                 u0=0.03918                ua=-6.284e-010
+ ub=2.158e-018             uc=2.277e-010             vsat=114000
+ pvsat=0+dpvsatn           a0=2.375                  ags=0.95
+ a1=0                      a2=1                      b0=0
+ b1=0                      keta=-0.045               dwg=0
+ dwb=0                     pclm=0.84                 pdiblc1=0
+ pdiblc2=0.0001            pdiblcb=0                 drout=0
+ pvag=1.5                  delta=0.0075              pscbe1=9.264e008
+ pscbe2=1e-020             fprout=200                pdits=0
+ pditsd=0                  pditsl=0                  rsh=10.5
+ rdsw=140                  prwg=0                    prwb=0
+ wr=1                      alpha0=0                  alpha1=0.03
+ beta0=8.7                 agidl=9e-008              bgidl=2.3e009
+ cgidl=0.5                 egidl=0.53                aigbacc=0.01134
+ bigbacc=0.003249          cigbacc=0.1416            nigbacc=4.05
+ aigbinv=0.35              bigbinv=0.03              cigbinv=0.006
+ eigbinv=1.1               nigbinv=1                 aigc=0.0103
+ bigc=0.001525             cigc=0                    aigsd=0.00845
+ bigsd=0.0004021           cigsd=0.001463            nigc=1
+ poxedge=1                 pigcd=2.3                 ntox=ntoxn
+ xrcrg1=12                 xrcrg2=1                  cgso=cgon
+ cgdo=cgon                 cgbo=0                    cgdl=cgln
+ cgsl=cgln                 clc=1e-007                cle=0.6
+ cf=cfn                    ckappas=0.6               acde=1.2
+ moin=12.6                 noff=1.686                voffcv=-0.05472
+ kt1=-0.2081               kt1l=0                    kt2=-0.04464
+ ute=-1.73                 ua1=2.684e-009            ub1=-3.673e-018
+ uc1=-6.421e-011           prt=0                     at=45000
+ jss=1.77e-07              jsws=4.23e-13             jswgs=9e-12
+ njs=1                     ijthsfwd=0.01             ijthsrev=0.01
+ bvs=10                    xjbvs=1                   pbs=0.5
+ cjs=cjn                   mjs=0.25                  pbsws=0.8
+ cjsws=cjswn               mjsws=0.01                pbswgs=0.78
+ cjswgs=cjswgn             mjswgs=0.52               tpb=1.00e-03
+ tcj=7.32e-04              tpbsw=1.90e-03            tcjsw=3.57e-04
+ tpbswg=1.90e-03           tcjswg=3.57e-04           xtis=3
+ dmcg=9.25e-008            dmci=9.25e-008            dmdg=0
+ dmcgt=0                   dwj=0                     xgw=0
+ xgl=0                     rshg=0.1                  gbmin=1e-012
+ rbpb=50                   rbpd=50                   rbps=50
+ rbdb=50                   rbsb=50                   ngcon=1
+ saref=0.63e-6             sbref=0.63e-6             kvsat=0.20
+ wlod=0.8e-6               tku0=0.01                 ku0=-7.36e-8
+ llodku0=1                 wlodku0=1                 lku0=4.027e-7
+ wku0=8e-7                 pku0=-2.0e-13             kvth0=3.5e-9
+ stk2=1.35e-9              steta0=0                  lkvth0=-2.68e-11
+ wkvth0=1.5e-6             pkvth0=0                  llodvth=1
+ wlodvth=1                 lodk2=0.5                 lodeta0=1
+ fnoimod=1                 noia=4.2926e+41           noib=1.612e+24
+ noic=8.75                 em=1.192e+07              ef=0.8841
+ wpemod=wpeflag            kvth0we=0.00323           lkvth0we=0
+ wkvth0we=0                pkvth0we=0                ku0we=-0.003
+ lku0we=4.00e-10           wku0we=0                  pku0we=0
+ k2we=0.0016               wk2we=0                   web=-210
+ wec=-3500                 scref=1.00e-06            ud=0
+ tnoimod=0                 minr=1e-3

     2: type=n
+ lmin=5.0000e-07-dxln      lmax=1.0000e-05-dxln      wmin=1.0000e-05-dxwn
+ wmax=9.001e-04            version=4.5               binunit=2
+ paramchk=1                mobmod=0                  capmod=2
+ igcmod=1                  igbmod=1                  diomod=1
+ rdsmod=0                  rbodymod=0                rgatemod=0
+ permod=1                  acnqsmod=0                trnqsmod=0
+ tnom=25                   toxe=toxn                 toxm=toxn
+ dtox=3e-010               epsrox=3.9                wint=6e-009
+ lint=2.5e-009             ll=0                      wl=0
+ lln=1                     wln=1                     lw=0
+ ww=0                      lwn=1                     wwn=1
+ lwl=0                     wwl=0                     llc=0
+ wlc=0                     lwc=0                     wwc=0
+ lwlc=0                    wwlc=0                    dlc=1.172e-008
+ dwc=0                     xpart=1                   toxref=3e-009
+ dlcig=2.5e-009            xl=-3.5e-08+dxln          xw=1.5e-8+dxwn
+ vth0=0.228+dvthn          wvth0=0+dwvthn            lvth0=0+dlvthn
+ pvth0=0+dpvthn            k1=0.3231                 k2=0.0085779874+dk2n
+ lk2=-3.4858742e-009       wk2=4.2482823e-025        pk2=-4.2312892e-030
+ k3=-2.7                   k3b=1.2                   w0=-5e-008
+ dvt0=13.9                 dvt1=1.25                 dvt2=0
+ dvt0w=0                   dvt1w=0                   dvt2w=0
+ dsub=0.5                  minv=0                    voffl=0
+ dvtp0=4e-007              dvtp1=2                   lpe0=4.45e-008
+ lpeb=0                    xj=1.5e-007               ngate=4e020
+ ndep=8.3687e017           nsd=1e020                 phin=0
+ cdsc=0                    cdscb=0                   cdscd=0
+ cit=0                     voff=-0.1059              nfactor=0.5
+ eta0=0.22                 peta0=0+dpeta0n           pvoff=0+dpvoffn
+ etab=-0.1                 u0=0.03918                ua=-6.284e-010
+ ub=2.1711705e-018         lub=-1.3117844e-025       wub=2.3582704e-041
+ pub=-2.3488373e-046       uc=2.2999032e-010         luc=-2.2811545e-017
+ wuc=3.165217e-033         puc=-3.1525561e-038       vsat=114000
+ pvsat=0+dpvsatn           a0=2.375                  ags=0.93789474
+ lags=1.2056842e-007       wags=-1.3594503e-023      pags=1.3540125e-028
+ a1=0                      a2=1                      b0=0
+ b1=0                      keta=-0.045               dwg=0
+ dwb=0                     pclm=0.84                 pdiblc1=0
+ pdiblc2=0.0001            pdiblcb=0                 drout=0
+ pvag=1.5                  delta=0.0075              pscbe1=9.264e008
+ pscbe2=1e-020             fprout=200                pdits=0
+ pditsd=0                  pditsl=0                  rsh=10.5
+ rdsw=140                  prwg=0                    prwb=0
+ wr=1                      alpha0=0                  alpha1=0.03
+ beta0=8.7                 agidl=9e-008              bgidl=2.3e009
+ cgidl=0.5                 egidl=0.53                aigbacc=0.01134
+ bigbacc=0.003249          cigbacc=0.1416            nigbacc=4.05
+ aigbinv=0.35              bigbinv=0.03              cigbinv=0.006
+ eigbinv=1.1               nigbinv=1                 aigc=0.0103
+ bigc=0.001525             cigc=0                    aigsd=0.00845
+ bigsd=0.0004021           cigsd=0.001463            nigc=1
+ poxedge=1                 pigcd=2.3                 ntox=ntoxn
+ xrcrg1=12                 xrcrg2=1                  cgso=cgon
+ cgdo=cgon                 cgbo=0                    cgdl=cgln
+ cgsl=cgln                 clc=1e-007                cle=0.6
+ cf=cfn                    ckappas=0.6               acde=1.2
+ moin=12.6                 noff=1.686                voffcv=-0.05472
+ kt1=-0.20699116           lkt1=-1.1044067e-008      wkt1=1.6993129e-024
+ pkt1=-1.6925157e-029      kt1l=0                    kt2=-0.04464
+ ute=-1.7392               lute=9.1632e-008          wute=-1.3594503e-023
+ pute=1.3540125e-028       ua1=2.684e-009            ub1=-3.673e-018
+ uc1=-6.421e-011           prt=0                     at=45000
+ jss=1.77e-07              jsws=4.23e-13             jswgs=9e-12
+ njs=1                     ijthsfwd=0.01             ijthsrev=0.01
+ bvs=10                    xjbvs=1                   pbs=0.5
+ cjs=cjn                   mjs=0.25                  pbsws=0.8
+ cjsws=cjswn               mjsws=0.01                pbswgs=0.78
+ cjswgs=cjswgn             mjswgs=0.52               tpb=1.00e-03
+ tcj=7.32e-04              tpbsw=1.90e-03            tcjsw=3.57e-04
+ tpbswg=1.90e-03           tcjswg=3.57e-04           xtis=3
+ dmcg=9.25e-008            dmci=9.25e-008            dmdg=0
+ dmcgt=0                   dwj=0                     xgw=0
+ xgl=0                     rshg=0.1                  gbmin=1e-012
+ rbpb=50                   rbpd=50                   rbps=50
+ rbdb=50                   rbsb=50                   ngcon=1
+ saref=0.63e-6             sbref=0.63e-6             kvsat=0.20
+ wlod=0.8e-6               tku0=0.01                 ku0=-7.36e-8
+ llodku0=1                 wlodku0=1                 lku0=4.027e-7
+ wku0=8e-7                 pku0=-2.0e-13             kvth0=3.5e-9
+ stk2=1.35e-9              steta0=0                  lkvth0=-2.68e-11
+ wkvth0=1.5e-6             pkvth0=0                  llodvth=1
+ wlodvth=1                 lodk2=0.5                 lodeta0=1
+ fnoimod=1                 noia=4.2926e+41           noib=1.612e+24
+ noic=8.75                 em=1.192e+07              ef=0.8841
+ wpemod=wpeflag            kvth0we=0.00323           lkvth0we=0
+ wkvth0we=0                pkvth0we=0                ku0we=-0.003
+ lku0we=4.00e-10           wku0we=0                  pku0we=0
+ k2we=0.0016               wk2we=0                   web=-210
+ wec=-3500                 scref=1.00e-06            ud=0
+ tnoimod=0                 minr=1e-3

     3: type=n
+ lmin=2.4000e-07-dxln      lmax=5.0000e-07-dxln      wmin=1.0000e-05-dxwn
+ wmax=9.001e-04            version=4.5               binunit=2
+ paramchk=1                mobmod=0                  capmod=2
+ igcmod=1                  igbmod=1                  diomod=1
+ rdsmod=0                  rbodymod=0                rgatemod=0
+ permod=1                  acnqsmod=0                trnqsmod=0
+ tnom=25                   toxe=toxn                 toxm=toxn
+ dtox=3e-010               epsrox=3.9                wint=6e-009
+ lint=2.5e-009             ll=0                      wl=0
+ lln=1                     wln=1                     lw=0
+ ww=0                      lwn=1                     wwn=1
+ lwl=0                     wwl=0                     llc=0
+ wlc=0                     lwc=0                     wwc=0
+ lwlc=0                    wwlc=0                    dlc=1.172e-008
+ dwc=0                     xpart=1                   toxref=3e-009
+ dlcig=2.5e-009            xl=-3.5e-08+dxln          xw=1.5e-8+dxwn
+ vth0=0.228+dvthn          wvth0=0+dwvthn            lvth0=0+dlvthn
+ pvth0=0+dpvthn            k1=0.3231                 k2=0.0056153846+dk2n
+ lk2=-2.1230769e-009       k3=-2.5615385             lk3=-6.3692308e-008
+ k3b=1.2                   w0=-5e-008                dvt0=13.9
+ dvt1=1.25                 dvt2=0                    dvt0w=0
+ dvt1w=0                   dvt2w=0                   dsub=0.5
+ minv=0                    voffl=0                   dvtp0=4e-007
+ dvtp1=2                   lpe0=4.45e-008            lpeb=0
+ xj=1.5e-007               ngate=4e020               ndep=8.3687e017
+ nsd=1e020                 phin=0                    cdsc=0
+ cdscb=0                   cdscd=0                   cit=-0.00076923077
+ lcit=3.5384615e-010       voff=-0.087976923         lvoff=-8.2446154e-009
+ nfactor=0.5               pvoff=0+dpvoffn           eta0=0.22
+ etab=-0.1                 u0=0.037072308            peta0=0+dpeta0n
+ lu0=9.6953846e-010        ua=-6.284e-010            ub=1.6767692e-018
+ lub=9.6246154e-026        uc=1.4401538e-010         luc=1.6736923e-017
+ vsat=114000               a0=2.375                  ags=1.3923077
+ pvsat=0+dpvsatn           lags=-8.8461538e-008      a1=0
+ a2=1                      b0=0                      b1=0
+ keta=-0.058846154         lketa=6.3692308e-009      dwg=0
+ dwb=0                     pclm=0.84                 pdiblc1=0
+ pdiblc2=0.0001            pdiblcb=0                 drout=0
+ pvag=1.5                  delta=0.0075              pscbe1=9.264e008
+ pscbe2=1e-020             fprout=200                pdits=0
+ pditsd=0                  pditsl=0                  rsh=10.5
+ rdsw=140                  prwg=0                    prwb=0
+ wr=1                      alpha0=0                  alpha1=0.03
+ beta0=8.7                 agidl=9e-008              bgidl=2.3e009
+ cgidl=0.5                 egidl=0.53                aigbacc=0.01134
+ bigbacc=0.003249          cigbacc=0.1416            nigbacc=4.05
+ aigbinv=0.35              bigbinv=0.03              cigbinv=0.006
+ eigbinv=1.1               nigbinv=1                 aigc=0.0103
+ bigc=0.001525             cigc=0                    aigsd=0.0084494818
+ laigsd=2.3835574e-013     waigsd=4.6686012e-010     paigsd=-2.1475566e-016
+ bigsd=0.0004021           cigsd=0.001463            nigc=1
+ poxedge=1                 pigcd=2.3                 ntox=ntoxn
+ xrcrg1=12                 xrcrg2=1                  cgso=cgon
+ cgdo=cgon                 cgbo=0                    cgdl=cgln
+ cgsl=cgln                 clc=1e-007                cle=0.6
+ cf=cfn                    ckappas=0.6               acde=1.2
+ moin=12.6                 noff=1.686                voffcv=-0.05472
+ kt1=-0.20061538           lkt1=-1.3976923e-008      kt1l=0
+ kt2=-0.04464              ute=-1.58                 lute=1.84e-008
+ ua1=2.684e-009            ub1=-3.673e-018           uc1=-6.421e-011
+ prt=0                     at=45000                  jss=1.77e-07
+ jsws=4.23e-13             jswgs=9e-12               njs=1
+ ijthsfwd=0.01             ijthsrev=0.01             bvs=10
+ xjbvs=1                   pbs=0.5                   cjs=cjn
+ mjs=0.25                  pbsws=0.8                 cjsws=cjswn
+ mjsws=0.01                pbswgs=0.78               cjswgs=cjswgn
+ mjswgs=0.52               tpb=1.00e-03              tcj=7.32e-04
+ tpbsw=1.90e-03            tcjsw=3.57e-04            tpbswg=1.90e-03
+ tcjswg=3.57e-04           xtis=3                    dmcg=9.25e-008
+ dmci=9.25e-008            dmdg=0                    dmcgt=0
+ dwj=0                     xgw=0                     xgl=0
+ rshg=0.1                  gbmin=1e-012              rbpb=50
+ rbpd=50                   rbps=50                   rbdb=50
+ rbsb=50                   ngcon=1                   saref=0.63e-6
+ sbref=0.63e-6             kvsat=0.20                wlod=0.8e-6
+ tku0=0.01                 ku0=-7.36e-8              llodku0=1
+ wlodku0=1                 lku0=4.027e-7             wku0=8e-7
+ pku0=-2.0e-13             kvth0=3.5e-9              stk2=1.35e-9
+ steta0=0                  lkvth0=-2.68e-11          wkvth0=1.5e-6
+ pkvth0=0                  llodvth=1                 wlodvth=1
+ lodk2=0.5                 lodeta0=1                 fnoimod=1
+ noia=4.2926e+41           noib=1.612e+24            noic=8.75
+ em=1.192e+07              ef=0.8841                 wpemod=wpeflag
+ kvth0we=0.00323           lkvth0we=0                wkvth0we=0
+ pkvth0we=0                ku0we=-0.003              lku0we=4.00e-10
+ wku0we=0                  pku0we=0                  k2we=0.0016
+ wk2we=0                   web=-210                  wec=-3500
+ scref=1.00e-06            ud=0                      tnoimod=0
+ minr=1e-3

     4: type=n
+ lmin=1.0e-07              lmax=2.4000e-07-dxln      wmin=1.0000e-05-dxwn
+ wmax=9.001e-04            version=4.5               binunit=2
+ paramchk=1                mobmod=0                  capmod=2
+ igcmod=1                  igbmod=1                  diomod=1
+ rdsmod=0                  rbodymod=0                rgatemod=0
+ permod=1                  acnqsmod=0                trnqsmod=0
+ tnom=25                   toxe=toxn                 toxm=toxn
+ dtox=3e-010               epsrox=3.9                wint=6e-009
+ lint=2.5e-009             ll=0                      wl=0
+ lln=1                     wln=1                     lw=0
+ ww=0                      lwn=1                     wwn=1
+ lwl=0                     wwl=0                     llc=0
+ wlc=0                     lwc=0                     wwc=0
+ lwlc=0                    wwlc=0                    dlc=1.172e-008
+ dwc=0                     xpart=1                   toxref=3e-009
+ dlcig=2.5e-009            xl=-3.5e-08+dxln          xw=1.5e-8+dxwn
+ vth0=0.228+dvthn          wvth0=0+dwvthn            lvth0=0+dlvthn
+ pvth0=0+dpvthn            k1=0.3231                 k2=-0.010669143+dk2n
+ lk2=1.1338286e-009        k3=-2.9571429             lk3=1.5428571e-008
+ k3b=1.2                   w0=-5e-008                dvt0=13.9
+ dvt1=1.25                 dvt2=0                    dvt0w=0
+ dvt1w=0                   dvt2w=0                   dsub=0.5
+ minv=0                    voffl=0                   dvtp0=4e-007
+ dvtp1=1.5714286           ldvtp1=8.5714286e-008     lpe0=4.45e-008
+ lpeb=0                    xj=1.5e-007               ngate=4e020
+ ndep=8.3687e017           nsd=1e020                 phin=0
+ cdsc=0                    cdscb=0                   cdscd=0
+ cit=-0.00012285714        lcit=2.2457143e-010       voff=-0.1175
+ lvoff=-2.34e-009          pvoff=0+dpvoffn           nfactor=0.5
+ eta0=0.22                 etab=-0.1                 peta0=0+dpeta0n
+ u0=0.044234286            lu0=-4.6285714e-010       ua=-6.284e-010
+ ub=2.1828571e-018         lub=-4.9714286e-027       uc=2.277e-010
+ vsat=114000               a0=2.375                  ags=0.95
+ pvsat=0+dpvsatn           a1=0                      a2=1
+ b0=0                      b1=0                      keta=-0.044142857
+ lketa=3.4285714e-009      dwg=0                     dwb=0
+ pclm=0.84                 pdiblc1=0                 pdiblc2=1.4285714e-005
+ lpdiblc2=1.7142857e-011   pdiblcb=0                 drout=0
+ pvag=1.5                  delta=0.0075              pscbe1=9.264e008
+ pscbe2=1e-020             fprout=200                pdits=0
+ pditsd=0                  pditsl=0                  rsh=10.5
+ rdsw=140                  prwg=0                    prwb=0
+ wr=1                      alpha0=0                  alpha1=0.03
+ beta0=8.7                 agidl=9e-008              bgidl=2.3e009
+ cgidl=0.5                 egidl=0.53                aigbacc=0.01134
+ bigbacc=0.003249          cigbacc=0.1416            nigbacc=4.05
+ aigbinv=0.35              bigbinv=0.03              cigbinv=0.006
+ eigbinv=1.1               nigbinv=1                 aigc=0.010347143
+ laigc=-9.4285714e-012     bigc=0.001525             cigc=0
+ aigsd=0.0084509623        laigsd=-5.7738346e-014    waigsd=-8.6702594e-010
+ paigsd=5.2021557e-017     bigsd=0.0004021           cigsd=0.001463
+ nigc=1                    poxedge=1                 pigcd=2.3
+ ntox=ntoxn                xrcrg1=12                 xrcrg2=1
+ cgso=cgon                 cgdo=cgon                 cgbo=0
+ cgdl=cgln                 cgsl=cgln                 clc=1e-007
+ cle=0.6                   cf=cfn                    ckappas=0.6
+ acde=1.2                  moin=12.6                 noff=1.686
+ voffcv=-0.05472           kt1=-0.2624               lkt1=-1.62e-009
+ kt1l=0                    kt2=-0.04464              ute=-1.5428571
+ lute=1.0971429e-008       ua1=2.684e-009            ub1=-3.673e-018
+ uc1=-6.421e-011           prt=0                     at=35357.143
+ lat=0.0019285714          jss=1.77e-07              jsws=4.23e-13
+ jswgs=9e-12               njs=1                     ijthsfwd=0.01
+ ijthsrev=0.01             bvs=10                    xjbvs=1
+ pbs=0.5                   cjs=cjn                   mjs=0.25
+ pbsws=0.8                 cjsws=cjswn               mjsws=0.01
+ pbswgs=0.78               cjswgs=cjswgn             mjswgs=0.52
+ tpb=1.00e-03              tcj=7.32e-04              tpbsw=1.90e-03
+ tcjsw=3.57e-04            tpbswg=1.90e-03           tcjswg=3.57e-04
+ xtis=3                    dmcg=9.25e-008            dmci=9.25e-008
+ dmdg=0                    dmcgt=0                   dwj=0
+ xgw=0                     xgl=0                     rshg=0.1
+ gbmin=1e-012              rbpb=50                   rbpd=50
+ rbps=50                   rbdb=50                   rbsb=50
+ ngcon=1                   saref=0.63e-6             sbref=0.63e-6
+ kvsat=0.20                wlod=0.8e-6               tku0=0.01
+ ku0=-7.36e-8              llodku0=1                 wlodku0=1
+ lku0=4.027e-7             wku0=8e-7                 pku0=-2.0e-13
+ kvth0=3.5e-9              stk2=1.35e-9              steta0=0
+ lkvth0=-2.68e-11          wkvth0=1.5e-6             pkvth0=0
+ llodvth=1                 wlodvth=1                 lodk2=0.5
+ lodeta0=1                 fnoimod=1                 noia=4.2926e+41
+ noib=1.612e+24            noic=8.75                 em=1.192e+07
+ ef=0.8841                 wpemod=wpeflag            kvth0we=0.00323
+ lkvth0we=0                wkvth0we=0                pkvth0we=0
+ ku0we=-0.003              lku0we=4.00e-10           wku0we=0
+ pku0we=0                  k2we=0.0016               wk2we=0
+ web=-210                  wec=-3500                 scref=1.00e-06
+ ud=0                      tnoimod=0                 minr=1e-3

     5: type=n
+ lmin=1.0000e-05-dxln      lmax=2.001e-05            wmin=1.0000e-06-dxwn
+ wmax=1.0000e-05-dxwn      version=4.5               binunit=2
+ paramchk=1                mobmod=0                  capmod=2
+ igcmod=1                  igbmod=1                  diomod=1
+ rdsmod=0                  rbodymod=0                rgatemod=0
+ permod=1                  acnqsmod=0                trnqsmod=0
+ tnom=25                   toxe=toxn                 toxm=toxn
+ dtox=3e-010               epsrox=3.9                wint=6e-009
+ lint=2.5e-009             ll=0                      wl=0
+ lln=1                     wln=1                     lw=0
+ ww=0                      lwn=1                     wwn=1
+ lwl=0                     wwl=0                     llc=0
+ wlc=0                     lwc=0                     wwc=0
+ lwlc=0                    wwlc=0                    dlc=1.172e-008
+ dwc=0                     xpart=1                   toxref=3e-009
+ dlcig=2.5e-009            xl=-3.5e-08+dxln          xw=1.5e-8+dxwn
+ vth0=0.22744278+dvthn     wvth0=5.5738939e-009+dwvthn
+ lvth0=0+dlvthn            pvth0=0+dpvthn            k1=0.3231
+ k2=0.008228+dk2n          k3=-2.7                   k3b=1.2
+ w0=-5e-008                dvt0=13.9                 dvt1=1.25
+ dvt2=0                    dvt0w=0                   dvt1w=0
+ dvt2w=0                   dsub=0.5                  minv=0
+ voffl=0                   dvtp0=4e-007              dvtp1=2
+ lpe0=4.45e-008            lpeb=0                    xj=1.5e-007
+ ngate=4e020               ndep=8.3687e017           nsd=1e020
+ phin=0                    cdsc=0                    cdscb=0
+ cdscd=0                   cit=0                     voff=-0.1059
+ pvoff=0+dpvoffn           nfactor=0.5               eta0=0.22133733
+ weta0=-1.3377345e-008     peta0=0+dpeta0n           etab=-0.1
+ u0=0.039846438            wu0=-6.6663771e-009       ua=-6.284e-010
+ ub=2.1867527e-018         wub=-2.8761292e-025       uc=2.315114e-010
+ wuc=-3.8125434e-017       vsat=114000               pvsat=0+dpvsatn
+ a0=2.375                  ags=0.95                  a1=0
+ a2=1                      b0=0                      b1=0
+ keta=-0.045               dwg=0                     dwb=0
+ pclm=0.84                 pdiblc1=0                 pdiblc2=0.0001
+ pdiblcb=0                 drout=0                   pvag=1.5
+ delta=0.0075              pscbe1=9.264e008          pscbe2=1e-020
+ fprout=200                pdits=0                   pditsd=0
+ pditsl=0                  rsh=10.5                  rdsw=140
+ prwg=0                    prwb=0                    wr=1
+ alpha0=0                  alpha1=0.03               beta0=8.7
+ agidl=9e-008              bgidl=2.3e009             cgidl=0.5
+ egidl=0.53                aigbacc=0.01134           bigbacc=0.003249
+ cigbacc=0.1416            nigbacc=4.05              aigbinv=0.35
+ bigbinv=0.03              cigbinv=0.006             eigbinv=1.1
+ nigbinv=1                 aigc=0.0103               bigc=0.001525
+ cigc=0                    aigsd=0.00845             bigsd=0.0004021
+ cigsd=0.001463            nigc=1                    poxedge=1
+ pigcd=2.3                 ntox=ntoxn                xrcrg1=12
+ xrcrg2=1                  cgso=cgon                 cgdo=cgon
+ cgbo=0                    cgdl=cgln                 cgsl=cgln
+ clc=1e-007                cle=0.6                   cf=cfn
+ ckappas=0.6               acde=1.2                  moin=12.6
+ noff=1.686                voffcv=-0.05472           kt1=-0.2081
+ kt1l=0                    kt2=-0.04464              ute=-1.7473853
+ wute=1.7390549e-007       ua1=2.684e-009            ub1=-3.673e-018
+ uc1=-6.421e-011           prt=0                     at=45000
+ jss=1.77e-07              jsws=4.23e-13             jswgs=9e-12
+ njs=1                     ijthsfwd=0.01             ijthsrev=0.01
+ bvs=10                    xjbvs=1                   pbs=0.5
+ cjs=cjn                   mjs=0.25                  pbsws=0.8
+ cjsws=cjswn               mjsws=0.01                pbswgs=0.78
+ cjswgs=cjswgn             mjswgs=0.52               tpb=1.00e-03
+ tcj=7.32e-04              tpbsw=1.90e-03            tcjsw=3.57e-04
+ tpbswg=1.90e-03           tcjswg=3.57e-04           xtis=3
+ dmcg=9.25e-008            dmci=9.25e-008            dmdg=0
+ dmcgt=0                   dwj=0                     xgw=0
+ xgl=0                     rshg=0.1                  gbmin=1e-012
+ rbpb=50                   rbpd=50                   rbps=50
+ rbdb=50                   rbsb=50                   ngcon=1
+ saref=0.63e-6             sbref=0.63e-6             kvsat=0.20
+ wlod=0.8e-6               tku0=0.01                 ku0=-7.36e-8
+ llodku0=1                 wlodku0=1                 lku0=4.027e-7
+ wku0=8e-7                 pku0=-2.0e-13             kvth0=3.5e-9
+ stk2=1.35e-9              steta0=0                  lkvth0=-2.68e-11
+ wkvth0=1.5e-6             pkvth0=0                  llodvth=1
+ wlodvth=1                 lodk2=0.5                 lodeta0=1
+ fnoimod=1                 noia=4.2926e+41           noib=1.612e+24
+ noic=8.75                 em=1.192e+07              ef=0.8841
+ wpemod=wpeflag            kvth0we=0.00323           lkvth0we=0
+ wkvth0we=0                pkvth0we=0                ku0we=-0.003
+ lku0we=4.00e-10           wku0we=0                  pku0we=0
+ k2we=0.0016               wk2we=0                   web=-210
+ wec=-3500                 scref=1.00e-06            ud=0
+ tnoimod=0                 minr=1e-3

     6: type=n
+ lmin=5.0000e-07-dxln      lmax=1.0000e-05-dxln      wmin=1.0000e-06-dxwn
+ wmax=1.0000e-05-dxwn      version=4.5               binunit=2
+ paramchk=1                mobmod=0                  capmod=2
+ igcmod=1                  igbmod=1                  diomod=1
+ rdsmod=0                  rbodymod=0                rgatemod=0
+ permod=1                  acnqsmod=0                trnqsmod=0
+ tnom=25                   toxe=toxn                 toxm=toxn
+ dtox=3e-010               epsrox=3.9                wint=6e-009
+ lint=2.5e-009             ll=0                      wl=0
+ lln=1                     wln=1                     lw=0
+ ww=0                      lwn=1                     wwn=1
+ lwl=0                     wwl=0                     llc=0
+ wlc=0                     lwc=0                     wwc=0
+ lwlc=0                    wwlc=0                    dlc=1.172e-008
+ dwc=0                     xpart=1                   toxref=3e-009
+ dlcig=2.5e-009            xl=-3.5e-08+dxln          xw=1.5e-8+dxwn
+ vth0=0.22744278+dvthn     wvth0=5.5738939e-009+dwvthn
+ lvth0=0+dlvthn            pvth0=0+dpvthn            k1=0.3231
+ k2=0.0085779874+dk2n      lk2=-3.4858742e-009       wk2=4.6819113e-026
+ pk2=-4.6631836e-031       k3=-2.7                   k3b=1.2
+ w0=-5e-008                dvt0=13.9                 dvt1=1.25
+ dvt2=0                    dvt0w=0                   dvt1w=0
+ dvt2w=0                   dsub=0.5                  minv=0
+ voffl=0                   dvtp0=4e-007              dvtp1=2
+ lpe0=4.45e-008            lpeb=0                    xj=1.5e-007
+ ngate=4e020               ndep=8.3687e017           nsd=1e020
+ phin=0                    cdsc=0                    cdscb=0
+ cdscd=0                   cit=0                     voff=-0.10596853
+ lvoff=6.8258338e-010      wvoff=6.8553028e-010      pvoff=-6.8278815e-015+dpvoffn
+ nfactor=0.5               eta0=0.22133733           weta0=-1.3377345e-008
+ peta0=0+dpeta0n           etab=-0.1                 u0=0.039846438
+ wu0=-6.6663771e-009       ua=-6.284e-010            ub=2.199281e-018
+ lub=-1.2478258e-025       wub=-2.8118945e-025       pub=-6.3977788e-032
+ uc=2.3374775e-010         luc=-2.2274078e-017       wuc=-3.7585647e-017
+ puc=-5.3762847e-024       vsat=114000               a0=2.375
+ ags=0.93789474            pvsat=0+dpvsatn           lags=1.2056842e-007
+ wags=-1.4982116e-024      pags=1.4922188e-029       a1=0
+ a2=1                      b0=0                      b1=0
+ keta=-0.045               dwg=0                     dwb=0
+ pclm=0.84                 pdiblc1=0                 pdiblc2=0.0001
+ pdiblcb=0                 drout=0                   pvag=1.5
+ delta=0.0075              pscbe1=9.264e008          pscbe2=1e-020
+ fprout=200                pdits=0                   pditsd=0
+ pditsl=0                  rsh=10.5                  rdsw=140
+ prwg=0                    prwb=0                    wr=1
+ alpha0=0                  alpha1=0.03               beta0=8.7
+ agidl=9e-008              bgidl=2.3e009             cgidl=0.5
+ egidl=0.53                aigbacc=0.01134           bigbacc=0.003249
+ cigbacc=0.1416            nigbacc=4.05              aigbinv=0.35
+ bigbinv=0.03              cigbinv=0.006             eigbinv=1.1
+ nigbinv=1                 aigc=0.0103               bigc=0.001525
+ cigc=0                    aigsd=0.00845             bigsd=0.0004021
+ cigsd=0.001463            nigc=1                    poxedge=1
+ pigcd=2.3                 ntox=ntoxn                xrcrg1=12
+ xrcrg2=1                  cgso=cgon                 cgdo=cgon
+ cgbo=0                    cgdl=cgln                 cgsl=cgln
+ clc=1e-007                cle=0.6                   cf=cfn
+ ckappas=0.6               acde=1.2                  moin=12.6
+ noff=1.686                voffcv=-0.05472           kt1=-0.20699116
+ lkt1=-1.1044067e-008      wkt1=1.8727645e-025       pkt1=-1.8652735e-030
+ kt1l=0                    kt2=-0.04464              ute=-1.7568444
+ lute=9.4211843e-008       wute=1.7649647e-007       pute=-2.5806166e-014
+ ua1=2.684e-009            ub1=-3.673e-018           uc1=-6.421e-011
+ prt=0                     at=45000                  jss=1.77e-07
+ jsws=4.23e-13             jswgs=9e-12               njs=1
+ ijthsfwd=0.01             ijthsrev=0.01             bvs=10
+ xjbvs=1                   pbs=0.5                   cjs=cjn
+ mjs=0.25                  pbsws=0.8                 cjsws=cjswn
+ mjsws=0.01                pbswgs=0.78               cjswgs=cjswgn
+ mjswgs=0.52               tpb=1.00e-03              tcj=7.32e-04
+ tpbsw=1.90e-03            tcjsw=3.57e-04            tpbswg=1.90e-03
+ tcjswg=3.57e-04           xtis=3                    dmcg=9.25e-008
+ dmci=9.25e-008            dmdg=0                    dmcgt=0
+ dwj=0                     xgw=0                     xgl=0
+ rshg=0.1                  gbmin=1e-012              rbpb=50
+ rbpd=50                   rbps=50                   rbdb=50
+ rbsb=50                   ngcon=1                   saref=0.63e-6
+ sbref=0.63e-6             kvsat=0.20                wlod=0.8e-6
+ tku0=0.01                 ku0=-7.36e-8              llodku0=1
+ wlodku0=1                 lku0=4.027e-7             wku0=8e-7
+ pku0=-2.0e-13             kvth0=3.5e-9              stk2=1.35e-9
+ steta0=0                  lkvth0=-2.68e-11          wkvth0=1.5e-6
+ pkvth0=0                  llodvth=1                 wlodvth=1
+ lodk2=0.5                 lodeta0=1                 fnoimod=1
+ noia=4.2926e+41           noib=1.612e+24            noic=8.75
+ em=1.192e+07              ef=0.8841                 wpemod=wpeflag
+ kvth0we=0.00323           lkvth0we=0                wkvth0we=0
+ pkvth0we=0                ku0we=-0.003              lku0we=4.00e-10
+ wku0we=0                  pku0we=0                  k2we=0.0016
+ wk2we=0                   web=-210                  wec=-3500
+ scref=1.00e-06            ud=0                      tnoimod=0
+ minr=1e-3

     7: type=n
+ lmin=2.4000e-07-dxln      lmax=5.0000e-07-dxln      wmin=1.0000e-06-dxwn
+ wmax=1.0000e-05-dxwn      version=4.5               binunit=2
+ paramchk=1                mobmod=0                  capmod=2
+ igcmod=1                  igbmod=1                  diomod=1
+ rdsmod=0                  rbodymod=0                rgatemod=0
+ permod=1                  acnqsmod=0                trnqsmod=0
+ tnom=25                   toxe=toxn                 toxm=toxn
+ dtox=3e-010               epsrox=3.9                wint=6e-009
+ lint=2.5e-009             ll=0                      wl=0
+ lln=1                     wln=1                     lw=0
+ ww=0                      lwn=1                     wwn=1
+ lwl=0                     wwl=0                     llc=0
+ wlc=0                     lwc=0                     wwc=0
+ lwlc=0                    wwlc=0                    dlc=1.172e-008
+ dwc=0                     xpart=1                   toxref=3e-009
+ dlcig=2.5e-009            xl=-3.5e-08+dxln          xw=1.5e-8+dxwn
+ vth0=0.22744278+dvthn     wvth0=5.5738939e-009+dwvthn
+ lvth0=0+dlvthn            pvth0=0+dpvthn            k1=0.3231
+ k2=0.0056153846+dk2n      lk2=-2.1230769e-009       k3=-2.5615385
+ lk3=-6.3692308e-008       k3b=1.2                   w0=-5e-008
+ dvt0=13.9                 dvt1=1.25                 dvt2=0
+ dvt0w=0                   dvt1w=0                   dvt2w=0
+ dsub=0.5                  minv=0                    voffl=0
+ dvtp0=4e-007              dvtp1=2                   lpe0=4.45e-008
+ lpeb=0                    xj=1.5e-007               ngate=4e020
+ ndep=8.3687e017           nsd=1e020                 phin=0
+ cdsc=0                    cdscb=0                   cdscd=0
+ cit=-0.00076923077        lcit=3.5384615e-010       voff=-0.086227245
+ lvoff=-8.3984087e-009     wvoff=-1.7502027e-008     pvoff=1.5383947e-015+dpvoffn
+ nfactor=0.5               eta0=0.22133733           weta0=-1.3377345e-008
+ peta0=0+dpeta0n           etab=-0.1                 u0=0.037503855
+ lu0=1.0775881e-009        wu0=-4.3167664e-009       pu0=-1.0808209e-015
+ ua=-6.284e-010            ub=1.6835502e-018         lub=1.1245361e-025
+ wub=-6.7830001e-026       pub=-1.6212314e-031       uc=1.4396909e-010
+ luc=1.9024106e-017        wuc=4.6306195e-019        puc=-2.2878691e-023
+ vsat=114000               pvsat=0+dpvsatn           a0=2.375
+ ags=1.3923077             lags=-8.8461538e-008      a1=0
+ a2=1                      b0=0                      b1=0
+ keta=-0.058846154         lketa=6.3692308e-009      dwg=0
+ dwb=0                     pclm=0.84                 pdiblc1=0
+ pdiblc2=0.0001            pdiblcb=0                 drout=0
+ pvag=1.5                  delta=0.0075              pscbe1=9.264e008
+ pscbe2=1e-020             fprout=200                pdits=0
+ pditsd=0                  pditsl=0                  rsh=10.5
+ rdsw=140                  prwg=0                    prwb=0
+ wr=1                      alpha0=0                  alpha1=0.03
+ beta0=8.7                 agidl=9e-008              bgidl=2.3e009
+ cgidl=0.5                 egidl=0.53                aigbacc=0.01134
+ bigbacc=0.003249          cigbacc=0.1416            nigbacc=4.05
+ aigbinv=0.35              bigbinv=0.03              cigbinv=0.006
+ eigbinv=1.1               nigbinv=1                 aigc=0.0103
+ bigc=0.001525             cigc=0                    aigsd=0.0085012974
+ laigsd=-2.3596821e-011    waigsd=-5.1451328e-011    paigsd=2.3667611e-017
+ bigsd=0.0004021           cigsd=0.001463            nigc=1
+ poxedge=1                 pigcd=2.3                 ntox=ntoxn
+ xrcrg1=12                 xrcrg2=1                  cgso=cgon
+ cgdo=cgon                 cgbo=0                    cgdl=cgln
+ cgsl=cgln                 clc=1e-007                cle=0.6
+ cf=cfn                    ckappas=0.6               acde=1.2
+ moin=12.6                 noff=1.686                voffcv=-0.05472
+ kt1=-0.20061538           lkt1=-1.3976923e-008      kt1l=0
+ kt2=-0.04464              ute=-1.5962366            lute=2.0332275e-008
+ wute=1.6241469e-007       pute=-1.9328549e-014      ua1=2.684e-009
+ ub1=-3.673e-018           uc1=-6.421e-011           prt=0
+ at=45000                  jss=1.77e-07              jsws=4.23e-13
+ jswgs=9e-12               njs=1                     ijthsfwd=0.01
+ ijthsrev=0.01             bvs=10                    xjbvs=1
+ pbs=0.5                   cjs=cjn                   mjs=0.25
+ pbsws=0.8                 cjsws=cjswn               mjsws=0.01
+ pbswgs=0.78               cjswgs=cjswgn             mjswgs=0.52
+ tpb=1.00e-03              tcj=7.32e-04              tpbsw=1.90e-03
+ tcjsw=3.57e-04            tpbswg=1.90e-03           tcjswg=3.57e-04
+ xtis=3                    dmcg=9.25e-008            dmci=9.25e-008
+ dmdg=0                    dmcgt=0                   dwj=0
+ xgw=0                     xgl=0                     rshg=0.1
+ gbmin=1e-012              rbpb=50                   rbpd=50
+ rbps=50                   rbdb=50                   rbsb=50
+ ngcon=1                   saref=0.63e-6             sbref=0.63e-6
+ kvsat=0.20                wlod=0.8e-6               tku0=0.01
+ ku0=-7.36e-8              llodku0=1                 wlodku0=1
+ lku0=4.027e-7             wku0=8e-7                 pku0=-2.0e-13
+ kvth0=3.5e-9              stk2=1.35e-9              steta0=0
+ lkvth0=-2.68e-11          wkvth0=1.5e-6             pkvth0=0
+ llodvth=1                 wlodvth=1                 lodk2=0.5
+ lodeta0=1                 fnoimod=1                 noia=4.2926e+41
+ noib=1.612e+24            noic=8.75                 em=1.192e+07
+ ef=0.8841                 wpemod=wpeflag            kvth0we=0.00323
+ lkvth0we=0                wkvth0we=0                pkvth0we=0
+ ku0we=-0.003              lku0we=4.00e-10           wku0we=0
+ pku0we=0                  k2we=0.0016               wk2we=0
+ web=-210                  wec=-3500                 scref=1.00e-06
+ ud=0                      tnoimod=0                 minr=1e-3

     8: type=n
+ lmin=1.0e-07              lmax=2.4000e-07-dxln      wmin=1.0000e-06-dxwn
+ wmax=1.0000e-05-dxwn      version=4.5               binunit=2
+ paramchk=1                mobmod=0                  capmod=2
+ igcmod=1                  igbmod=1                  diomod=1
+ rdsmod=0                  rbodymod=0                rgatemod=0
+ permod=1                  acnqsmod=0                trnqsmod=0
+ tnom=25                   toxe=toxn                 toxm=toxn
+ dtox=3e-010               epsrox=3.9                wint=6e-009
+ lint=2.5e-009             ll=0                      wl=0
+ lln=1                     wln=1                     lw=0
+ ww=0                      lwn=1                     wwn=1
+ lwl=0                     wwl=0                     llc=0
+ wlc=0                     lwc=0                     wwc=0
+ lwlc=0                    wwlc=0                    dlc=1.172e-008
+ dwc=0                     xpart=1                   toxref=3e-009
+ dlcig=2.5e-009            xl=-3.5e-08+dxln          xw=1.5e-8+dxwn
+ vth0=0.22744278+dvthn     wvth0=5.5738939e-009+dwvthn
+ lvth0=0+dlvthn            pvth0=0+dpvthn            k1=0.32433703
+ lk1=-2.4740667e-010       wk1=-1.2374044e-008       pk1=2.4748089e-015
+ k2=-0.011014366+dk2n      lk2=1.2028732e-009        wk2=3.4532661e-009
+ pk2=-6.9065323e-016       k3=-2.9571429             lk3=1.5428571e-008
+ k3b=1.2                   w0=-5e-008                dvt0=13.9
+ dvt1=1.25                 dvt2=0                    dvt0w=0
+ dvt1w=0                   dvt2w=0                   dsub=0.5
+ minv=0                    voffl=0                   dvtp0=4e-007
+ dvtp1=1.5714286           ldvtp1=8.5714286e-008     lpe0=4.45e-008
+ lpeb=0                    xj=1.5e-007               ngate=4e020
+ ndep=8.3687e017           nsd=1e020                 phin=0
+ cdsc=0                    cdscb=0                   cdscd=0
+ cit=-0.00012285714        lcit=2.2457143e-010       voff=-0.11586017
+ lvoff=-2.4718229e-009     wvoff=-1.6403173e-008     pvoff=1.318624e-015+dpvoffn
+ nfactor=0.5               eta0=0.22133733           weta0=-1.3377345e-008
+ peta0=0+dpeta0n           etab=-0.1                 u0=0.045463996
+ lu0=-5.1444e-010          wu0=-1.2300788e-008       pu0=5.1598332e-016
+ ua=-6.284e-010            ub=2.2915951e-018         lub=-9.1553714e-027
+ wub=-1.0877056e-024       pub=4.185198e-032         uc=2.4114338e-010
+ luc=-4.1075238e-019       wuc=-1.3447417e-016       puc=4.1087561e-024
+ vsat=114000               pvsat=0+dpvsatn           a0=2.375
+ ags=0.95                  a1=0                      a2=1
+ b0=0                      b1=0                      keta=-0.044142857
+ lketa=3.4285714e-009      dwg=0                     dwb=0
+ pclm=0.84                 pdiblc1=0                 pdiblc2=1.4285714e-005
+ lpdiblc2=1.7142857e-011   pdiblcb=0                 drout=0
+ pvag=1.5                  delta=0.0075              pscbe1=9.264e008
+ pscbe2=1e-020             fprout=200                pdits=0
+ pditsd=0                  pditsl=0                  rsh=10.5
+ rdsw=140                  prwg=0                    prwb=0
+ wr=1                      alpha0=0                  alpha1=0.03
+ beta0=8.7                 agidl=9e-008              bgidl=2.3e009
+ cgidl=0.5                 egidl=0.53                aigbacc=0.01134
+ bigbacc=0.003249          cigbacc=0.1416            nigbacc=4.05
+ aigbinv=0.35              bigbinv=0.03              cigbinv=0.006
+ eigbinv=1.1               nigbinv=1                 aigc=0.010347143
+ laigc=-9.4285714e-012     bigc=0.001525             cigc=0
+ aigsd=0.0083547333        laigsd=5.716e-012         waigsd=9.5552467e-011
+ paigsd=-5.733148e-018     bigsd=0.0004021           cigsd=0.001463
+ nigc=1                    poxedge=1                 pigcd=2.3
+ ntox=ntoxn                xrcrg1=12                 xrcrg2=1
+ cgso=cgon                 cgdo=cgon                 cgbo=0
+ cgdl=cgln                 cgsl=cgln                 clc=1e-007
+ cle=0.6                   cf=cfn                    ckappas=0.6
+ acde=1.2                  moin=12.6                 noff=1.686
+ voffcv=-0.05472           kt1=-0.2624               lkt1=-1.62e-009
+ kt1l=0                    kt2=-0.04464              ute=-1.5502921
+ lute=1.1143371e-008       wute=7.437167e-008        pute=-1.7199444e-015
+ ua1=2.684e-009            ub1=-3.673e-018           uc1=-6.421e-011
+ prt=0                     at=35357.143              lat=0.0019285714
+ jss=1.77e-07              jsws=4.23e-13             jswgs=9e-12
+ njs=1                     ijthsfwd=0.01             ijthsrev=0.01
+ bvs=10                    xjbvs=1                   pbs=0.5
+ cjs=cjn                   mjs=0.25                  pbsws=0.8
+ cjsws=cjswn               mjsws=0.01                pbswgs=0.78
+ cjswgs=cjswgn             mjswgs=0.52               tpb=1.00e-03
+ tcj=7.32e-04              tpbsw=1.90e-03            tcjsw=3.57e-04
+ tpbswg=1.90e-03           tcjswg=3.57e-04           xtis=3
+ dmcg=9.25e-008            dmci=9.25e-008            dmdg=0
+ dmcgt=0                   dwj=0                     xgw=0
+ xgl=0                     rshg=0.1                  gbmin=1e-012
+ rbpb=50                   rbpd=50                   rbps=50
+ rbdb=50                   rbsb=50                   ngcon=1
+ saref=0.63e-6             sbref=0.63e-6             kvsat=0.20
+ wlod=0.8e-6               tku0=0.01                 ku0=-7.36e-8
+ llodku0=1                 wlodku0=1                 lku0=4.027e-7
+ wku0=8e-7                 pku0=-2.0e-13             kvth0=3.5e-9
+ stk2=1.35e-9              steta0=0                  lkvth0=-2.68e-11
+ wkvth0=1.5e-6             pkvth0=0                  llodvth=1
+ wlodvth=1                 lodk2=0.5                 lodeta0=1
+ fnoimod=1                 noia=4.2926e+41           noib=1.612e+24
+ noic=8.75                 em=1.192e+07              ef=0.8841
+ wpemod=wpeflag            kvth0we=0.00323           lkvth0we=0
+ wkvth0we=0                pkvth0we=0                ku0we=-0.003
+ lku0we=4.00e-10           wku0we=0                  pku0we=0
+ k2we=0.0016               wk2we=0                   web=-210
+ wec=-3500                 scref=1.00e-06            ud=0
+ tnoimod=0                 minr=1e-3

     9: type=n
+ lmin=1.0000e-05-dxln      lmax=2.001e-05            wmin=5.0000e-07-dxwn
+ wmax=1.0000e-06-dxwn      version=4.5               binunit=2
+ paramchk=1                mobmod=0                  capmod=2
+ igcmod=1                  igbmod=1                  diomod=1
+ rdsmod=0                  rbodymod=0                rgatemod=0
+ permod=1                  acnqsmod=0                trnqsmod=0
+ tnom=25                   toxe=toxn                 toxm=toxn
+ dtox=3e-010               epsrox=3.9                wint=6e-009
+ lint=2.5e-009             ll=0                      wl=0
+ lln=1                     wln=1                     lw=0
+ ww=0                      lwn=1                     wwn=1
+ lwl=0                     wwl=0                     llc=0
+ wlc=0                     lwc=0                     wwc=0
+ lwlc=0                    wwlc=0                    dlc=1.172e-008
+ dwc=0                     xpart=1                   toxref=3e-009
+ dlcig=2.5e-009            xl=-3.5e-08+dxln          xw=1.5e-8+dxwn
+ vth0=0.23803+dvthn        wvth0=-5.04509e-009+dwvthn
+ lvth0=0+dlvthn            pvth0=0+dpvthn            k1=0.3231
+ k2=0.008228+dk2n          k3=-2.7                   k3b=1.2
+ w0=-5e-008                dvt0=13.9                 dvt1=1.25
+ dvt2=0                    dvt0w=0                   dvt1w=0
+ dvt2w=0                   dsub=0.5                  minv=0
+ voffl=0                   dvtp0=4e-007              dvtp1=2
+ lpe0=4.45e-008            lpeb=0                    xj=1.5e-007
+ ngate=4e020               ndep=8.3687e017           nsd=1e020
+ phin=0                    cdsc=0                    cdscb=0
+ cdscd=0                   cit=0                     voff=-0.0997634
+ pvoff=0+dpvoffn           wvoff=-6.1550098e-009     nfactor=0.5
+ eta0=0.227114             peta0=0+dpeta0n           weta0=-1.9171342e-008
+ etab=-0.1                 u0=0.0376264              wu0=-4.4396792e-009
+ ua=-6.284e-010            ub=2.168602e-018          wub=-2.6940781e-025
+ uc=2.368586e-010          wuc=-4.3488676e-017       vsat=114000
+ a0=2.375                  ags=0.95                  pvsat=0+dpvsatn
+ a1=0                      a2=1                      b0=0
+ b1=0                      keta=-0.045               dwg=0
+ dwb=0                     pclm=0.84                 pdiblc1=0
+ pdiblc2=0.0001            pdiblcb=0                 drout=0
+ pvag=1.5                  delta=0.0075              pscbe1=9.264e008
+ pscbe2=1e-020             fprout=200                pdits=0
+ pditsd=0                  pditsl=0                  rsh=10.5
+ rdsw=140                  prwg=0                    prwb=0
+ wr=1                      alpha0=0                  alpha1=0.03
+ beta0=8.7                 agidl=9e-008              bgidl=2.3e009
+ cgidl=0.5                 egidl=0.53                aigbacc=0.01134
+ bigbacc=0.003249          cigbacc=0.1416            nigbacc=4.05
+ aigbinv=0.35              bigbinv=0.03              cigbinv=0.006
+ eigbinv=1.1               nigbinv=1                 aigc=0.0103
+ bigc=0.001525             cigc=0                    aigsd=0.00845
+ bigsd=0.0004021           cigsd=0.001463            nigc=1
+ poxedge=1                 pigcd=2.3                 ntox=ntoxn
+ xrcrg1=12                 xrcrg2=1                  cgso=cgon
+ cgdo=cgon                 cgbo=0                    cgdl=cgln
+ cgsl=cgln                 clc=1e-007                cle=0.6
+ cf=cfn                    ckappas=0.6               acde=1.2
+ moin=12.6                 noff=1.686                voffcv=-0.05472
+ kt1=-0.2081               kt1l=0                    kt2=-0.04464
+ ute=-1.68466              wute=1.1099198e-007       ua1=2.684e-009
+ ub1=-3.673e-018           uc1=-6.421e-011           prt=0
+ at=45000                  jss=1.77e-07              jsws=4.23e-13
+ jswgs=9e-12               njs=1                     ijthsfwd=0.01
+ ijthsrev=0.01             bvs=10                    xjbvs=1
+ pbs=0.5                   cjs=cjn                   mjs=0.25
+ pbsws=0.8                 cjsws=cjswn               mjsws=0.01
+ pbswgs=0.78               cjswgs=cjswgn             mjswgs=0.52
+ tpb=1.00e-03              tcj=7.32e-04              tpbsw=1.90e-03
+ tcjsw=3.57e-04            tpbswg=1.90e-03           tcjswg=3.57e-04
+ xtis=3                    dmcg=9.25e-008            dmci=9.25e-008
+ dmdg=0                    dmcgt=0                   dwj=0
+ xgw=0                     xgl=0                     rshg=0.1
+ gbmin=1e-012              rbpb=50                   rbpd=50
+ rbps=50                   rbdb=50                   rbsb=50
+ ngcon=1                   saref=0.63e-6             sbref=0.63e-6
+ kvsat=0.20                wlod=0.8e-6               tku0=0.01
+ ku0=-7.36e-8              llodku0=1                 wlodku0=1
+ lku0=4.027e-7             wku0=8e-7                 pku0=-2.0e-13
+ kvth0=3.5e-9              stk2=1.35e-9              steta0=0
+ lkvth0=-2.68e-11          wkvth0=1.5e-6             pkvth0=0
+ llodvth=1                 wlodvth=1                 lodk2=0.5
+ lodeta0=1                 fnoimod=1                 noia=4.2926e+41
+ noib=1.612e+24            noic=8.75                 em=1.192e+07
+ ef=0.8841                 wpemod=wpeflag            kvth0we=0.00323
+ lkvth0we=0                wkvth0we=0                pkvth0we=0
+ ku0we=-0.003              lku0we=4.00e-10           wku0we=0
+ pku0we=0                  k2we=0.0016               wk2we=0
+ web=-210                  wec=-3500                 scref=1.00e-06
+ ud=0                      tnoimod=0                 minr=1e-3

     10: type=n
+ lmin=5.0000e-07-dxln      lmax=1.0000e-05-dxln      wmin=5.0000e-07-dxwn
+ wmax=1.0000e-06-dxwn      version=4.5               binunit=2
+ paramchk=1                mobmod=0                  capmod=2
+ igcmod=1                  igbmod=1                  diomod=1
+ rdsmod=0                  rbodymod=0                rgatemod=0
+ permod=1                  acnqsmod=0                trnqsmod=0
+ tnom=25                   toxe=toxn                 toxm=toxn
+ dtox=3e-010               epsrox=3.9                wint=6e-009
+ lint=2.5e-009             ll=0                      wl=0
+ lln=1                     wln=1                     lw=0
+ ww=0                      lwn=1                     wwn=1
+ lwl=0                     wwl=0                     llc=0
+ wlc=0                     lwc=0                     wwc=0
+ lwlc=0                    wwlc=0                    dlc=1.172e-008
+ dwc=0                     xpart=1                   toxref=3e-009
+ dlcig=2.5e-009            xl=-3.5e-08+dxln          xw=1.5e-8+dxwn
+ vth0=0.23803+dvthn        wvth0=-5.04509e-009+dwvthn
+ lvth0=0+dlvthn            pvth0=0+dpvthn            k1=0.3231
+ k2=0.0085779874+dk2n      lk2=-3.4858742e-009       wk2=4.2377311e-026
+ pk2=-4.2207802e-031       k3=-2.7                   k3b=1.2
+ w0=-5e-008                dvt0=13.9                 dvt1=1.25
+ dvt2=0                    dvt0w=0                   dvt1w=0
+ dvt2w=0                   dsub=0.5                  minv=0
+ voffl=0                   dvtp0=4e-007              dvtp1=2
+ lpe0=4.45e-008            lpeb=0                    xj=1.5e-007
+ ngate=4e020               ndep=8.3687e017           nsd=1e020
+ phin=0                    cdsc=0                    cdscb=0
+ cdscd=0                   cit=0                     voff=-0.099294587
+ lvoff=-4.6693738e-009     wvoff=-6.0084367e-009     pvoff=-1.4598685e-015+dpvoffn
+ nfactor=0.5               eta0=0.227114             weta0=-1.9171342e-008
+ peta0=0+dpeta0n           etab=-0.1                 u0=0.0376264
+ wu0=-4.4396792e-009       ua=-6.284e-010            ub=2.1852939e-018
+ lub=-1.6625131e-025       wub=-2.6716035e-025       pub=-2.238465e-032
+ uc=2.4008127e-010         luc=-3.2097822e-017       wuc=-4.3938167e-017
+ puc=4.47693e-024          vsat=114000               a0=2.375
+ ags=0.93789474            pvsat=0+dpvsatn           lags=1.2056842e-007
+ wags=-1.356074e-024       pags=1.3506497e-029       a1=0
+ a2=1                      b0=0                      b1=0
+ keta=-0.045               dwg=0                     dwb=0
+ pclm=0.84                 pdiblc1=0                 pdiblc2=0.0001
+ pdiblcb=0                 drout=0                   pvag=1.5
+ delta=0.0075              pscbe1=9.264e008          pscbe2=1e-020
+ fprout=200                pdits=0                   pditsd=0
+ pditsl=0                  rsh=10.5                  rdsw=140
+ prwg=0                    prwb=0                    wr=1
+ alpha0=0                  alpha1=0.03               beta0=8.7
+ agidl=9e-008              bgidl=2.3e009             cgidl=0.5
+ egidl=0.53                aigbacc=0.01134           bigbacc=0.003249
+ cigbacc=0.1416            nigbacc=4.05              aigbinv=0.35
+ bigbinv=0.03              cigbinv=0.006             eigbinv=1.1
+ nigbinv=1                 aigc=0.0103               bigc=0.001525
+ cigc=0                    aigsd=0.00845             bigsd=0.0004021
+ cigsd=0.001463            nigc=1                    poxedge=1
+ pigcd=2.3                 ntox=ntoxn                xrcrg1=12
+ xrcrg2=1                  cgso=cgon                 cgdo=cgon
+ cgbo=0                    cgdl=cgln                 cgsl=cgln
+ clc=1e-007                cle=0.6                   cf=cfn
+ ckappas=0.6               acde=1.2                  moin=12.6
+ noff=1.686                voffcv=-0.05472           kt1=-0.20699116
+ lkt1=-1.1044067e-008      wkt1=1.6950925e-025       pkt1=-1.6883121e-030
+ kt1l=0                    kt2=-0.04464              ute=-1.6935817
+ lute=8.8859891e-008       wute=1.13044e-007         pute=-2.0438159e-014
+ ua1=2.684e-009            ub1=-3.673e-018           uc1=-6.421e-011
+ prt=0                     at=45000                  jss=1.77e-07
+ jsws=4.23e-13             jswgs=9e-12               njs=1
+ ijthsfwd=0.01             ijthsrev=0.01             bvs=10
+ xjbvs=1                   pbs=0.5                   cjs=cjn
+ mjs=0.25                  pbsws=0.8                 cjsws=cjswn
+ mjsws=0.01                pbswgs=0.78               cjswgs=cjswgn
+ mjswgs=0.52               tpb=1.00e-03              tcj=7.32e-04
+ tpbsw=1.90e-03            tcjsw=3.57e-04            tpbswg=1.90e-03
+ tcjswg=3.57e-04           xtis=3                    dmcg=9.25e-008
+ dmci=9.25e-008            dmdg=0                    dmcgt=0
+ dwj=0                     xgw=0                     xgl=0
+ rshg=0.1                  gbmin=1e-012              rbpb=50
+ rbpd=50                   rbps=50                   rbdb=50
+ rbsb=50                   ngcon=1                   saref=0.63e-6
+ sbref=0.63e-6             kvsat=0.20                wlod=0.8e-6
+ tku0=0.01                 ku0=-7.36e-8              llodku0=1
+ wlodku0=1                 lku0=4.027e-7             wku0=8e-7
+ pku0=-2.0e-13             kvth0=3.5e-9              stk2=1.35e-9
+ steta0=0                  lkvth0=-2.68e-11          wkvth0=1.5e-6
+ pkvth0=0                  llodvth=1                 wlodvth=1
+ lodk2=0.5                 lodeta0=1                 fnoimod=1
+ noia=4.2926e+41           noib=1.612e+24            noic=8.75
+ em=1.192e+07              ef=0.8841                 wpemod=wpeflag
+ kvth0we=0.00323           lkvth0we=0                wkvth0we=0
+ pkvth0we=0                ku0we=-0.003              lku0we=4.00e-10
+ wku0we=0                  pku0we=0                  k2we=0.0016
+ wk2we=0                   web=-210                  wec=-3500
+ scref=1.00e-06            ud=0                      tnoimod=0
+ minr=1e-3

     11: type=n
+ lmin=2.4000e-07-dxln      lmax=5.0000e-07-dxln      wmin=5.0000e-07-dxwn
+ wmax=1.0000e-06-dxwn      version=4.5               binunit=2
+ paramchk=1                mobmod=0                  capmod=2
+ igcmod=1                  igbmod=1                  diomod=1
+ rdsmod=0                  rbodymod=0                rgatemod=0
+ permod=1                  acnqsmod=0                trnqsmod=0
+ tnom=25                   toxe=toxn                 toxm=toxn
+ dtox=3e-010               epsrox=3.9                wint=6e-009
+ lint=2.5e-009             ll=0                      wl=0
+ lln=1                     wln=1                     lw=0
+ ww=0                      lwn=1                     wwn=1
+ lwl=0                     wwl=0                     llc=0
+ wlc=0                     lwc=0                     wwc=0
+ lwlc=0                    wwlc=0                    dlc=1.172e-008
+ dwc=0                     xpart=1                   toxref=3e-009
+ dlcig=2.5e-009            xl=-3.5e-08+dxln          xw=1.5e-8+dxwn
+ vth0=0.23803+dvthn        wvth0=-5.04509e-009+dwvthn
+ lvth0=0+dlvthn            pvth0=0+dpvthn            k1=0.3231
+ k2=0.0056153846+dk2n      lk2=-2.1230769e-009       k3=-2.5615385
+ lk3=-6.3692308e-008       k3b=1.2                   w0=-5e-008
+ dvt0=13.9                 dvt1=1.25                 dvt2=0
+ dvt0w=0                   dvt1w=0                   dvt2w=0
+ dsub=0.5                  minv=0                    voffl=0
+ dvtp0=4e-007              dvtp1=2                   lpe0=4.45e-008
+ lpeb=0                    xj=1.5e-007               ngate=4e020
+ ndep=8.3687e017           nsd=1e020                 phin=0
+ cdsc=0                    cdscb=0                   cdscd=0
+ cit=-0.00076923077        lcit=3.5384615e-010       voff=-0.088950631
+ lvoff=-9.4275938e-009     wvoff=-1.4770471e-008     pvoff=2.5706674e-015+dpvoffn
+ nfactor=0.5               eta0=0.227114             weta0=-1.9171342e-008
+ peta0=0+dpeta0n           etab=-0.1                 u0=0.0376264
+ wu0=-4.4396792e-009       ua=-6.284e-010            ub=1.9834226e-018
+ lub=-7.3390523e-026       wub=-3.6860204e-025       pub=2.4278525e-032
+ uc=1.874334e-010          luc=-7.8798e-018          wuc=-4.3131639e-017
+ puc=4.1059271e-024        vsat=114000               a0=2.375
+ ags=1.3923077             pvsat=0+dpvsatn           lags=-8.8461538e-008
+ a1=0                      a2=1                      b0=0
+ b1=0                      keta=-0.058846154         lketa=6.3692308e-009
+ dwg=0                     dwb=0                     pclm=0.84
+ pdiblc1=0                 pdiblc2=0.0001            pdiblcb=0
+ drout=0                   pvag=1.5                  delta=0.0075
+ pscbe1=9.264e008          pscbe2=1e-020             fprout=200
+ pdits=0                   pditsd=0                  pditsl=0
+ rsh=10.5                  rdsw=140                  prwg=0
+ prwb=0                    wr=1                      alpha0=0
+ alpha1=0.03               beta0=8.7                 agidl=9e-008
+ bgidl=2.3e009             cgidl=0.5                 egidl=0.53
+ aigbacc=0.01134           bigbacc=0.003249          cigbacc=0.1416
+ nigbacc=4.05              aigbinv=0.35              bigbinv=0.03
+ cigbinv=0.006             eigbinv=1.1               nigbinv=1
+ aigc=0.0103               bigc=0.001525             cigc=0
+ aigsd=0.00845             bigsd=0.0004021           cigsd=0.001463
+ nigc=1                    poxedge=1                 pigcd=2.3
+ ntox=ntoxn                xrcrg1=12                 xrcrg2=1
+ cgso=cgon                 cgdo=cgon                 cgbo=0
+ cgdl=cgln                 cgsl=cgln                 clc=1e-007
+ cle=0.6                   cf=cfn                    ckappas=0.6
+ acde=1.2                  moin=12.6                 noff=1.686
+ voffcv=-0.05472           kt1=-0.20061538           lkt1=-1.3976923e-008
+ kt1l=0                    kt2=-0.04464              ute=-1.4972988
+ lute=-1.4302462e-009      wute=6.318005e-008        pute=2.49926e-015
+ ua1=2.684e-009            ub1=-3.673e-018           uc1=-1.1860365e-010
+ luc1=2.5021077e-017       wuc1=5.4556827e-017       puc1=-2.509614e-023
+ prt=0                     at=45000                  jss=1.77e-07
+ jsws=4.23e-13             jswgs=9e-12               njs=1
+ ijthsfwd=0.01             ijthsrev=0.01             bvs=10
+ xjbvs=1                   pbs=0.5                   cjs=cjn
+ mjs=0.25                  pbsws=0.8                 cjsws=cjswn
+ mjsws=0.01                pbswgs=0.78               cjswgs=cjswgn
+ mjswgs=0.52               tpb=1.00e-03              tcj=7.32e-04
+ tpbsw=1.90e-03            tcjsw=3.57e-04            tpbswg=1.90e-03
+ tcjswg=3.57e-04           xtis=3                    dmcg=9.25e-008
+ dmci=9.25e-008            dmdg=0                    dmcgt=0
+ dwj=0                     xgw=0                     xgl=0
+ rshg=0.1                  gbmin=1e-012              rbpb=50
+ rbpd=50                   rbps=50                   rbdb=50
+ rbsb=50                   ngcon=1                   saref=0.63e-6
+ sbref=0.63e-6             kvsat=0.20                wlod=0.8e-6
+ tku0=0.01                 ku0=-7.36e-8              llodku0=1
+ wlodku0=1                 lku0=4.027e-7             wku0=8e-7
+ pku0=-2.0e-13             kvth0=3.5e-9              stk2=1.35e-9
+ steta0=0                  lkvth0=-2.68e-11          wkvth0=1.5e-6
+ pkvth0=0                  llodvth=1                 wlodvth=1
+ lodk2=0.5                 lodeta0=1                 fnoimod=1
+ noia=4.2926e+41           noib=1.612e+24            noic=8.75
+ em=1.192e+07              ef=0.8841                 wpemod=wpeflag
+ kvth0we=0.00323           lkvth0we=0                wkvth0we=0
+ pkvth0we=0                ku0we=-0.003              lku0we=4.00e-10
+ wku0we=0                  pku0we=0                  k2we=0.0016
+ wk2we=0                   web=-210                  wec=-3500
+ scref=1.00e-06            ud=0                      tnoimod=0
+ minr=1e-3

     12: type=n
+ lmin=1.0e-07              lmax=2.4000e-07-dxln      wmin=5.0000e-07-dxwn
+ wmax=1.0000e-06-dxwn      version=4.5               binunit=2
+ paramchk=1                mobmod=0                  capmod=2
+ igcmod=1                  igbmod=1                  diomod=1
+ rdsmod=0                  rbodymod=0                rgatemod=0
+ permod=1                  acnqsmod=0                trnqsmod=0
+ tnom=25                   toxe=toxn                 toxm=toxn
+ dtox=3e-010               epsrox=3.9                wint=6e-009
+ lint=2.5e-009             ll=0                      wl=0
+ lln=1                     wln=1                     lw=0
+ ww=0                      lwn=1                     wwn=1
+ lwl=0                     wwl=0                     llc=0
+ wlc=0                     lwc=0                     wwc=0
+ lwlc=0                    wwlc=0                    dlc=1.172e-008
+ dwc=0                     xpart=1                   toxref=3e-009
+ dlcig=2.5e-009            xl=-3.5e-08+dxln          xw=1.5e-8+dxwn
+ vth0=0.23803+dvthn        wvth0=-5.04509e-009+dwvthn
+ lvth0=0+dlvthn            pvth0=0+dpvthn            k1=0.312
+ lk1=2.22e-009             k2=-0.0058468571+dk2n     lk2=1.6937143e-010
+ wk2=-1.7297451e-009       pk2=3.4594903e-016        k3=-2.9571429
+ lk3=1.5428571e-008        k3b=1.2                   w0=-5e-008
+ dvt0=13.9                 dvt1=1.25                 dvt2=0
+ dvt0w=0                   dvt1w=0                   dvt2w=0
+ dsub=0.5                  minv=0                    voffl=0
+ dvtp0=4e-007              dvtp1=1.1402857           ldvtp1=1.7194286e-007
+ wdvtp1=4.3243629e-007     pdvtp1=-8.6487257e-014    lpe0=4.45e-008
+ lpeb=0                    xj=1.5e-007               ngate=4e020
+ ndep=8.3687e017           nsd=1e020                 phin=0
+ cdsc=0                    cdscb=0                   cdscd=0
+ cit=-0.00012285714        lcit=2.2457143e-010       voff=-0.13176877
+ lvoff=-8.6396571e-010     wvoff=-4.4685083e-010     pvoff=-2.9405667e-016+dpvoffn
+ nfactor=0.5               eta0=0.227114             weta0=-1.9171342e-008
+ peta0=0+dpeta0n           etab=-0.1                 u0=0.0376264
+ wu0=-4.4396792e-009       ua=-6.284e-010            ub=1.3941151e-018
+ lub=4.4470971e-026        wub=-1.875332e-025        pub=-1.1935241e-032
+ uc=1.1179963e-010         luc=7.2469543e-018        wuc=-4.7423846e-018
+ puc=-3.5719237e-024       vsat=114000               a0=2.375
+ ags=0.95                  pvsat=0+dpvsatn           a1=0
+ a2=1                      b0=0                      b1=0
+ keta=-0.044142857         lketa=3.4285714e-009      dwg=0
+ dwb=0                     pclm=0.84                 pdiblc1=0
+ pdiblc2=-7.1942857e-005   lpdiblc2=3.4388571e-011   wpdiblc2=8.6487257e-011
+ ppdiblc2=-1.7297451e-017  pdiblcb=0                 drout=0
+ pvag=1.5                  delta=0.0075              pscbe1=9.264e008
+ pscbe2=1e-020             fprout=200                pdits=0
+ pditsd=0                  pditsl=0                  rsh=10.5
+ rdsw=140                  prwg=0                    prwb=0
+ wr=1                      alpha0=0                  alpha1=0.03
+ beta0=8.7                 agidl=9e-008              bgidl=2.3e009
+ cgidl=0.5                 egidl=0.53                aigbacc=0.01134
+ bigbacc=0.003249          cigbacc=0.1416            nigbacc=4.05
+ aigbinv=0.35              bigbinv=0.03              cigbinv=0.006
+ eigbinv=1.1               nigbinv=1                 aigc=0.010394569
+ laigc=-1.8913714e-011     waigc=-4.7567991e-011     paigc=9.5135983e-018
+ bigc=0.001525             cigc=0                    aigsd=0.00845
+ bigsd=0.0004021           cigsd=0.001463            nigc=1
+ poxedge=1                 pigcd=2.3                 ntox=ntoxn
+ xrcrg1=12                 xrcrg2=1                  cgso=cgon
+ cgdo=cgon                 cgbo=0                    cgdl=cgln
+ cgsl=cgln                 clc=1e-007                cle=0.6
+ cf=cfn                    ckappas=0.6               acde=1.2
+ moin=12.6                 noff=1.686                voffcv=-0.05472
+ kt1=-0.2624               lkt1=-1.62e-009           kt1l=0
+ kt2=-0.04464              ute=-1.5662517            lute=1.2360343e-008
+ wute=9.0379184e-008       pute=-2.9405667e-015      ua1=2.684e-009
+ ub1=-3.673e-018           uc1=3.6806771e-011        luc1=-6.0610063e-018
+ wuc1=-1.0131982e-016      puc1=6.0791893e-024       prt=0
+ at=35357.143              lat=0.0019285714          jss=1.77e-07
+ jsws=4.23e-13             jswgs=9e-12               njs=1
+ ijthsfwd=0.01             ijthsrev=0.01             bvs=10
+ xjbvs=1                   pbs=0.5                   cjs=cjn
+ mjs=0.25                  pbsws=0.8                 cjsws=cjswn
+ mjsws=0.01                pbswgs=0.78               cjswgs=cjswgn
+ mjswgs=0.52               tpb=1.00e-03              tcj=7.32e-04
+ tpbsw=1.90e-03            tcjsw=3.57e-04            tpbswg=1.90e-03
+ tcjswg=3.57e-04           xtis=3                    dmcg=9.25e-008
+ dmci=9.25e-008            dmdg=0                    dmcgt=0
+ dwj=0                     xgw=0                     xgl=0
+ rshg=0.1                  gbmin=1e-012              rbpb=50
+ rbpd=50                   rbps=50                   rbdb=50
+ rbsb=50                   ngcon=1                   saref=0.63e-6
+ sbref=0.63e-6             kvsat=0.20                wlod=0.8e-6
+ tku0=0.01                 ku0=-7.36e-8              llodku0=1
+ wlodku0=1                 lku0=4.027e-7             wku0=8e-7
+ pku0=-2.0e-13             kvth0=3.5e-9              stk2=1.35e-9
+ steta0=0                  lkvth0=-2.68e-11          wkvth0=1.5e-6
+ pkvth0=0                  llodvth=1                 wlodvth=1
+ lodk2=0.5                 lodeta0=1                 fnoimod=1
+ noia=4.2926e+41           noib=1.612e+24            noic=8.75
+ em=1.192e+07              ef=0.8841                 wpemod=wpeflag
+ kvth0we=0.00323           lkvth0we=0                wkvth0we=0
+ pkvth0we=0                ku0we=-0.003              lku0we=4.00e-10
+ wku0we=0                  pku0we=0                  k2we=0.0016
+ wk2we=0                   web=-210                  wec=-3500
+ scref=1.00e-06            ud=0                      tnoimod=0
+ minr=1e-3

     13: type=n
+ lmin=1.0000e-05-dxln      lmax=2.001e-05            wmin=2.4000e-07-dxwn
+ wmax=5.0000e-07-dxwn      version=4.5               binunit=2
+ paramchk=1                mobmod=0                  capmod=2
+ igcmod=1                  igbmod=1                  diomod=1
+ rdsmod=0                  rbodymod=0                rgatemod=0
+ permod=1                  acnqsmod=0                trnqsmod=0
+ tnom=25                   toxe=toxn                 toxm=toxn
+ dtox=3e-010               epsrox=3.9                wint=6e-009
+ lint=2.5e-009             ll=0                      wl=0
+ lln=1                     wln=1                     lw=0
+ ww=0                      lwn=1                     wwn=1
+ lwl=0                     wwl=0                     llc=0
+ wlc=0                     lwc=0                     wwc=0
+ lwlc=0                    wwlc=0                    dlc=1.172e-008
+ dwc=0                     xpart=1                   toxref=3e-009
+ dlcig=2.5e-009            xl=-3.5e-08+dxln          xw=1.5e-8+dxwn
+ vth0=0.228+dvthn          wvth0=0+dwvthn            lvth0=0+dlvthn
+ pvth0=0+dpvthn            k1=0.3231                 k2=0.008228+dk2n
+ k3=-2.7                   k3b=1.2                   w0=-5e-008
+ dvt0=13.9                 dvt1=1.25                 dvt2=0
+ dvt0w=0                   dvt1w=0                   dvt2w=0
+ dsub=0.5                  minv=0                    voffl=0
+ dvtp0=4e-007              dvtp1=2                   lpe0=4.45e-008
+ lpeb=0                    xj=1.5e-007               ngate=4e020
+ ndep=8.3687e017           nsd=1e020                 phin=0
+ cdsc=0                    cdscb=0                   cdscd=0
+ cit=0                     voff=-0.112               nfactor=0.5
+ eta0=0.23012308           peta0=0+dpeta0n           pvoff=0+dpvoffn
+ weta0=-2.0684908e-008     etab=-0.1                 u0=0.029734615
+ wu0=-4.7011154e-010       ua=-6.284e-010            ub=1.633e-018
+ uc=1.504e-010             vsat=114000               a0=2.375
+ pvsat=0+dpvsatn           ags=0.95                  a1=0
+ a2=1                      b0=0                      b1=0
+ keta=-0.045               dwg=0                     dwb=0
+ pclm=0.84                 pdiblc1=0                 pdiblc2=0.0001
+ pdiblcb=0                 drout=0                   pvag=1.5
+ delta=0.0075              pscbe1=9.264e008          pscbe2=1e-020
+ fprout=200                pdits=0                   pditsd=0
+ pditsl=0                  rsh=10.5                  rdsw=140
+ prwg=0                    prwb=0                    wr=1
+ alpha0=0                  alpha1=0.03               beta0=8.7
+ agidl=9e-008              bgidl=2.3e009             cgidl=0.5
+ egidl=0.53                aigbacc=0.01134           bigbacc=0.003249
+ cigbacc=0.1416            nigbacc=4.05              aigbinv=0.35
+ bigbinv=0.03              cigbinv=0.006             eigbinv=1.1
+ nigbinv=1                 aigc=0.0103               bigc=0.001525
+ cigc=0                    aigsd=0.00845             bigsd=0.0004021
+ cigsd=0.001463            nigc=1                    poxedge=1
+ pigcd=2.3                 ntox=ntoxn                xrcrg1=12
+ xrcrg2=1                  cgso=cgon                 cgdo=cgon
+ cgbo=0                    cgdl=cgln                 cgsl=cgln
+ clc=1e-007                cle=0.6                   cf=cfn
+ ckappas=0.6               acde=1.2                  moin=12.6
+ noff=1.686                voffcv=-0.05472           kt1=-0.2081
+ kt1l=0                    kt2=-0.04464              ute=-1.5191423
+ wute=2.7736581e-008       ua1=2.684e-009            ub1=-3.673e-018
+ uc1=-6.421e-011           prt=0                     at=45000
+ jss=1.77e-07              jsws=4.23e-13             jswgs=9e-12
+ njs=1                     ijthsfwd=0.01             ijthsrev=0.01
+ bvs=10                    xjbvs=1                   pbs=0.5
+ cjs=cjn                   mjs=0.25                  pbsws=0.8
+ cjsws=cjswn               mjsws=0.01                pbswgs=0.78
+ cjswgs=cjswgn             mjswgs=0.52               tpb=1.00e-03
+ tcj=7.32e-04              tpbsw=1.90e-03            tcjsw=3.57e-04
+ tpbswg=1.90e-03           tcjswg=3.57e-04           xtis=3
+ dmcg=9.25e-008            dmci=9.25e-008            dmdg=0
+ dmcgt=0                   dwj=0                     xgw=0
+ xgl=0                     rshg=0.1                  gbmin=1e-012
+ rbpb=50                   rbpd=50                   rbps=50
+ rbdb=50                   rbsb=50                   ngcon=1
+ saref=0.63e-6             sbref=0.63e-6             kvsat=0.20
+ wlod=0.8e-6               tku0=0.01                 ku0=-7.36e-8
+ llodku0=1                 wlodku0=1                 lku0=4.027e-7
+ wku0=8e-7                 pku0=-2.0e-13             kvth0=3.5e-9
+ stk2=1.35e-9              steta0=0                  lkvth0=-2.68e-11
+ wkvth0=1.5e-6             pkvth0=0                  llodvth=1
+ wlodvth=1                 lodk2=0.5                 lodeta0=1
+ fnoimod=1                 noia=4.2926e+41           noib=1.612e+24
+ noic=8.75                 em=1.192e+07              ef=0.8841
+ wpemod=wpeflag            kvth0we=0.00323           lkvth0we=0
+ wkvth0we=0                pkvth0we=0                ku0we=-0.003
+ lku0we=4.00e-10           wku0we=0                  pku0we=0
+ k2we=0.0016               wk2we=0                   web=-210
+ wec=-3500                 scref=1.00e-06            ud=0
+ tnoimod=0                 minr=1e-3

     14: type=n
+ lmin=5.0000e-07-dxln      lmax=1.0000e-05-dxln      wmin=2.4000e-07-dxwn
+ wmax=5.0000e-07-dxwn      version=4.5               binunit=2
+ paramchk=1                mobmod=0                  capmod=2
+ igcmod=1                  igbmod=1                  diomod=1
+ rdsmod=0                  rbodymod=0                rgatemod=0
+ permod=1                  acnqsmod=0                trnqsmod=0
+ tnom=25                   toxe=toxn                 toxm=toxn
+ dtox=3e-010               epsrox=3.9                wint=6e-009
+ lint=2.5e-009             ll=0                      wl=0
+ lln=1                     wln=1                     lw=0
+ ww=0                      lwn=1                     wwn=1
+ lwl=0                     wwl=0                     llc=0
+ wlc=0                     lwc=0                     wwc=0
+ lwlc=0                    wwlc=0                    dlc=1.172e-008
+ dwc=0                     xpart=1                   toxref=3e-009
+ dlcig=2.5e-009            xl=-3.5e-08+dxln          xw=1.5e-8+dxwn
+ vth0=0.228+dvthn          wvth0=0+dwvthn            lvth0=0+dlvthn
+ pvth0=0+dpvthn            k1=0.3231                 k2=0.0085779874+dk2n
+ lk2=-3.4858742e-009       wk2=1.9744012e-026        pk2=-1.9665036e-031
+ k3=-2.7                   k3b=1.2                   w0=-5e-008
+ dvt0=13.9                 dvt1=1.25                 dvt2=0
+ dvt0w=0                   dvt1w=0                   dvt2w=0
+ dsub=0.5                  minv=0                    voffl=0
+ dvtp0=4e-007              dvtp1=2                   lpe0=4.45e-008
+ lpeb=0                    xj=1.5e-007               ngate=4e020
+ ndep=8.3687e017           nsd=1e020                 phin=0
+ cdsc=0                    cdscb=0                   cdscd=0
+ cit=0                     voff=-0.11123979          lvoff=-7.5716968e-009
+ wvoff=7.8976046e-026      pvoff=-7.8660142e-031+dpvoffn
+ nfactor=0.5               eta0=0.23012308           peta0=0+dpeta0n
+ weta0=-2.0684908e-008     etab=-0.1                 u0=0.029734615
+ wu0=-4.7011154e-010       ua=-6.284e-010            ub=1.6574184e-018
+ lub=-2.4320691e-025       wub=-1.6389573e-027       pub=1.6324015e-032
+ uc=1.5272905e-010         luc=-2.3197364e-017       wuc=1.4710435e-034
+ puc=-1.4651593e-039       vsat=114000               a0=2.375
+ pvsat=0+dpvsatn           ags=0.93789474            lags=1.2056842e-007
+ wags=-6.3180837e-025      pags=6.2928114e-030       a1=0
+ a2=1                      b0=0                      b1=0
+ keta=-0.045               dwg=0                     dwb=0
+ pclm=0.84                 pdiblc1=0                 pdiblc2=0.0001
+ pdiblcb=0                 drout=0                   pvag=1.5
+ delta=0.0075              pscbe1=9.264e008          pscbe2=1e-020
+ fprout=200                pdits=0                   pditsd=0
+ pditsl=0                  rsh=10.5                  rdsw=140
+ prwg=0                    prwb=0                    wr=1
+ alpha0=0                  alpha1=0.03               beta0=8.7
+ agidl=9e-008              bgidl=2.3e009             cgidl=0.5
+ egidl=0.53                aigbacc=0.01134           bigbacc=0.003249
+ cigbacc=0.1416            nigbacc=4.05              aigbinv=0.35
+ bigbinv=0.03              cigbinv=0.006             eigbinv=1.1
+ nigbinv=1                 aigc=0.0103               bigc=0.001525
+ cigc=0                    aigsd=0.00845             bigsd=0.0004021
+ cigsd=0.001463            nigc=1                    poxedge=1
+ pigcd=2.3                 ntox=ntoxn                xrcrg1=12
+ xrcrg2=1                  cgso=cgon                 cgdo=cgon
+ cgbo=0                    cgdl=cgln                 cgsl=cgln
+ clc=1e-007                cle=0.6                   cf=cfn
+ ckappas=0.6               acde=1.2                  moin=12.6
+ noff=1.686                voffcv=-0.05472           kt1=-0.20699116
+ lkt1=-1.1044067e-008      wkt1=7.8976046e-026       pkt1=-7.8660142e-031
+ kt1l=0                    kt2=-0.04464              ute=-1.5217217
+ lute=2.5690348e-008       wute=2.6598416e-008       pute=1.1336121e-014
+ ua1=2.684e-009            ub1=-3.673e-018           uc1=-6.421e-011
+ prt=0                     at=45000                  jss=1.77e-07
+ jsws=4.23e-13             jswgs=9e-12               njs=1
+ ijthsfwd=0.01             ijthsrev=0.01             bvs=10
+ xjbvs=1                   pbs=0.5                   cjs=cjn
+ mjs=0.25                  pbsws=0.8                 cjsws=cjswn
+ mjsws=0.01                pbswgs=0.78               cjswgs=cjswgn
+ mjswgs=0.52               tpb=1.00e-03              tcj=7.32e-04
+ tpbsw=1.90e-03            tcjsw=3.57e-04            tpbswg=1.90e-03
+ tcjswg=3.57e-04           xtis=3                    dmcg=9.25e-008
+ dmci=9.25e-008            dmdg=0                    dmcgt=0
+ dwj=0                     xgw=0                     xgl=0
+ rshg=0.1                  gbmin=1e-012              rbpb=50
+ rbpd=50                   rbps=50                   rbdb=50
+ rbsb=50                   ngcon=1                   saref=0.63e-6
+ sbref=0.63e-6             kvsat=0.20                wlod=0.8e-6
+ tku0=0.01                 ku0=-7.36e-8              llodku0=1
+ wlodku0=1                 lku0=4.027e-7             wku0=8e-7
+ pku0=-2.0e-13             kvth0=3.5e-9              stk2=1.35e-9
+ steta0=0                  lkvth0=-2.68e-11          wkvth0=1.5e-6
+ pkvth0=0                  llodvth=1                 wlodvth=1
+ lodk2=0.5                 lodeta0=1                 fnoimod=1
+ noia=4.2926e+41           noib=1.612e+24            noic=8.75
+ em=1.192e+07              ef=0.8841                 wpemod=wpeflag
+ kvth0we=0.00323           lkvth0we=0                wkvth0we=0
+ pkvth0we=0                ku0we=-0.003              lku0we=4.00e-10
+ wku0we=0                  pku0we=0                  k2we=0.0016
+ wk2we=0                   web=-210                  wec=-3500
+ scref=1.00e-06            ud=0                      tnoimod=0
+ minr=1e-3

     15: type=n
+ lmin=2.4000e-07-dxln      lmax=5.0000e-07-dxln      wmin=2.4000e-07-dxwn
+ wmax=5.0000e-07-dxwn      version=4.5               binunit=2
+ paramchk=1                mobmod=0                  capmod=2
+ igcmod=1                  igbmod=1                  diomod=1
+ rdsmod=0                  rbodymod=0                rgatemod=0
+ permod=1                  acnqsmod=0                trnqsmod=0
+ tnom=25                   toxe=toxn                 toxm=toxn
+ dtox=3e-010               epsrox=3.9                wint=6e-009
+ lint=2.5e-009             ll=0                      wl=0
+ lln=1                     wln=1                     lw=0
+ ww=0                      lwn=1                     wwn=1
+ lwl=0                     wwl=0                     llc=0
+ wlc=0                     lwc=0                     wwc=0
+ lwlc=0                    wwlc=0                    dlc=1.172e-008
+ dwc=0                     xpart=1                   toxref=3e-009
+ dlcig=2.5e-009            xl=-3.5e-08+dxln          xw=1.5e-8+dxwn
+ vth0=0.228+dvthn          wvth0=0+dwvthn            lvth0=0+dlvthn
+ pvth0=0+dpvthn            k1=0.3231                 k2=0.0056153846+dk2n
+ lk2=-2.1230769e-009       k3=-2.5615385             lk3=-6.3692308e-008
+ k3b=1.2                   w0=-5e-008                dvt0=13.9
+ dvt1=1.25                 dvt2=0                    dvt0w=0
+ dvt1w=0                   dvt2w=0                   dsub=0.5
+ minv=0                    voffl=0                   dvtp0=4e-007
+ dvtp1=2                   lpe0=4.45e-008            lpeb=0
+ xj=1.5e-007               ngate=4e020               ndep=8.3687e017
+ nsd=1e020                 phin=0                    cdsc=0
+ cdscb=0                   cdscd=0                   cit=-0.00076923077
+ lcit=3.5384615e-010       voff=-0.12176627          lvoff=-2.7295148e-009
+ wvoff=1.7357964e-009      pvoff=-7.9846637e-016+dpvoffn
+ nfactor=0.5               eta0=0.23012308           peta0=0+dpeta0n
+ weta0=-2.0684908e-008     etab=-0.1                 u0=0.029734615
+ wu0=-4.7011154e-010       ua=-6.284e-010            ub=1.1883556e-018
+ lub=-2.7438047e-026       wub=3.1316661e-026        pub=1.1644301e-033
+ uc=8.4638669e-011         luc=8.1242124e-018        wuc=8.5741112e-018
+ puc=-3.9440912e-024       vsat=114000               a0=2.375
+ pvsat=0+dpvsatn           ags=1.3923077             lags=-8.8461538e-008
+ a1=0                      a2=1                      b0=0
+ b1=0                      keta=-0.058846154         lketa=6.3692308e-009
+ dwg=0                     dwb=0                     pclm=0.84
+ pdiblc1=0                 pdiblc2=0.0001            pdiblcb=0
+ drout=0                   pvag=1.5                  delta=0.0075
+ pscbe1=9.264e008          pscbe2=1e-020             fprout=200
+ pdits=0                   pditsd=0                  pditsl=0
+ rsh=10.5                  rdsw=140                  prwg=0
+ prwb=0                    wr=1                      alpha0=0
+ alpha1=0.03               beta0=8.7                 agidl=9e-008
+ bgidl=2.3e009             cgidl=0.5                 egidl=0.53
+ aigbacc=0.01134           bigbacc=0.003249          cigbacc=0.1416
+ nigbacc=4.05              aigbinv=0.35              bigbinv=0.03
+ cigbinv=0.006             eigbinv=1.1               nigbinv=1
+ aigc=0.0103               bigc=0.001525             cigc=0
+ aigsd=0.00845             bigsd=0.0004021           cigsd=0.001463
+ nigc=1                    poxedge=1                 pigcd=2.3
+ ntox=ntoxn                xrcrg1=12                 xrcrg2=1
+ cgso=cgon                 cgdo=cgon                 cgbo=0
+ cgdl=cgln                 cgsl=cgln                 clc=1e-007
+ cle=0.6                   cf=cfn                    ckappas=0.6
+ acde=1.2                  moin=12.6                 noff=1.686
+ voffcv=-0.05472           kt1=-0.20061538           lkt1=-1.3976923e-008
+ kt1l=0                    kt2=-0.04464              ute=-1.4836305
+ lute=8.1684024e-009       wute=5.6304897e-008       pute=-2.3288602e-015
+ ua1=2.684e-009            ub1=-3.673e-018           uc1=-1.0140769e-011
+ luc1=-2.4871846e-017      prt=0                     at=45000
+ jss=1.77e-07              jsws=4.23e-13             jswgs=9e-12
+ njs=1                     ijthsfwd=0.01             ijthsrev=0.01
+ bvs=10                    xjbvs=1                   pbs=0.5
+ cjs=cjn                   mjs=0.25                  pbsws=0.8
+ cjsws=cjswn               mjsws=0.01                pbswgs=0.78
+ cjswgs=cjswgn             mjswgs=0.52               tpb=1.00e-03
+ tcj=7.32e-04              tpbsw=1.90e-03            tcjsw=3.57e-04
+ tpbswg=1.90e-03           tcjswg=3.57e-04           xtis=3
+ dmcg=9.25e-008            dmci=9.25e-008            dmdg=0
+ dmcgt=0                   dwj=0                     xgw=0
+ xgl=0                     rshg=0.1                  gbmin=1e-012
+ rbpb=50                   rbpd=50                   rbps=50
+ rbdb=50                   rbsb=50                   ngcon=1
+ saref=0.63e-6             sbref=0.63e-6             kvsat=0.20
+ wlod=0.8e-6               tku0=0.01                 ku0=-7.36e-8
+ llodku0=1                 wlodku0=1                 lku0=4.027e-7
+ wku0=8e-7                 pku0=-2.0e-13             kvth0=3.5e-9
+ stk2=1.35e-9              steta0=0                  lkvth0=-2.68e-11
+ wkvth0=1.5e-6             pkvth0=0                  llodvth=1
+ wlodvth=1                 lodk2=0.5                 lodeta0=1
+ fnoimod=1                 noia=4.2926e+41           noib=1.612e+24
+ noic=8.75                 em=1.192e+07              ef=0.8841
+ wpemod=wpeflag            kvth0we=0.00323           lkvth0we=0
+ wkvth0we=0                pkvth0we=0                ku0we=-0.003
+ lku0we=4.00e-10           wku0we=0                  pku0we=0
+ k2we=0.0016               wk2we=0                   web=-210
+ wec=-3500                 scref=1.00e-06            ud=0
+ tnoimod=0                 minr=1e-3

     16: type=n
+ lmin=1.0e-07              lmax=2.4000e-07-dxln      wmin=2.4000e-07-dxwn
+ wmax=5.0000e-07-dxwn      version=4.5               binunit=2
+ paramchk=1                mobmod=0                  capmod=2
+ igcmod=1                  igbmod=1                  diomod=1
+ rdsmod=0                  rbodymod=0                rgatemod=0
+ permod=1                  acnqsmod=0                trnqsmod=0
+ tnom=25                   toxe=toxn                 toxm=toxn
+ dtox=3e-010               epsrox=3.9                wint=6e-009
+ lint=2.5e-009             ll=0                      wl=0
+ lln=1                     wln=1                     lw=0
+ ww=0                      lwn=1                     wwn=1
+ lwl=0                     wwl=0                     llc=0
+ wlc=0                     lwc=0                     wwc=0
+ lwlc=0                    wwlc=0                    dlc=1.172e-008
+ dwc=0                     xpart=1                   toxref=3e-009
+ dlcig=2.5e-009            xl=-3.5e-08+dxln          xw=1.5e-8+dxwn
+ vth0=0.228+dvthn          wvth0=0+dwvthn            lvth0=0+dlvthn
+ pvth0=0+dpvthn            k1=0.312                  lk1=2.22e-009
+ k2=-0.0092857143+dk2n     lk2=8.5714286e-010        k3=-2.9571429
+ lk3=1.5428571e-008        k3b=1.2                   w0=-5e-008
+ dvt0=13.9                 dvt1=1.25                 dvt2=0
+ dvt0w=0                   dvt1w=0                   dvt2w=0
+ dsub=0.5                  minv=0                    voffl=0
+ dvtp0=4e-007              dvtp1=2                   lpe0=4.45e-008
+ lpeb=0                    xj=1.5e-007               ngate=4e020
+ ndep=8.3687e017           nsd=1e020                 phin=0
+ cdsc=0                    cdscb=0                   cdscd=0
+ cit=-0.00012285714        lcit=2.2457143e-010       voff=-0.12881187
+ lvoff=-1.3203956e-009     wvoff=-1.9341732e-009     pvoff=-6.447244e-017+dpvoffn
+ nfactor=0.5               eta0=0.23012308           weta0=-2.0684908e-008
+ etab=-0.1                 peta0=0+dpeta0n           u0=0.029734615
+ wu0=-4.7011154e-010       ua=-6.284e-010            ub=9.6908077e-019
+ lub=1.6416923e-026        wub=2.6259087e-026        pub=2.1759448e-033
+ uc=1.2854066e-010         luc=-6.5618571e-019       wuc=-1.3163123e-017
+ puc=4.033557e-025         vsat=114000               pvsat=0+dpvsatn
+ a0=2.375                  ags=0.95                  a1=0
+ a2=1                      b0=0                      b1=0
+ keta=-0.044142857         lketa=3.4285714e-009      dwg=0
+ dwb=0                     pclm=0.84                 pdiblc1=0
+ pdiblc2=0.0001            pdiblcb=0                 drout=0
+ pvag=1.5                  delta=0.0075              pscbe1=9.264e008
+ pscbe2=1e-020             fprout=200                pdits=0
+ pditsd=0                  pditsl=0                  rsh=10.5
+ rdsw=140                  prwg=0                    prwb=0
+ wr=1                      alpha0=0                  alpha1=0.03
+ beta0=8.7                 agidl=9e-008              bgidl=2.3e009
+ cgidl=0.5                 egidl=0.53                aigbacc=0.01134
+ bigbacc=0.003249          cigbacc=0.1416            nigbacc=4.05
+ aigbinv=0.35              bigbinv=0.03              cigbinv=0.006
+ eigbinv=1.1               nigbinv=1                 aigc=0.0103
+ bigc=0.001525             cigc=0                    aigsd=0.00845
+ bigsd=0.0004021           cigsd=0.001463            nigc=1
+ poxedge=1                 pigcd=2.3                 ntox=ntoxn
+ xrcrg1=12                 xrcrg2=1                  cgso=cgon
+ cgdo=cgon                 cgbo=0                    cgdl=cgln
+ cgsl=cgln                 clc=1e-007                cle=0.6
+ cf=cfn                    ckappas=0.6               acde=1.2
+ moin=12.6                 noff=1.686                voffcv=-0.05472
+ kt1=-0.2624               lkt1=-1.62e-009           kt1l=0
+ kt2=-0.04464              ute=-1.4673489            lute=4.9120879e-009
+ wute=4.0631069e-008       pute=8.0590549e-016       ua1=2.684e-009
+ ub1=-3.673e-018           uc1=-1.6462429e-010       luc1=6.0248571e-018
+ prt=0                     at=35357.143              lat=0.0019285714
+ jss=1.77e-07              jsws=4.23e-13             jswgs=9e-12
+ njs=1                     ijthsfwd=0.01             ijthsrev=0.01
+ bvs=10                    xjbvs=1                   pbs=0.5
+ cjs=cjn                   mjs=0.25                  pbsws=0.8
+ cjsws=cjswn               mjsws=0.01                pbswgs=0.78
+ cjswgs=cjswgn             mjswgs=0.52               tpb=1.00e-03
+ tcj=7.32e-04              tpbsw=1.90e-03            tcjsw=3.57e-04
+ tpbswg=1.90e-03           tcjswg=3.57e-04           xtis=3
+ dmcg=9.25e-008            dmci=9.25e-008            dmdg=0
+ dmcgt=0                   dwj=0                     xgw=0
+ xgl=0                     rshg=0.1                  gbmin=1e-012
+ rbpb=50                   rbpd=50                   rbps=50
+ rbdb=50                   rbsb=50                   ngcon=1
+ saref=0.63e-6             sbref=0.63e-6             kvsat=0.20
+ wlod=0.8e-6               tku0=0.01                 ku0=-7.36e-8
+ llodku0=1                 wlodku0=1                 lku0=4.027e-7
+ wku0=8e-7                 pku0=-2.0e-13             kvth0=3.5e-9
+ stk2=1.35e-9              steta0=0                  lkvth0=-2.68e-11
+ wkvth0=1.5e-6             pkvth0=0                  llodvth=1
+ wlodvth=1                 lodk2=0.5                 lodeta0=1
+ fnoimod=1                 noia=4.2926e+41           noib=1.612e+24
+ noic=8.75                 em=1.192e+07              ef=0.8841
+ wpemod=wpeflag            kvth0we=0.00323           lkvth0we=0
+ wkvth0we=0                pkvth0we=0                ku0we=-0.003
+ lku0we=4.00e-10           wku0we=0                  pku0we=0
+ k2we=0.0016               wk2we=0                   web=-210
+ wec=-3500                 scref=1.00e-06            ud=0
+ tnoimod=0                 minr=1e-3

     17: type=n
+ lmin=1.0000e-05-dxln      lmax=2.001e-05            wmin=1.20e-07
+ wmax=2.4000e-07-dxwn      version=4.5               binunit=2
+ paramchk=1                mobmod=0                  capmod=2
+ igcmod=1                  igbmod=1                  diomod=1
+ rdsmod=0                  rbodymod=0                rgatemod=0
+ permod=1                  acnqsmod=0                trnqsmod=0
+ tnom=25                   toxe=toxn                 toxm=toxn
+ dtox=3e-010               epsrox=3.9                wint=6e-009
+ lint=2.5e-009             ll=0                      wl=0
+ lln=1                     wln=1                     lw=0
+ ww=0                      lwn=1                     wwn=1
+ lwl=0                     wwl=0                     llc=0
+ wlc=0                     lwc=0                     wwc=0
+ lwlc=0                    wwlc=0                    dlc=1.172e-008
+ dwc=0                     xpart=1                   toxref=3e-009
+ dlcig=2.5e-009            xl=-3.5e-08+dxln          xw=1.5e-8+dxwn
+ vth0=0.228+dvthn          wvth0=0+dwvthn            lvth0=0+dlvthn
+ pvth0=0+dpvthn            k1=0.3231                 k2=0.008228+dk2n
+ k3=-2.7                   k3b=1.2                   w0=-5e-008
+ dvt0=13.9                 dvt1=1.25                 dvt2=0
+ dvt0w=0                   dvt1w=0                   dvt2w=0
+ dsub=0.5                  minv=0                    voffl=0
+ dvtp0=4e-007              dvtp1=2                   lpe0=4.45e-008
+ lpeb=0                    xj=1.5e-007               ngate=4e020
+ ndep=8.3687e017           nsd=1e020                 phin=0
+ cdsc=0                    cdscb=0                   cdscd=0
+ cit=0                     voff=-0.1243              wvoff=2.9889e-009
+ nfactor=0.5               pvoff=0+dpvoffn           eta0=0.219825
+ weta0=-1.8182475e-008     etab=-0.1                 peta0=0+dpeta0n
+ u0=0.029645               wu0=-4.48335e-010         ua=-6.284e-010
+ ub=1.369575e-018          wub=6.4012275e-026        uc=1.691575e-010
+ wuc=-4.5580725e-018       vsat=114000               a0=2.375
+ pvsat=0+dpvsatn           ags=0.95                  a1=0
+ a2=1                      b0=0                      b1=0
+ keta=-0.045               dwg=0                     dwb=0
+ pclm=0.84                 pdiblc1=0                 pdiblc2=0.0001
+ pdiblcb=0                 drout=0                   pvag=1.5
+ delta=0.0075              pscbe1=9.264e008          pscbe2=1e-020
+ fprout=200                pdits=0                   pditsd=0
+ pditsl=0                  rsh=10.5                  rdsw=140
+ prwg=0                    prwb=0                    wr=1
+ alpha0=0                  alpha1=0.03               beta0=8.7
+ agidl=9e-008              bgidl=2.3e009             cgidl=0.5
+ egidl=0.53                aigbacc=0.01134           bigbacc=0.003249
+ cigbacc=0.1416            nigbacc=4.05              aigbinv=0.35
+ bigbinv=0.03              cigbinv=0.006             eigbinv=1.1
+ nigbinv=1                 aigc=0.0103               bigc=0.001525
+ cigc=0                    aigsd=0.00845             bigsd=0.0004021
+ cigsd=0.001463            nigc=1                    poxedge=1
+ pigcd=2.3                 ntox=ntoxn                xrcrg1=12
+ xrcrg2=1                  cgso=cgon                 cgdo=cgon
+ cgbo=0                    cgdl=cgln                 cgsl=cgln
+ clc=1e-007                cle=0.6                   cf=cfn
+ ckappas=0.6               acde=1.2                  moin=12.6
+ noff=1.686                voffcv=-0.05472           kt1=-0.2081
+ kt1l=0                    kt2=-0.04464              ute=-1.481875
+ wute=1.8680625e-008       ua1=2.684e-009            ub1=-3.673e-018
+ uc1=-6.421e-011           prt=0                     at=45000
+ jss=1.77e-07              jsws=4.23e-13             jswgs=9e-12
+ njs=1                     ijthsfwd=0.01             ijthsrev=0.01
+ bvs=10                    xjbvs=1                   pbs=0.5
+ cjs=cjn                   mjs=0.25                  pbsws=0.8
+ cjsws=cjswn               mjsws=0.01                pbswgs=0.78
+ cjswgs=cjswgn             mjswgs=0.52               tpb=1.00e-03
+ tcj=7.32e-04              tpbsw=1.90e-03            tcjsw=3.57e-04
+ tpbswg=1.90e-03           tcjswg=3.57e-04           xtis=3
+ dmcg=9.25e-008            dmci=9.25e-008            dmdg=0
+ dmcgt=0                   dwj=0                     xgw=0
+ xgl=0                     rshg=0.1                  gbmin=1e-012
+ rbpb=50                   rbpd=50                   rbps=50
+ rbdb=50                   rbsb=50                   ngcon=1
+ saref=0.63e-6             sbref=0.63e-6             kvsat=0.20
+ wlod=0.8e-6               tku0=0.01                 ku0=-7.36e-8
+ llodku0=1                 wlodku0=1                 lku0=4.027e-7
+ wku0=8e-7                 pku0=-2.0e-13             kvth0=3.5e-9
+ stk2=1.35e-9              steta0=0                  lkvth0=-2.68e-11
+ wkvth0=1.5e-6             pkvth0=0                  llodvth=1
+ wlodvth=1                 lodk2=0.5                 lodeta0=1
+ fnoimod=1                 noia=4.2926e+41           noib=1.612e+24
+ noic=8.75                 em=1.192e+07              ef=0.8841
+ wpemod=wpeflag            kvth0we=0.00323           lkvth0we=0
+ wkvth0we=0                pkvth0we=0                ku0we=-0.003
+ lku0we=4.00e-10           wku0we=0                  pku0we=0
+ k2we=0.0016               wk2we=0                   web=-210
+ wec=-3500                 scref=1.00e-06            ud=0
+ tnoimod=0                 minr=1e-3

     18: type=n
+ lmin=5.0000e-07-dxln      lmax=1.0000e-05-dxln      wmin=1.20e-07
+ wmax=2.4000e-07-dxwn      version=4.5               binunit=2
+ paramchk=1                mobmod=0                  capmod=2
+ igcmod=1                  igbmod=1                  diomod=1
+ rdsmod=0                  rbodymod=0                rgatemod=0
+ permod=1                  acnqsmod=0                trnqsmod=0
+ tnom=25                   toxe=toxn                 toxm=toxn
+ dtox=3e-010               epsrox=3.9                wint=6e-009
+ lint=2.5e-009             ll=0                      wl=0
+ lln=1                     wln=1                     lw=0
+ ww=0                      lwn=1                     wwn=1
+ lwl=0                     wwl=0                     llc=0
+ wlc=0                     lwc=0                     wwc=0
+ lwlc=0                    wwlc=0                    dlc=1.172e-008
+ dwc=0                     xpart=1                   toxref=3e-009
+ dlcig=2.5e-009            xl=-3.5e-08+dxln          xw=1.5e-8+dxwn
+ vth0=0.228+dvthn          wvth0=0+dwvthn            lvth0=0+dlvthn
+ pvth0=0+dpvthn            k1=0.3231                 k2=0.0085779874+dk2n
+ lk2=-3.4858742e-009       wk2=1.0460793e-026        pk2=-1.041895e-031
+ k3=-2.7                   k3b=1.2                   w0=-5e-008
+ dvt0=13.9                 dvt1=1.25                 dvt2=0
+ dvt0w=0                   dvt1w=0                   dvt2w=0
+ dsub=0.5                  minv=0                    voffl=0
+ dvtp0=4e-007              dvtp1=2                   lpe0=4.45e-008
+ lpeb=0                    xj=1.5e-007               ngate=4e020
+ ndep=8.3687e017           nsd=1e020                 phin=0
+ cdsc=0                    cdscb=0                   cdscd=0
+ cit=0                     voff=-0.12330652          lvoff=-9.8950503e-009
+ wvoff=2.9322158e-009      pvoff=5.6457489e-016+dpvoffn
+ nfactor=0.5               eta0=0.219825             peta0=0+dpeta0n
+ weta0=-1.8182475e-008     etab=-0.1                 u0=0.029645
+ wu0=-4.48335e-010         ua=-6.284e-010            ub=1.3791091e-018
+ lub=-9.4959688e-026       wub=6.5990193e-026        pub=-1.970006e-032
+ uc=1.7115204e-010         luc=-1.9865576e-017       wuc=-4.4767849e-018
+ puc=-8.0962442e-025       vsat=114000               a0=2.375
+ pvsat=0+dpvsatn           ags=0.93789474            lags=1.2056842e-007
+ wags=-3.3474539e-025      pags=3.3340641e-030       a1=0
+ a2=1                      b0=0                      b1=0
+ keta=-0.045               dwg=0                     dwb=0
+ pclm=0.84                 pdiblc1=0                 pdiblc2=0.0001
+ pdiblcb=0                 drout=0                   pvag=1.5
+ delta=0.0075              pscbe1=9.264e008          pscbe2=1e-020
+ fprout=200                pdits=0                   pditsd=0
+ pditsl=0                  rsh=10.5                  rdsw=140
+ prwg=0                    prwb=0                    wr=1
+ alpha0=0                  alpha1=0.03               beta0=8.7
+ agidl=9e-008              bgidl=2.3e009             cgidl=0.5
+ egidl=0.53                aigbacc=0.01134           bigbacc=0.003249
+ cigbacc=0.1416            nigbacc=4.05              aigbinv=0.35
+ bigbinv=0.03              cigbinv=0.006             eigbinv=1.1
+ nigbinv=1                 aigc=0.0103               bigc=0.001525
+ cigc=0                    aigsd=0.00845             bigsd=0.0004021
+ cigsd=0.001463            nigc=1                    poxedge=1
+ pigcd=2.3                 ntox=ntoxn                xrcrg1=12
+ xrcrg2=1                  cgso=cgon                 cgdo=cgon
+ cgbo=0                    cgdl=cgln                 cgsl=cgln
+ clc=1e-007                cle=0.6                   cf=cfn
+ ckappas=0.6               acde=1.2                  moin=12.6
+ noff=1.686                voffcv=-0.05472           kt1=-0.20699116
+ lkt1=-1.1044067e-008      wkt1=4.1843174e-026       pkt1=-4.1675801e-031
+ kt1l=0                    kt2=-0.04464              ute=-1.4863588
+ lute=4.4658543e-008       wute=1.8005238e-008       pute=6.7268498e-015
+ ua1=2.684e-009            ub1=-3.673e-018           uc1=-6.421e-011
+ prt=0                     at=45000                  jss=1.77e-07
+ jsws=4.23e-13             jswgs=9e-12               njs=1
+ ijthsfwd=0.01             ijthsrev=0.01             bvs=10
+ xjbvs=1                   pbs=0.5                   cjs=cjn
+ mjs=0.25                  pbsws=0.8                 cjsws=cjswn
+ mjsws=0.01                pbswgs=0.78               cjswgs=cjswgn
+ mjswgs=0.52               tpb=1.00e-03              tcj=7.32e-04
+ tpbsw=1.90e-03            tcjsw=3.57e-04            tpbswg=1.90e-03
+ tcjswg=3.57e-04           xtis=3                    dmcg=9.25e-008
+ dmci=9.25e-008            dmdg=0                    dmcgt=0
+ dwj=0                     xgw=0                     xgl=0
+ rshg=0.1                  gbmin=1e-012              rbpb=50
+ rbpd=50                   rbps=50                   rbdb=50
+ rbsb=50                   ngcon=1                   saref=0.63e-6
+ sbref=0.63e-6             kvsat=0.20                wlod=0.8e-6
+ tku0=0.01                 ku0=-7.36e-8              llodku0=1
+ wlodku0=1                 lku0=4.027e-7             wku0=8e-7
+ pku0=-2.0e-13             kvth0=3.5e-9              stk2=1.35e-9
+ steta0=0                  lkvth0=-2.68e-11          wkvth0=1.5e-6
+ pkvth0=0                  llodvth=1                 wlodvth=1
+ lodk2=0.5                 lodeta0=1                 fnoimod=1
+ noia=4.2926e+41           noib=1.612e+24            noic=8.75
+ em=1.192e+07              ef=0.8841                 wpemod=wpeflag
+ kvth0we=0.00323           lkvth0we=0                wkvth0we=0
+ pkvth0we=0                ku0we=-0.003              lku0we=4.00e-10
+ wku0we=0                  pku0we=0                  k2we=0.0016
+ wk2we=0                   web=-210                  wec=-3500
+ scref=1.00e-06            ud=0                      tnoimod=0
+ minr=1e-3

     19: type=n
+ lmin=2.4000e-07-dxln      lmax=5.0000e-07-dxln      wmin=1.20e-07
+ wmax=2.4000e-07-dxwn      version=4.5               binunit=2
+ paramchk=1                mobmod=0                  capmod=2
+ igcmod=1                  igbmod=1                  diomod=1
+ rdsmod=0                  rbodymod=0                rgatemod=0
+ permod=1                  acnqsmod=0                trnqsmod=0
+ tnom=25                   toxe=toxn                 toxm=toxn
+ dtox=3e-010               epsrox=3.9                wint=6e-009
+ lint=2.5e-009             ll=0                      wl=0
+ lln=1                     wln=1                     lw=0
+ ww=0                      lwn=1                     wwn=1
+ lwl=0                     wwl=0                     llc=0
+ wlc=0                     lwc=0                     wwc=0
+ lwlc=0                    wwlc=0                    dlc=1.172e-008
+ dwc=0                     xpart=1                   toxref=3e-009
+ dlcig=2.5e-009            xl=-3.5e-08+dxln          xw=1.5e-8+dxwn
+ vth0=0.228+dvthn          wvth0=0+dwvthn            lvth0=0+dlvthn
+ pvth0=0+dpvthn            k1=0.3231                 k2=0.0087692308+dk2n
+ lk2=-3.5738462e-009       wk2=-7.6638462e-010       pk2=3.5253692e-016
+ k3=-2.5615385             lk3=-6.3692308e-008       k3b=1.2
+ w0=-5e-008                dvt0=13.9                 dvt1=1.25
+ dvt2=0                    dvt0w=0                   dvt1w=0
+ dvt2w=0                   dsub=0.5                  minv=0
+ voffl=0                   dvtp0=4e-007              dvtp1=2
+ lpe0=4.45e-008            lpeb=0                    xj=1.5e-007
+ ngate=4e020               ndep=8.3687e017           nsd=1e020
+ phin=0                    cdsc=0                    cdscb=0
+ cdscd=0                   cit=-0.00076923077        lcit=3.5384615e-010
+ voff=-0.12677327          lvoff=-8.3003462e-009     wvoff=2.9524967e-009
+ pvoff=5.5524565e-016+dpvoffn                        nfactor=0.5
+ eta0=0.219825             weta0=-1.8182475e-008     peta0=0+dpeta0n
+ etab=-0.1                 u0=0.029645               wu0=-4.48335e-010
+ ua=-6.284e-010            ub=1.2755212e-018         lub=-4.7309231e-026
+ wub=1.0135437e-026        pub=5.9931277e-033        uc=1.8331696e-010
+ luc=-2.5461442e-017       wuc=-1.5404714e-017       puc=4.2172229e-024
+ vsat=114000               a0=2.375                  ags=1.3923077
+ pvsat=0+dpvsatn           lags=-8.8461538e-008      a1=0
+ a2=1                      b0=0                      b1=0
+ keta=-0.058846154         lketa=6.3692308e-009      dwg=0
+ dwb=0                     pclm=0.84                 pdiblc1=0
+ pdiblc2=0.0001            pdiblcb=0                 drout=0
+ pvag=1.5                  delta=0.0075              pscbe1=9.264e008
+ pscbe2=1e-020             fprout=200                pdits=0
+ pditsd=0                  pditsl=0                  rsh=10.5
+ rdsw=140                  prwg=0                    prwb=0
+ wr=1                      alpha0=0                  alpha1=0.03
+ beta0=8.7                 agidl=9e-008              bgidl=2.3e009
+ cgidl=0.5                 egidl=0.53                aigbacc=0.01134
+ bigbacc=0.003249          cigbacc=0.1416            nigbacc=4.05
+ aigbinv=0.35              bigbinv=0.03              cigbinv=0.006
+ eigbinv=1.1               nigbinv=1                 aigc=0.0103
+ bigc=0.001525             cigc=0                    aigsd=0.00845
+ bigsd=0.0004021           cigsd=0.001463            nigc=1
+ poxedge=1                 pigcd=2.3                 ntox=ntoxn
+ xrcrg1=12                 xrcrg2=1                  cgso=cgon
+ cgdo=cgon                 cgbo=0                    cgdl=cgln
+ cgsl=cgln                 clc=1e-007                cle=0.6
+ cf=cfn                    ckappas=0.6               acde=1.2
+ moin=12.6                 noff=1.686                voffcv=-0.05472
+ kt1=-0.20061538           lkt1=-1.3976923e-008      kt1l=0
+ kt2=-0.04464              ute=-1.4587365            lute=3.1952308e-008
+ wute=5.0255671e-008       pute=-8.1083492e-015      ua1=2.684e-009
+ ub1=-3.673e-018           uc1=-1.0140769e-011       luc1=-2.4871846e-017
+ prt=0                     at=45000                  jss=1.77e-07
+ jsws=4.23e-13             jswgs=9e-12               njs=1
+ ijthsfwd=0.01             ijthsrev=0.01             bvs=10
+ xjbvs=1                   pbs=0.5                   cjs=cjn
+ mjs=0.25                  pbsws=0.8                 cjsws=cjswn
+ mjsws=0.01                pbswgs=0.78               cjswgs=cjswgn
+ mjswgs=0.52               tpb=1.00e-03              tcj=7.32e-04
+ tpbsw=1.90e-03            tcjsw=3.57e-04            tpbswg=1.90e-03
+ tcjswg=3.57e-04           xtis=3                    dmcg=9.25e-008
+ dmci=9.25e-008            dmdg=0                    dmcgt=0
+ dwj=0                     xgw=0                     xgl=0
+ rshg=0.1                  gbmin=1e-012              rbpb=50
+ rbpd=50                   rbps=50                   rbdb=50
+ rbsb=50                   ngcon=1                   saref=0.63e-6
+ sbref=0.63e-6             kvsat=0.20                wlod=0.8e-6
+ tku0=0.01                 ku0=-7.36e-8              llodku0=1
+ wlodku0=1                 lku0=4.027e-7             wku0=8e-7
+ pku0=-2.0e-13             kvth0=3.5e-9              stk2=1.35e-9
+ steta0=0                  lkvth0=-2.68e-11          wkvth0=1.5e-6
+ pkvth0=0                  llodvth=1                 wlodvth=1
+ lodk2=0.5                 lodeta0=1                 fnoimod=1
+ noia=4.2926e+41           noib=1.612e+24            noic=8.75
+ em=1.192e+07              ef=0.8841                 wpemod=wpeflag
+ kvth0we=0.00323           lkvth0we=0                wkvth0we=0
+ pkvth0we=0                ku0we=-0.003              lku0we=4.00e-10
+ wku0we=0                  pku0we=0                  k2we=0.0016
+ wk2we=0                   web=-210                  wec=-3500
+ scref=1.00e-06            ud=0                      tnoimod=0
+ minr=1e-3

     20: type=n
+ lmin=1.0e-07              lmax=2.4000e-07-dxln      wmin=1.20e-07
+ wmax=2.4000e-07-dxwn      version=4.5               binunit=2
+ paramchk=1                mobmod=0                  capmod=2
+ igcmod=1                  igbmod=1                  diomod=1
+ rdsmod=0                  rbodymod=0                rgatemod=0
+ permod=1                  acnqsmod=0                trnqsmod=0
+ tnom=25                   toxe=toxn                 toxm=toxn
+ dtox=3e-010               epsrox=3.9                wint=6e-009
+ lint=2.5e-009             ll=0                      wl=0
+ lln=1                     wln=1                     lw=0
+ ww=0                      lwn=1                     wwn=1
+ lwl=0                     wwl=0                     llc=0
+ wlc=0                     lwc=0                     wwc=0
+ lwlc=0                    wwlc=0                    dlc=1.172e-008
+ dwc=0                     xpart=1                   toxref=3e-009
+ dlcig=2.5e-009            xl=-3.5e-08+dxln          xw=1.5e-8+dxwn
+ vth0=0.228+dvthn          wvth0=0+dwvthn            lvth0=0+dlvthn
+ pvth0=0+dpvthn            k1=0.3006225              lk1=4.4955e-009
+ wk1=2.7647325e-009        pk1=-5.529465e-016        k2=-0.0041607143+dk2n
+ lk2=-9.8785714e-010       wk2=-1.245375e-009        pk2=4.48335e-016
+ k3=-2.9571429             lk3=1.5428571e-008        k3b=1.2
+ w0=-5e-008                dvt0=13.9                 dvt1=1.25
+ dvt2=0                    dvt0w=0                   dvt1w=0
+ dvt2w=0                   dsub=0.5                  minv=0
+ voffl=0                   dvtp0=4e-007              dvtp1=2
+ lpe0=4.45e-008            lpeb=0                    xj=1.5e-007
+ ngate=4e020               ndep=8.3687e017           nsd=1e020
+ phin=0                    cdsc=0                    cdscb=0
+ cdscd=0                   cit=-0.00012285714        lcit=2.2457143e-010
+ voff=-0.16377286          lvoff=-9.0042857e-010     wvoff=6.5613471e-009
+ pvoff=-1.6652443e-016+dpvoffn                       nfactor=0.5
+ eta0=0.219825             weta0=-1.8182475e-008     peta0=0+dpeta0n
+ etab=-0.1                 u0=0.029645               wu0=-4.48335e-010
+ ua=-6.284e-010            ub=9.2968929e-019         lub=2.1857143e-026
+ wub=3.5831218e-026        pub=8.5397143e-034        uc=5.8981786e-011
+ luc=-5.9440714e-019       wuc=3.7396832e-018        puc=3.8834351e-025
+ vsat=114000               a0=2.375                  ags=0.95
+ pvsat=0+dpvsatn           a1=0                      a2=1
+ b0=0                      b1=0                      keta=-0.044142857
+ lketa=3.4285714e-009      dwg=0                     dwb=0
+ pclm=0.87953571           lpclm=-7.9071429e-009     wpclm=-9.6071786e-009
+ ppclm=1.9214357e-015      pdiblc1=0                 pdiblc2=0.0001
+ pdiblcb=0                 drout=0                   pvag=1.5
+ delta=0.0075              pscbe1=9.264e008          pscbe2=1e-020
+ fprout=200                pdits=0                   pditsd=0
+ pditsl=0                  rsh=10.5                  rdsw=140
+ prwg=0                    prwb=0                    wr=1
+ alpha0=0                  alpha1=0.03               beta0=8.7
+ agidl=9e-008              bgidl=2.3e009             cgidl=0.5
+ egidl=0.53                aigbacc=0.01134           bigbacc=0.003249
+ cigbacc=0.1416            nigbacc=4.05              aigbinv=0.35
+ bigbinv=0.03              cigbinv=0.006             eigbinv=1.1
+ nigbinv=1                 aigc=0.0103               bigc=0.001525
+ cigc=0                    aigsd=0.00845             bigsd=0.0004021
+ cigsd=0.001463            nigc=1                    poxedge=1
+ pigcd=2.3                 ntox=ntoxn                xrcrg1=12
+ xrcrg2=1                  cgso=cgon                 cgdo=cgon
+ cgbo=0                    cgdl=cgln                 cgsl=cgln
+ clc=1e-007                cle=0.6                   cf=cfn
+ ckappas=0.6               acde=1.2                  moin=12.6
+ noff=1.686                voffcv=-0.05472           kt1=-0.2624
+ lkt1=-1.62e-009           kt1l=0                    kt2=-0.04464
+ ute=-1.3291357            lute=6.0321429e-009       wute=7.0452643e-009
+ pute=5.3373214e-016       ua1=2.684e-009            ub1=-3.673e-018
+ uc1=-1.6462429e-010       luc1=6.0248571e-018       prt=0
+ at=35357.143              lat=0.0019285714          jss=1.77e-07
+ jsws=4.23e-13             jswgs=9e-12               njs=1
+ ijthsfwd=0.01             ijthsrev=0.01             bvs=10
+ xjbvs=1                   pbs=0.5                   cjs=cjn
+ mjs=0.25                  pbsws=0.8                 cjsws=cjswn
+ mjsws=0.01                pbswgs=0.78               cjswgs=cjswgn
+ mjswgs=0.52               tpb=1.00e-03              tcj=7.32e-04
+ tpbsw=1.90e-03            tcjsw=3.57e-04            tpbswg=1.90e-03
+ tcjswg=3.57e-04           xtis=3                    dmcg=9.25e-008
+ dmci=9.25e-008            dmdg=0                    dmcgt=0
+ dwj=0                     xgw=0                     xgl=0
+ rshg=0.1                  gbmin=1e-012              rbpb=50
+ rbpd=50                   rbps=50                   rbdb=50
+ rbsb=50                   ngcon=1                   saref=0.63e-6
+ sbref=0.63e-6             kvsat=0.20                wlod=0.8e-6
+ tku0=0.01                 ku0=-7.36e-8              llodku0=1
+ wlodku0=1                 lku0=4.027e-7             wku0=8e-7
+ pku0=-2.0e-13             kvth0=3.5e-9              stk2=1.35e-9
+ steta0=0                  lkvth0=-2.68e-11          wkvth0=1.5e-6
+ pkvth0=0                  llodvth=1                 wlodvth=1
+ lodk2=0.5                 lodeta0=1                 fnoimod=1
+ noia=4.2926e+41           noib=1.612e+24            noic=8.75
+ em=1.192e+07              ef=0.8841                 wpemod=wpeflag
+ kvth0we=0.00323           lkvth0we=0                wkvth0we=0
+ pkvth0we=0                ku0we=-0.003              lku0we=4.00e-10
+ wku0we=0                  pku0we=0                  k2we=0.0016
+ wk2we=0                   web=-210                  wec=-3500
+ scref=1.00e-06            ud=0                      tnoimod=0
+ minr=1e-3

//  *****************************************************************************************
//
//             *
//                             1.0V STANDARD VT PMOS DEVICE MODELS
//             *
//
//             *
//  *****************************************************************************************

     }
model pch bsim4  {
     1: type=p
+ lmin=1.0000e-05-dxlp      lmax=2.001e-05            wmin=1.0000e-05-dxwp
+ wmax=9.001e-04            version=4.5               binunit=2
+ paramchk=1                mobmod=0                  capmod=2
+ igcmod=1                  igbmod=1                  diomod=1
+ rdsmod=0                  rbodymod=0                rgatemod=0
+ permod=1                  acnqsmod=0                trnqsmod=0
+ tnom=25                   toxe=toxp                 toxm=toxp
+ dtox=5.25e-010            epsrox=3.9                wint=5e-009
+ lint=2.5e-009             ll=0                      wl=0
+ lln=1                     wln=1                     lw=0
+ ww=0                      lwn=1                     wwn=1
+ lwl=0                     wwl=0                     llc=0
+ wlc=0                     lwc=0                     wwc=0
+ lwlc=0                    wwlc=0                    dlc=1.525e-008
+ dwc=0                     xpart=1                   toxref=3e-009
+ dlcig=2.5e-009            xl=-3.5e-08+dxlp          xw=1.5e-8+dxwp
+ vth0=-0.1652+dvthp        wvth0=0+dwvthp            lvth0=0+dlvthp
+ pvth0=0+dpvthp            k1=0.1623                 k2=0.0127+dk2p
+ k3=-0.58                  k3b=0.8                   w0=0
+ dvt0=10                   dvt1=1.71                 dvt2=0.0928
+ dvt0w=0                   dvt1w=0                   dvt2w=0
+ dsub=0.5                  minv=0                    voffl=0
+ dvtp0=0                   dvtp1=0                   lpe0=2.805e-007
+ lpeb=1e-007               xj=1.7000001e-007         ngate=8e019
+ ndep=1.7200001e017        nsd=1e020                 phin=0
+ cdsc=0                    cdscb=0                   cdscd=0
+ lcdscd=0+dlcdscdp         cit=0                     voff=-0.09669
+ nfactor=0.5               lvoff=0+dlvoffp           eta0=0.085
+ etab=-0.02                u0=0.008462               ua=-2.764e-010
+ ub=2.003e-018             uc=8.136e-011             vsat=120000
+ a0=3.62                   ags=1.096                 a1=0
+ a2=1                      b0=0                      b1=0
+ keta=-0.04058             dwg=0                     dwb=0
+ pclm=0.2                  pdiblc1=0                 pdiblc2=0.005
+ pdiblcb=0                 drout=0                   pvag=0
+ delta=0.02                pscbe1=9.264e008          pscbe2=1e-020
+ fprout=1000               pdits=0                   pditsd=0
+ pditsl=0                  rsh=9.68                  rdsw=210+drdswp
+ prwg=0                    prwb=0                    wr=1
+ alpha0=0                  alpha1=0.06               beta0=12
+ agidl=9e-008              bgidl=2.3e009             cgidl=0.5
+ egidl=0.53                aigbacc=0.01069           bigbacc=0.003132
+ cigbacc=0.1498            nigbacc=4.049             aigbinv=0.35
+ bigbinv=0.03              cigbinv=0.006             eigbinv=1.1
+ nigbinv=1                 aigc=0.00606              bigc=0.0007625
+ cigc=1e-010               aigsd=0.00459             bigsd=0
+ cigsd=0.002267            nigc=1                    poxedge=1
+ pigcd=2.3                 ntox=ntoxp                xrcrg1=12
+ xrcrg2=1                  cgso=cgop                 cgdo=cgop
+ cgbo=0                    cgdl=cglp                 cgsl=cglp
+ clc=1e-007                cle=0.6                   cf=cfp
+ ckappas=0.6               acde=1.2                  moin=11.09
+ noff=2.175                voffcv=-0.03885           kt1=-0.2898
+ kt1l=0                    kt2=-0.02958              ute=-1.187
+ ua1=4.079e-009            ub1=-7.644e-018           uc1=-6.421e-011
+ prt=0                     at=280000                 jss=1.245e-07
+ jsws=3.77e-13             jswgs=3.00e-12            njs=1
+ ijthsfwd=0.01             ijthsrev=0.01             bvs=10
+ xjbvs=1                   pbs=0.8                   cjs=cjp
+ mjs=0.36                  pbsws=0.8                 cjsws=cjswp
+ mjsws=0.01                pbswgs=1                  cjswgs=cjswgp
+ mjswgs=0.98               tpb=1.9e-03               tcj=8.54e-04
+ tpbsw=1.9e-03             tcjsw=3.57e-04            tpbswg=1.9e-03
+ tcjswg=3.12e-03           xtis=3                    dmcg=9.25e-008
+ dmci=9.25e-008            dmdg=0                    dmcgt=0
+ dwj=0                     xgw=0                     xgl=0
+ rshg=0.1                  gbmin=1e-012              rbpb=50
+ rbpd=50                   rbps=50                   rbdb=50
+ rbsb=50                   ngcon=1                   saref=0.63e-6
+ sbref=0.63e-6             kvsat=-0.9                wlod=0.8e-6
+ tku0=0.1                  ku0=1.3249e-7             llodku0=1
+ wlodku0=1                 lku0=1.33e-7              wku0=6.5e-7
+ pku0=0                    kvth0=-1.5e-9             stk2=4e-10
+ steta0=0                  lkvth0=-1.68e-15          wkvth0=0.5e-6
+ pkvth0=0                  llodvth=2                 wlodvth=1
+ lodk2=2                   lodeta0=1                 fnoimod=1
+ noia=1.635e+42            noib=7.241e+26            noic=8.75
+ em=1.50e+08               ef=1.19                   wpemod=wpeflag
+ kvth0we=-0.0028           lkvth0we=0                wkvth0we=0
+ pkvth0we=0                ku0we=-0.0045             lku0we=3.00e-10
+ wku0we=0                  pku0we=0                  k2we=0.00045
+ wk2we=0                   web=-180                  wec=-3000
+ scref=1.00e-06            ud=0                      tnoimod=0
+ minr=1e-3

     2: type=p
+ lmin=1.2000e-06-dxlp      lmax=1.0000e-05-dxlp      wmin=1.0000e-05-dxwp
+ wmax=9.001e-04            version=4.5               binunit=2
+ paramchk=1                mobmod=0                  capmod=2
+ igcmod=1                  igbmod=1                  diomod=1
+ rdsmod=0                  rbodymod=0                rgatemod=0
+ permod=1                  acnqsmod=0                trnqsmod=0
+ tnom=25                   toxe=toxp                 toxm=toxp
+ dtox=5.25e-010            epsrox=3.9                wint=5e-009
+ lint=2.5e-009             ll=0                      wl=0
+ lln=1                     wln=1                     lw=0
+ ww=0                      lwn=1                     wwn=1
+ lwl=0                     wwl=0                     llc=0
+ wlc=0                     lwc=0                     wwc=0
+ lwlc=0                    wwlc=0                    dlc=1.525e-008
+ dwc=0                     xpart=1                   toxref=3e-009
+ dlcig=2.5e-009            xl=-3.5e-08+dxlp          xw=1.5e-8+dxwp
+ vth0=-0.16469909+dvthp    wvth0=0+dwvthp            lvth0=-4.9890545e-009+dlvthp
+ pvth0=0+dpvthp            k1=0.1623                 k2=0.010577727+dk2p
+ lk2=2.1137836e-008        k3=-0.58                  k3b=0.8
+ w0=0                      dvt0=10                   dvt1=1.71
+ dvt2=0.0928               dvt0w=0                   dvt1w=0
+ dvt2w=0                   dsub=0.5                  minv=0
+ voffl=0                   dvtp0=0                   dvtp1=0
+ lpe0=2.805e-007           lpeb=1e-007               xj=1.7000001e-007
+ ngate=8e019               ndep=1.7200001e017        nsd=1e020
+ phin=0                    cdsc=0                    cdscb=0
+ cdscd=0                   lcdscd=0+dlcdscdp         cit=-0.00013181818
+ lcit=1.3129091e-009       voff=-0.096844227         lvoff=1.5361036e-009+dlvoffp
+ nfactor=0.5               eta0=0.085                etab=-0.02
+ u0=0.0083917409           lu0=6.9978055e-010        ua=-2.764e-010
+ ub=2.0135455e-018         lub=-1.0503273e-025       uc=8.1308591e-011
+ luc=5.1203455e-019        vsat=120000               a0=3.62
+ ags=1.0109773             lags=8.4682636e-007       a1=0
+ a2=1                      b0=0                      b1=0
+ keta=-0.032444182         lketa=-8.1032749e-008     dwg=0
+ dwb=0                     pclm=0.094545455          lpclm=1.0503273e-006
+ pdiblc1=0                 pdiblc2=0.005             pdiblcb=0
+ drout=0                   pvag=0                    delta=0.02
+ pscbe1=9.264e008          pscbe2=1e-020             fprout=1000
+ pdits=0                   pditsd=0                  pditsl=0
+ rsh=9.68                  rdsw=210+drdswp           prwg=0
+ prwb=0                    wr=1                      alpha0=0
+ alpha1=0.06               beta0=12                  agidl=9e-008
+ bgidl=2.3e009             cgidl=0.5                 egidl=0.53
+ aigbacc=0.01069           bigbacc=0.003132          cigbacc=0.1498
+ nigbacc=4.049             aigbinv=0.35              bigbinv=0.03
+ cigbinv=0.006             eigbinv=1.1               nigbinv=1
+ aigc=0.00606              bigc=0.0007625            cigc=1e-010
+ aigsd=0.00459             bigsd=0                   cigsd=0.002267
+ nigc=1                    poxedge=1                 pigcd=2.3
+ ntox=ntoxp                xrcrg1=12                 xrcrg2=1
+ cgso=cgop                 cgdo=cgop                 cgbo=0
+ cgdl=cglp                 cgsl=cglp                 clc=1e-007
+ cle=0.6                   cf=cfp                    ckappas=0.6
+ acde=1.2                  moin=11.09                noff=2.175
+ voffcv=-0.03885           kt1=-0.2898               kt1l=0
+ kt2=-0.02958              ute=-1.1975455            lute=1.0503273e-007
+ ua1=4.2147727e-009        lua1=-1.3522964e-015      ub1=-8.0252182e-018
+ lub1=3.7969331e-024       uc1=-6.421e-011           prt=0
+ at=280000                 jss=1.245e-07             jsws=3.77e-13
+ jswgs=3.00e-12            njs=1                     ijthsfwd=0.01
+ ijthsrev=0.01             bvs=10                    xjbvs=1
+ pbs=0.8                   cjs=cjp                   mjs=0.36
+ pbsws=0.8                 cjsws=cjswp               mjsws=0.01
+ pbswgs=1                  cjswgs=cjswgp             mjswgs=0.98
+ tpb=1.9e-03               tcj=8.54e-04              tpbsw=1.9e-03
+ tcjsw=3.57e-04            tpbswg=1.9e-03            tcjswg=3.12e-03
+ xtis=3                    dmcg=9.25e-008            dmci=9.25e-008
+ dmdg=0                    dmcgt=0                   dwj=0
+ xgw=0                     xgl=0                     rshg=0.1
+ gbmin=1e-012              rbpb=50                   rbpd=50
+ rbps=50                   rbdb=50                   rbsb=50
+ ngcon=1                   saref=0.63e-6             sbref=0.63e-6
+ kvsat=-0.9                wlod=0.8e-6               tku0=0.1
+ ku0=1.3249e-7             llodku0=1                 wlodku0=1
+ lku0=1.33e-7              wku0=6.5e-7               pku0=0
+ kvth0=-1.5e-9             stk2=4e-10                steta0=0
+ lkvth0=-1.68e-15          wkvth0=0.5e-6             pkvth0=0
+ llodvth=2                 wlodvth=1                 lodk2=2
+ lodeta0=1                 fnoimod=1                 noia=1.635e+42
+ noib=7.241e+26            noic=8.75                 em=1.50e+08
+ ef=1.19                   wpemod=wpeflag            kvth0we=-0.0028
+ lkvth0we=0                wkvth0we=0                pkvth0we=0
+ ku0we=-0.0045             lku0we=3.00e-10           wku0we=0
+ pku0we=0                  k2we=0.00045              wk2we=0
+ web=-180                  wec=-3000                 scref=1.00e-06
+ ud=0                      tnoimod=0                 minr=1e-3

     3: type=p
+ lmin=5.0000e-07-dxlp      lmax=1.2000e-06-dxlp      wmin=1.0000e-05-dxwp
+ wmax=9.001e-04            version=4.5               binunit=2
+ paramchk=1                mobmod=0                  capmod=2
+ igcmod=1                  igbmod=1                  diomod=1
+ rdsmod=0                  rbodymod=0                rgatemod=0
+ permod=1                  acnqsmod=0                trnqsmod=0
+ tnom=25                   toxe=toxp                 toxm=toxp
+ dtox=5.25e-010            epsrox=3.9                wint=5e-009
+ lint=2.5e-009             ll=0                      wl=0
+ lln=1                     wln=1                     lw=0
+ ww=0                      lwn=1                     wwn=1
+ lwl=0                     wwl=0                     llc=0
+ wlc=0                     lwc=0                     wwc=0
+ lwlc=0                    wwlc=0                    dlc=1.525e-008
+ dwc=0                     xpart=1                   toxref=3e-009
+ dlcig=2.5e-009            xl=-3.5e-08+dxlp          xw=1.5e-8+dxwp
+ vth0=-0.15506857+dvthp    wvth0=0+dwvthp            lvth0=-1.6160457e-008+dlvthp
+ pvth0=0+dpvthp            k1=0.1623                 k2=0.024331429+dk2p
+ lk2=5.1835429e-009        k3=-0.58                  k3b=0.8
+ w0=0                      dvt0=10                   dvt1=1.71
+ dvt2=0.0928               dvt0w=0                   dvt1w=0
+ dvt2w=0                   dsub=0.5                  minv=0
+ voffl=0                   dvtp0=0                   dvtp1=0
+ lpe0=2.805e-007           lpeb=1e-007               xj=1.7000001e-007
+ ngate=8e019               ndep=1.7200001e017        nsd=1e020
+ phin=0                    cdsc=0                    cdscb=0
+ cdscd=0                   lcdscd=0+dlcdscdp         cit=0.001
+ voff=-0.079696            lvoff=-1.835584e-008+dlvoffp
+ nfactor=0.5               eta0=0.085                etab=-0.02
+ u0=0.0086348857           lu0=4.1773257e-010        ua=-4.4085714e-012
+ lua=-3.1551006e-016       ub=1.4998e-018            lub=4.90912e-025
+ uc=6.7194286e-011         luc=1.6884629e-017        vsat=120000
+ a0=3.62                   ags=0.92877143            lags=9.4218514e-007
+ a1=0                      a2=1                      b0=0
+ b1=0                      keta=-0.068654286         lketa=-3.9029029e-008
+ dwg=0                     dwb=0                     pclm=1
+ pdiblc1=0                 pdiblc2=0.005             pdiblcb=0
+ drout=0                   pvag=0                    delta=0.02
+ pscbe1=9.264e008          pscbe2=1e-020             fprout=1000
+ pdits=0                   pditsd=0                  pditsl=0
+ rsh=9.68                  rdsw=210+drdswp           prwg=0
+ prwb=0                    wr=1                      alpha0=0
+ alpha1=0.06               beta0=12                  agidl=9e-008
+ bgidl=2.3e009             cgidl=0.5                 egidl=0.53
+ aigbacc=0.01069           bigbacc=0.003132          cigbacc=0.1498
+ nigbacc=4.049             aigbinv=0.35              bigbinv=0.03
+ cigbinv=0.006             eigbinv=1.1               nigbinv=1
+ aigc=0.00606              bigc=0.0007625            cigc=1e-010
+ aigsd=0.00459             bigsd=0                   cigsd=0.002267
+ nigc=1                    poxedge=1                 pigcd=2.3
+ ntox=ntoxp                xrcrg1=12                 xrcrg2=1
+ cgso=cgop                 cgdo=cgop                 cgbo=0
+ cgdl=cglp                 cgsl=cglp                 clc=1e-007
+ cle=0.6                   cf=cfp                    ckappas=0.6
+ acde=1.2                  moin=11.09                noff=2.175
+ voffcv=-0.03885           kt1=-0.2898               kt1l=0
+ kt2=-0.02958              ute=-0.78434286           lute=-3.7428229e-007
+ ua1=4.2390857e-009        lua1=-1.3804994e-015      ub1=-5.3513143e-018
+ lub1=6.9520457e-025       uc1=-6.421e-011           prt=0
+ at=282694.29              lat=-0.0031253714         jss=1.245e-07
+ jsws=3.77e-13             jswgs=3.00e-12            njs=1
+ ijthsfwd=0.01             ijthsrev=0.01             bvs=10
+ xjbvs=1                   pbs=0.8                   cjs=cjp
+ mjs=0.36                  pbsws=0.8                 cjsws=cjswp
+ mjsws=0.01                pbswgs=1                  cjswgs=cjswgp
+ mjswgs=0.98               tpb=1.9e-03               tcj=8.54e-04
+ tpbsw=1.9e-03             tcjsw=3.57e-04            tpbswg=1.9e-03
+ tcjswg=3.12e-03           xtis=3                    dmcg=9.25e-008
+ dmci=9.25e-008            dmdg=0                    dmcgt=0
+ dwj=0                     xgw=0                     xgl=0
+ rshg=0.1                  gbmin=1e-012              rbpb=50
+ rbpd=50                   rbps=50                   rbdb=50
+ rbsb=50                   ngcon=1                   saref=0.63e-6
+ sbref=0.63e-6             kvsat=-0.9                wlod=0.8e-6
+ tku0=0.1                  ku0=1.3249e-7             llodku0=1
+ wlodku0=1                 lku0=1.33e-7              wku0=6.5e-7
+ pku0=0                    kvth0=-1.5e-9             stk2=4e-10
+ steta0=0                  lkvth0=-1.68e-15          wkvth0=0.5e-6
+ pkvth0=0                  llodvth=2                 wlodvth=1
+ lodk2=2                   lodeta0=1                 fnoimod=1
+ noia=1.635e+42            noib=7.241e+26            noic=8.75
+ em=1.50e+08               ef=1.19                   wpemod=wpeflag
+ kvth0we=-0.0028           lkvth0we=0                wkvth0we=0
+ pkvth0we=0                ku0we=-0.0045             lku0we=3.00e-10
+ wku0we=0                  pku0we=0                  k2we=0.00045
+ wk2we=0                   web=-180                  wec=-3000
+ scref=1.00e-06            ud=0                      tnoimod=0
+ minr=1e-3

     4: type=p
+ lmin=2.4000e-07-dxlp      lmax=5.0000e-07-dxlp      wmin=1.0000e-05-dxwp
+ wmax=9.001e-04            version=4.5               binunit=2
+ paramchk=1                mobmod=0                  capmod=2
+ igcmod=1                  igbmod=1                  diomod=1
+ rdsmod=0                  rbodymod=0                rgatemod=0
+ permod=1                  acnqsmod=0                trnqsmod=0
+ tnom=25                   toxe=toxp                 toxm=toxp
+ dtox=5.25e-010            epsrox=3.9                wint=5e-009
+ lint=2.5e-009             ll=0                      wl=0
+ lln=1                     wln=1                     lw=0
+ ww=0                      lwn=1                     wwn=1
+ lwl=0                     wwl=0                     llc=0
+ wlc=0                     lwc=0                     wwc=0
+ lwlc=0                    wwlc=0                    dlc=1.525e-008
+ dwc=0                     xpart=1                   toxref=3e-009
+ dlcig=2.5e-009            xl=-3.5e-08+dxlp          xw=1.5e-8+dxwp
+ vth0=-0.20381538+dvthp    wvth0=0+dwvthp            lvth0=6.2630769e-009+dlvthp
+ pvth0=0+dpvthp            k1=0.1623                 k2=0.036830769+dk2p
+ lk2=-5.6615385e-010       k3=-0.58                  k3b=0.8
+ w0=0                      dvt0=10                   dvt1=1.71
+ dvt2=0.0928               dvt0w=0                   dvt1w=0
+ dvt2w=0                   dsub=0.5                  minv=0
+ voffl=0                   dvtp0=0                   dvtp1=0
+ lpe0=2.805e-007           lpeb=1e-007               xj=1.7000001e-007
+ ngate=8e019               ndep=1.7200001e017        nsd=1e020
+ phin=0                    cdsc=0                    cdscb=0
+ cdscd=0                   lcdscd=0+dlcdscdp         cit=0.001
+ voff=-0.11375385          lvoff=-2.6892308e-009+dlvoffp
+ nfactor=0.34615385        lnfactor=7.0769231e-008   eta0=0.050384615
+ leta0=1.5923077e-008      etab=-0.02                u0=0.0096883846
+ lu0=-6.6876923e-011       ua=-6.9199231e-010        lua=7.7846154e-019
+ ub=2.477e-018             lub=4.14e-026             uc=9.0284615e-011
+ luc=6.2630769e-018        vsat=120000               a0=3.62
+ ags=-0.19915385           lags=1.4610308e-006       a1=0
+ a2=1                      b0=0                      b1=0
+ keta=-0.1405              lketa=-5.98e-009          dwg=0
+ dwb=0                     pclm=1.3769231            lpclm=-1.7338462e-007
+ pdiblc1=0                 pdiblc2=0.005             pdiblcb=0
+ drout=0                   pvag=0                    delta=0.02
+ pscbe1=9.264e008          pscbe2=1e-020             fprout=1000
+ pdits=0                   pditsd=0                  pditsl=0
+ rsh=9.68                  rdsw=210+drdswp           prwg=0
+ prwb=0                    wr=1                      alpha0=0
+ alpha1=0.06               beta0=12                  agidl=9e-008
+ bgidl=2.3e009             cgidl=0.5                 egidl=0.53
+ aigbacc=0.01069           bigbacc=0.003132          cigbacc=0.1498
+ nigbacc=4.049             aigbinv=0.35              bigbinv=0.03
+ cigbinv=0.006             eigbinv=1.1               nigbinv=1
+ aigc=0.00606              bigc=0.0007625            cigc=1e-010
+ aigsd=0.00459             bigsd=0                   cigsd=0.002267
+ nigc=1                    poxedge=1                 pigcd=2.3
+ ntox=ntoxp                xrcrg1=12                 xrcrg2=1
+ cgso=cgop                 cgdo=cgop                 cgbo=0
+ cgdl=cglp                 cgsl=cglp                 clc=1e-007
+ cle=0.6                   cf=cfp                    ckappas=0.6
+ acde=1.2                  moin=11.09                noff=2.175
+ voffcv=-0.03885           kt1=-0.30764615           lkt1=8.2092308e-009
+ kt1l=0                    kt2=-0.022526154          lkt2=-3.2447692e-009
+ ute=-1.7964615            lute=9.1292308e-008       ua1=7.6184615e-010
+ lua1=2.1903077e-016       ub1=-3.7176923e-018       lub1=-5.6261538e-026
+ uc1=-6.421e-011           prt=0                     at=354438.46
+ lat=-0.036127692          jss=1.245e-07             jsws=3.77e-13
+ jswgs=3.00e-12            njs=1                     ijthsfwd=0.01
+ ijthsrev=0.01             bvs=10                    xjbvs=1
+ pbs=0.8                   cjs=cjp                   mjs=0.36
+ pbsws=0.8                 cjsws=cjswp               mjsws=0.01
+ pbswgs=1                  cjswgs=cjswgp             mjswgs=0.98
+ tpb=1.9e-03               tcj=8.54e-04              tpbsw=1.9e-03
+ tcjsw=3.57e-04            tpbswg=1.9e-03            tcjswg=3.12e-03
+ xtis=3                    dmcg=9.25e-008            dmci=9.25e-008
+ dmdg=0                    dmcgt=0                   dwj=0
+ xgw=0                     xgl=0                     rshg=0.1
+ gbmin=1e-012              rbpb=50                   rbpd=50
+ rbps=50                   rbdb=50                   rbsb=50
+ ngcon=1                   saref=0.63e-6             sbref=0.63e-6
+ kvsat=-0.9                wlod=0.8e-6               tku0=0.1
+ ku0=1.3249e-7             llodku0=1                 wlodku0=1
+ lku0=1.33e-7              wku0=6.5e-7               pku0=0
+ kvth0=-1.5e-9             stk2=4e-10                steta0=0
+ lkvth0=-1.68e-15          wkvth0=0.5e-6             pkvth0=0
+ llodvth=2                 wlodvth=1                 lodk2=2
+ lodeta0=1                 fnoimod=1                 noia=1.635e+42
+ noib=7.241e+26            noic=8.75                 em=1.50e+08
+ ef=1.19                   wpemod=wpeflag            kvth0we=-0.0028
+ lkvth0we=0                wkvth0we=0                pkvth0we=0
+ ku0we=-0.0045             lku0we=3.00e-10           wku0we=0
+ pku0we=0                  k2we=0.00045              wk2we=0
+ web=-180                  wec=-3000                 scref=1.00e-06
+ ud=0                      tnoimod=0                 minr=1e-3

     5: type=p
+ lmin=1.00e-07             lmax=2.4000e-07-dxlp      wmin=1.0000e-05-dxwp
+ wmax=9.001e-04            version=4.5               binunit=2
+ paramchk=1                mobmod=0                  capmod=2
+ igcmod=1                  igbmod=1                  diomod=1
+ rdsmod=0                  rbodymod=0                rgatemod=0
+ permod=1                  acnqsmod=0                trnqsmod=0
+ tnom=25                   toxe=toxp                 toxm=toxp
+ dtox=5.25e-010            epsrox=3.9                wint=5e-009
+ lint=2.5e-009             ll=0                      wl=0
+ lln=1                     wln=1                     lw=0
+ ww=0                      lwn=1                     wwn=1
+ lwl=0                     wwl=0                     llc=0
+ wlc=0                     lwc=0                     wwc=0
+ lwlc=0                    wwlc=0                    dlc=1.525e-008
+ dwc=0                     xpart=1                   toxref=3e-009
+ dlcig=2.5e-009            xl=-3.5e-08+dxlp          xw=1.5e-8+dxwp
+ vth0=-0.17828571+dvthp    wvth0=0+dwvthp            lvth0=1.1571429e-009+dlvthp
+ pvth0=0+dpvthp            k1=0.1623                 k2=0.035114286+dk2p
+ lk2=-2.2285714e-010       k3=-0.58                  k3b=0.8
+ w0=0                      dvt0=10                   dvt1=1.71
+ dvt2=0.0928               dvt0w=0                   dvt1w=0
+ dvt2w=0                   dsub=0.5                  minv=0
+ voffl=0                   dvtp0=0                   dvtp1=0
+ lpe0=2.805e-007           lpeb=1e-007               xj=1.7000001e-007
+ ngate=8e019               ndep=1.7200001e017        nsd=1e020
+ phin=0                    cdsc=0                    cdscb=0
+ cdscd=0                   lcdscd=0+dlcdscdp         cit=-0.00071428571
+ lcit=3.4285714e-010       voff=-0.11387143          lvoff=-2.6657143e-009+dlvoffp
+ nfactor=0.44285714        lnfactor=5.1428571e-008   eta0=0.14714286
+ leta0=-3.4285714e-009     etab=-0.0097142857        letab=-2.0571429e-009
+ u0=0.0093985714           lu0=-8.9142857e-012       ua=-8.1298571e-010
+ lua=2.4977143e-017        ub=2.6574286e-018         lub=5.3142857e-027
+ uc=7.18e-011              luc=9.96e-018             vsat=120000
+ a0=3.62                   ags=3.5171429             lags=7.1777143e-007
+ a1=0                      a2=1                      b0=0
+ b1=0                      keta=-0.23914286          lketa=1.3748571e-008
+ dwg=0                     dwb=0                     pclm=0.64285714
+ lpclm=-2.6571429e-008     pdiblc1=0                 pdiblc2=0.005
+ pdiblcb=0                 drout=0                   pvag=0
+ delta=0.02                pscbe1=9.264e008          pscbe2=1e-020
+ fprout=1000               pdits=0                   pditsd=0
+ pditsl=0                  rsh=9.68                  rdsw=210+drdswp
+ prwg=0                    prwb=0                    wr=1
+ alpha0=0                  alpha1=0.06               beta0=12
+ agidl=9e-008              bgidl=2.3e009             cgidl=0.5
+ egidl=0.53                aigbacc=0.01069           bigbacc=0.003132
+ cigbacc=0.1498            nigbacc=4.049             aigbinv=0.35
+ bigbinv=0.03              cigbinv=0.006             eigbinv=1.1
+ nigbinv=1                 aigc=0.00606              bigc=0.0007625
+ cigc=1e-010               aigsd=0.00459             bigsd=0
+ cigsd=0.002267            nigc=1                    poxedge=1
+ pigcd=2.3                 ntox=ntoxp                xrcrg1=12
+ xrcrg2=1                  cgso=cgop                 cgdo=cgop
+ cgbo=0                    cgdl=cglp                 cgsl=cglp
+ clc=1e-007                cle=0.6                   cf=cfp
+ ckappas=0.6               acde=1.2                  moin=11.09
+ noff=2.175                voffcv=-0.03885           kt1=-0.25631429
+ lkt1=-2.0571429e-009      kt1l=0                    kt2=-0.03875
+ ute=-1.25                 lute=-1.8e-008            ua1=2.0134286e-009
+ lua1=-3.1285714e-017      ub1=-3.8164286e-018       lub1=-3.6514286e-026
+ uc1=-6.421e-011           prt=0                     at=227401.43
+ lat=-0.010720286          jss=1.245e-07             jsws=3.77e-13
+ jswgs=3.00e-12            njs=1                     ijthsfwd=0.01
+ ijthsrev=0.01             bvs=10                    xjbvs=1
+ pbs=0.8                   cjs=cjp                   mjs=0.36
+ pbsws=0.8                 cjsws=cjswp               mjsws=0.01
+ pbswgs=1                  cjswgs=cjswgp             mjswgs=0.98
+ tpb=1.9e-03               tcj=8.54e-04              tpbsw=1.9e-03
+ tcjsw=3.57e-04            tpbswg=1.9e-03            tcjswg=3.12e-03
+ xtis=3                    dmcg=9.25e-008            dmci=9.25e-008
+ dmdg=0                    dmcgt=0                   dwj=0
+ xgw=0                     xgl=0                     rshg=0.1
+ gbmin=1e-012              rbpb=50                   rbpd=50
+ rbps=50                   rbdb=50                   rbsb=50
+ ngcon=1                   saref=0.63e-6             sbref=0.63e-6
+ kvsat=-0.9                wlod=0.8e-6               tku0=0.1
+ ku0=1.3249e-7             llodku0=1                 wlodku0=1
+ lku0=1.33e-7              wku0=6.5e-7               pku0=0
+ kvth0=-1.5e-9             stk2=4e-10                steta0=0
+ lkvth0=-1.68e-15          wkvth0=0.5e-6             pkvth0=0
+ llodvth=2                 wlodvth=1                 lodk2=2
+ lodeta0=1                 fnoimod=1                 noia=1.635e+42
+ noib=7.241e+26            noic=8.75                 em=1.50e+08
+ ef=1.19                   wpemod=wpeflag            kvth0we=-0.0028
+ lkvth0we=0                wkvth0we=0                pkvth0we=0
+ ku0we=-0.0045             lku0we=3.00e-10           wku0we=0
+ pku0we=0                  k2we=0.00045              wk2we=0
+ web=-180                  wec=-3000                 scref=1.00e-06
+ ud=0                      tnoimod=0                 minr=1e-3

     6: type=p
+ lmin=1.0000e-05-dxlp      lmax=2.001e-05            wmin=1.0000e-06-dxwp
+ wmax=1.0000e-05-dxwp      version=4.5               binunit=2
+ paramchk=1                mobmod=0                  capmod=2
+ igcmod=1                  igbmod=1                  diomod=1
+ rdsmod=0                  rbodymod=0                rgatemod=0
+ permod=1                  acnqsmod=0                trnqsmod=0
+ tnom=25                   toxe=toxp                 toxm=toxp
+ dtox=5.25e-010            epsrox=3.9                wint=5e-009
+ lint=2.5e-009             ll=0                      wl=0
+ lln=1                     wln=1                     lw=0
+ ww=0                      lwn=1                     wwn=1
+ lwl=0                     wwl=0                     llc=0
+ wlc=0                     lwc=0                     wwc=0
+ lwlc=0                    wwlc=0                    dlc=1.525e-008
+ dwc=0                     xpart=1                   toxref=3e-009
+ dlcig=2.5e-009            xl=-3.5e-08+dxlp          xw=1.5e-8+dxwp
+ vth0=-0.16574717+dvthp    wvth0=5.4744025e-009+dwvthp
+ lvth0=0+dlvthp            pvth0=0+dpvthp            k1=0.1623
+ k2=0.012789333+dk2p       wk2=-8.9378e-010          k3=-0.58
+ k3b=0.8                   w0=0                      dvt0=10
+ dvt1=1.71                 dvt2=0.0928               dvt0w=0
+ dvt1w=0                   dvt2w=0                   dsub=0.5
+ minv=0                    voffl=0                   dvtp0=0
+ dvtp1=0                   lpe0=2.805e-007           lpeb=1e-007
+ xj=1.7000001e-007         ngate=8e019               ndep=1.7200001e017
+ nsd=1e020                 phin=0                    cdsc=0
+ cdscb=0                   cdscd=0                   lcdscd=0+dlcdscdp
+ cit=0.00011166667         wcit=-1.117225e-009       voff=-0.09669
+ lvoff=0+dlvoffp           nfactor=0.5               eta0=0.085
+ etab=-0.02                u0=0.0085405017           wu0=-7.8540918e-010
+ ua=-2.77941e-010          wua=1.5417705e-017        ub=2.0172933e-018
+ wub=-1.430048e-025        uc=8.136e-011             vsat=120000
+ a0=3.62                   ags=1.096                 a1=0
+ a2=1                      b0=0                      b1=0
+ keta=-0.04058             dwg=0                     dwb=0
+ pclm=0.2                  pdiblc1=0                 pdiblc2=0.005
+ pdiblcb=0                 drout=0                   pvag=0
+ delta=0.02                pscbe1=9.264e008          pscbe2=1e-020
+ fprout=1000               pdits=0                   pditsd=0
+ pditsl=0                  rsh=9.68                  rdsw=210+drdswp
+ prwg=0                    prwb=0                    wr=1
+ alpha0=0                  alpha1=0.06               beta0=12
+ agidl=9e-008              bgidl=2.3e009             cgidl=0.5
+ egidl=0.53                aigbacc=0.01069           bigbacc=0.003132
+ cigbacc=0.1498            nigbacc=4.049             aigbinv=0.35
+ bigbinv=0.03              cigbinv=0.006             eigbinv=1.1
+ nigbinv=1                 aigc=0.00606              bigc=0.0007625
+ cigc=1e-010               aigsd=0.0045821833        waigsd=7.820575e-011
+ bigsd=0                   cigsd=0.002267            nigc=1
+ poxedge=1                 pigcd=2.3                 ntox=ntoxp
+ xrcrg1=12                 xrcrg2=1                  cgso=cgop
+ cgdo=cgop                 cgbo=0                    cgdl=cglp
+ cgsl=cglp                 clc=1e-007                cle=0.6
+ cf=cfp                    ckappas=0.6               acde=1.2
+ moin=11.09                noff=2.175                voffcv=-0.03885
+ kt1=-0.29497017           wkt1=5.1727518e-008       kt1l=0
+ kt2=-0.027639233          wkt2=-1.9417371e-008      ute=-1.193365
+ wute=6.3681825e-008       ua1=4.1822917e-009        wua1=-1.0334331e-015
+ ub1=-7.7915117e-018       wub1=1.4758542e-024       uc1=-6.421e-011
+ prt=0                     at=280000                 jss=1.245e-07
+ jsws=3.77e-13             jswgs=3.00e-12            njs=1
+ ijthsfwd=0.01             ijthsrev=0.01             bvs=10
+ xjbvs=1                   pbs=0.8                   cjs=cjp
+ mjs=0.36                  pbsws=0.8                 cjsws=cjswp
+ mjsws=0.01                pbswgs=1                  cjswgs=cjswgp
+ mjswgs=0.98               tpb=1.9e-03               tcj=8.54e-04
+ tpbsw=1.9e-03             tcjsw=3.57e-04            tpbswg=1.9e-03
+ tcjswg=3.12e-03           xtis=3                    dmcg=9.25e-008
+ dmci=9.25e-008            dmdg=0                    dmcgt=0
+ dwj=0                     xgw=0                     xgl=0
+ rshg=0.1                  gbmin=1e-012              rbpb=50
+ rbpd=50                   rbps=50                   rbdb=50
+ rbsb=50                   ngcon=1                   saref=0.63e-6
+ sbref=0.63e-6             kvsat=-0.9                wlod=0.8e-6
+ tku0=0.1                  ku0=1.3249e-7             llodku0=1
+ wlodku0=1                 lku0=1.33e-7              wku0=6.5e-7
+ pku0=0                    kvth0=-1.5e-9             stk2=4e-10
+ steta0=0                  lkvth0=-1.68e-15          wkvth0=0.5e-6
+ pkvth0=0                  llodvth=2                 wlodvth=1
+ lodk2=2                   lodeta0=1                 fnoimod=1
+ noia=1.635e+42            noib=7.241e+26            noic=8.75
+ em=1.50e+08               ef=1.19                   wpemod=wpeflag
+ kvth0we=-0.0028           lkvth0we=0                wkvth0we=0
+ pkvth0we=0                ku0we=-0.0045             lku0we=3.00e-10
+ wku0we=0                  pku0we=0                  k2we=0.00045
+ wk2we=0                   web=-180                  wec=-3000
+ scref=1.00e-06            ud=0                      tnoimod=0
+ minr=1e-3

     7: type=p
+ lmin=1.2000e-06-dxlp      lmax=1.0000e-05-dxlp      wmin=1.0000e-06-dxwp
+ wmax=1.0000e-05-dxwp      version=4.5               binunit=2
+ paramchk=1                mobmod=0                  capmod=2
+ igcmod=1                  igbmod=1                  diomod=1
+ rdsmod=0                  rbodymod=0                rgatemod=0
+ permod=1                  acnqsmod=0                trnqsmod=0
+ tnom=25                   toxe=toxp                 toxm=toxp
+ dtox=5.25e-010            epsrox=3.9                wint=5e-009
+ lint=2.5e-009             ll=0                      wl=0
+ lln=1                     wln=1                     lw=0
+ ww=0                      lwn=1                     wwn=1
+ lwl=0                     wwl=0                     llc=0
+ wlc=0                     lwc=0                     wwc=0
+ lwlc=0                    wwlc=0                    dlc=1.525e-008
+ dwc=0                     xpart=1                   toxref=3e-009
+ dlcig=2.5e-009            xl=-3.5e-08+dxlp          xw=1.5e-8+dxwp
+ vth0=-0.16535518+dvthp    lvth0=-3.904154e-009+dlvthp
+ wvth0=6.5642047e-009+dwvthp                         pvth0=-1.085443e-014+dpvthp
+ k1=0.1623                 k2=0.010715636+dk2p       lk2=2.0654029e-008
+ wk2=-1.3797729e-009       pk2=4.840489e-015         k3=-0.58
+ k3b=0.8                   w0=0                      dvt0=10
+ dvt1=1.71                 dvt2=0.0928               dvt0w=0
+ dvt1w=0                   dvt2w=0                   dsub=0.5
+ minv=0                    voffl=0                   dvtp0=0
+ dvtp1=0                   lpe0=2.805e-007           lpeb=1e-007
+ xj=1.7000001e-007         ngate=8e019               ndep=1.7200001e017
+ nsd=1e020                 phin=0                    cdsc=0
+ cdscb=0                   cdscd=0                   lcdscd=0+dlcdscdp
+ cit=-5.4318182e-006       lcit=1.1663009e-009       wcit=-1.2644956e-009
+ pcit=1.4668149e-015       voff=-0.096938139         lvoff=2.4714638e-009+dlvoffp
+ wvoff=9.3958623e-010      pvoff=-9.3582788e-015     nfactor=0.5
+ eta0=0.085                etab=-0.02                u0=0.00847563
+ lu0=6.4612195e-010        wu0=-8.393102e-010        pu0=5.3685424e-016
+ ua=-2.7802637e-010        lua=8.5032745e-019        wua=1.6271874e-017
+ pua=-8.5075262e-024       ub=2.0353458e-018         lub=-1.798029e-025
+ wub=-2.1811279e-025       pub=7.4807558e-031        uc=8.2005569e-011
+ luc=-6.4298629e-018       wuc=-6.9732614e-018       puc=6.9453684e-023
+ vsat=120000               a0=3.62                   ags=1.0109773
+ lags=8.4682636e-007       a1=0                      a2=1
+ b0=0                      b1=0                      keta=-0.032616402
+ lketa=-7.9317433e-008     wketa=1.7230656e-009      pketa=-1.7161734e-014
+ dwg=0                     dwb=0                     pclm=0.094545455
+ lpclm=1.0503273e-006      pdiblc1=0                 pdiblc2=0.005
+ pdiblcb=0                 drout=0                   pvag=0
+ delta=0.02                pscbe1=9.264e008          pscbe2=1e-020
+ fprout=1000               pdits=0                   pditsd=0
+ pditsl=0                  rsh=9.68                  rdsw=210+drdswp
+ prwg=0                    prwb=0                    wr=1
+ alpha0=0                  alpha1=0.06               beta0=12
+ agidl=9e-008              bgidl=2.3e009             cgidl=0.5
+ egidl=0.53                aigbacc=0.01069           bigbacc=0.003132
+ cigbacc=0.1498            nigbacc=4.049             aigbinv=0.35
+ bigbinv=0.03              cigbinv=0.006             eigbinv=1.1
+ nigbinv=1                 aigc=0.00606              bigc=0.0007625
+ cigc=1e-010               aigsd=0.0045821833        waigsd=7.820575e-011
+ bigsd=0                   cigsd=0.002267            nigc=1
+ poxedge=1                 pigcd=2.3                 ntox=ntoxp
+ xrcrg1=12                 xrcrg2=1                  cgso=cgop
+ cgdo=cgop                 cgbo=0                    cgdl=cglp
+ cgsl=cglp                 clc=1e-007                cle=0.6
+ cf=cfp                    ckappas=0.6               acde=1.2
+ moin=11.09                noff=2.175                voffcv=-0.03885
+ kt1=-0.29565169           lkt1=6.7879588e-009       wkt1=5.8546145e-008
+ pkt1=-6.7913528e-014      kt1l=0                    kt2=-0.027383405
+ lkt2=-2.5480502e-009      wkt2=-2.1976933e-008      pkt2=2.5493242e-014
+ ute=-1.1966522            lute=3.2740233e-008       wute=-8.9372922e-009
+ pute=7.2328641e-013       ua1=4.3541129e-009        lua1=-1.7113398e-015
+ wua1=-1.3940987e-015      pua1=3.5922296e-021       ub1=-8.187111e-018
+ lub1=3.9401693e-024       wub1=1.6197376e-024       pub1=-1.4330781e-030
+ uc1=-6.421e-011           prt=0                     at=280000
+ jss=1.245e-07             jsws=3.77e-13             jswgs=3.00e-12
+ njs=1                     ijthsfwd=0.01             ijthsrev=0.01
+ bvs=10                    xjbvs=1                   pbs=0.8
+ cjs=cjp                   mjs=0.36                  pbsws=0.8
+ cjsws=cjswp               mjsws=0.01                pbswgs=1
+ cjswgs=cjswgp             mjswgs=0.98               tpb=1.9e-03
+ tcj=8.54e-04              tpbsw=1.9e-03             tcjsw=3.57e-04
+ tpbswg=1.9e-03            tcjswg=3.12e-03           xtis=3
+ dmcg=9.25e-008            dmci=9.25e-008            dmdg=0
+ dmcgt=0                   dwj=0                     xgw=0
+ xgl=0                     rshg=0.1                  gbmin=1e-012
+ rbpb=50                   rbpd=50                   rbps=50
+ rbdb=50                   rbsb=50                   ngcon=1
+ saref=0.63e-6             sbref=0.63e-6             kvsat=-0.9
+ wlod=0.8e-6               tku0=0.1                  ku0=1.3249e-7
+ llodku0=1                 wlodku0=1                 lku0=1.33e-7
+ wku0=6.5e-7               pku0=0                    kvth0=-1.5e-9
+ stk2=4e-10                steta0=0                  lkvth0=-1.68e-15
+ wkvth0=0.5e-6             pkvth0=0                  llodvth=2
+ wlodvth=1                 lodk2=2                   lodeta0=1
+ fnoimod=1                 noia=1.635e+42            noib=7.241e+26
+ noic=8.75                 em=1.50e+08               ef=1.19
+ wpemod=wpeflag            kvth0we=-0.0028           lkvth0we=0
+ wkvth0we=0                pkvth0we=0                ku0we=-0.0045
+ lku0we=3.00e-10           wku0we=0                  pku0we=0
+ k2we=0.00045              wk2we=0                   web=-180
+ wec=-3000                 scref=1.00e-06            ud=0
+ tnoimod=0                 minr=1e-3

     8: type=p
+ lmin=5.0000e-07-dxlp      lmax=1.2000e-06-dxlp      wmin=1.0000e-06-dxwp
+ wmax=1.0000e-05-dxwp      version=4.5               binunit=2
+ paramchk=1                mobmod=0                  capmod=2
+ igcmod=1                  igbmod=1                  diomod=1
+ rdsmod=0                  rbodymod=0                rgatemod=0
+ permod=1                  acnqsmod=0                trnqsmod=0
+ tnom=25                   toxe=toxp                 toxm=toxp
+ dtox=5.25e-010            epsrox=3.9                wint=5e-009
+ lint=2.5e-009             ll=0                      wl=0
+ lln=1                     wln=1                     lw=0
+ ww=0                      lwn=1                     wwn=1
+ lwl=0                     wwl=0                     llc=0
+ wlc=0                     lwc=0                     wwc=0
+ lwlc=0                    wwlc=0                    dlc=1.525e-008
+ dwc=0                     xpart=1                   toxref=3e-009
+ dlcig=2.5e-009            xl=-3.5e-08+dxlp          xw=1.5e-8+dxwp
+ vth0=-0.1539602+dvthp     lvth0=-1.7122335e-008+dlvthp
+ wvth0=-1.1089256e-008+dwvthp                        pvth0=9.6235846e-015+dpvthp
+ k1=0.1623                 k2=0.02378809+dk2p        lk2=5.4899817e-009
+ wk2=5.4360976e-009        pk2=-3.0659208e-015       k3=-0.58
+ k3b=0.8                   w0=0                      dvt0=10
+ dvt1=1.71                 dvt2=0.0928               dvt0w=0
+ dvt1w=0                   dvt2w=0                   dsub=0.5
+ minv=0                    voffl=0                   dvtp0=0
+ dvtp1=0                   lpe0=2.805e-007           lpeb=1e-007
+ xj=1.7000001e-007         ngate=8e019               ndep=1.7200001e017
+ nsd=1e020                 phin=0                    cdsc=0
+ cdscb=0                   cdscd=0                   lcdscd=0+dlcdscdp
+ cit=0.001                 voff=-0.078427339         lvoff=-1.9001064e-008+dlvoffp
+ wvoff=-1.2692953e-008     pvoff=6.4554665e-015      nfactor=0.5
+ eta0=0.085                etab=-0.02                u0=0.008607135
+ lu0=4.9357619e-010        wu0=2.7764637e-010        pu0=-7.5881539e-016
+ ua=-3.5334238e-012        lua=-3.175615e-016        wua=-8.7558519e-018
+ pua=2.0524636e-023        ub=1.4318269e-018         lub=5.2027906e-025
+ wub=6.8007082e-025        pub=-2.9381741e-031       uc=5.8432281e-011
+ luc=2.0915151e-017        wuc=8.7663858e-017        puc=-4.0325375e-023
+ vsat=120000               a0=3.62                   ags=0.92877143
+ lags=9.4218514e-007       a1=0                      a2=1
+ b0=0                      b1=0                      keta=-0.066489229
+ lketa=-4.0024955e-008     wketa=-2.1661397e-008     pketa=9.9642425e-015
+ dwg=0                     dwb=0                     pclm=1
+ pdiblc1=0                 pdiblc2=0.005             pdiblcb=0
+ drout=0                   pvag=0                    delta=0.02
+ pscbe1=9.264e008          pscbe2=1e-020             fprout=1000
+ pdits=0                   pditsd=0                  pditsl=0
+ rsh=9.68                  rdsw=210+drdswp           prwg=0
+ prwb=0                    wr=1                      alpha0=0
+ alpha1=0.06               beta0=12                  agidl=9e-008
+ bgidl=2.3e009             cgidl=0.5                 egidl=0.53
+ aigbacc=0.01069           bigbacc=0.003132          cigbacc=0.1498
+ nigbacc=4.049             aigbinv=0.35              bigbinv=0.03
+ cigbinv=0.006             eigbinv=1.1               nigbinv=1
+ aigc=0.00606              bigc=0.0007625            cigc=1e-010
+ aigsd=0.0045821833        waigsd=7.820575e-011      bigsd=0
+ cigsd=0.002267            nigc=1                    poxedge=1
+ pigcd=2.3                 ntox=ntoxp                xrcrg1=12
+ xrcrg2=1                  cgso=cgop                 cgdo=cgop
+ cgbo=0                    cgdl=cglp                 cgsl=cglp
+ clc=1e-007                cle=0.6                   cf=cfp
+ ckappas=0.6               acde=1.2                  moin=11.09
+ noff=2.175                voffcv=-0.03885           kt1=-0.28916159
+ lkt1=-7.4056057e-010      wkt1=-6.3873349e-009      pkt1=7.4093085e-015
+ kt1l=0                    kt2=-0.02958              ute=-0.88694474
+ lute=-3.2652038e-007      wute=1.0265319e-006       pute=-4.7785782e-013
+ ua1=3.9367173e-009        lua1=-1.2271608e-015      wua1=3.0251963e-015
+ pua1=-1.5341527e-021      ub1=-5.4132829e-018       lub1=7.225287e-025
+ wub1=6.1999603e-025       pub1=-2.7337793e-031      uc1=-6.421e-011
+ prt=0                     at=282745.65              lat=-0.0031849568
+ wat=-0.0005139235         pat=5.9615126e-010        jss=1.245e-07
+ jsws=3.77e-13             jswgs=3.00e-12            njs=1
+ ijthsfwd=0.01             ijthsrev=0.01             bvs=10
+ xjbvs=1                   pbs=0.8                   cjs=cjp
+ mjs=0.36                  pbsws=0.8                 cjsws=cjswp
+ mjsws=0.01                pbswgs=1                  cjswgs=cjswgp
+ mjswgs=0.98               tpb=1.9e-03               tcj=8.54e-04
+ tpbsw=1.9e-03             tcjsw=3.57e-04            tpbswg=1.9e-03
+ tcjswg=3.12e-03           xtis=3                    dmcg=9.25e-008
+ dmci=9.25e-008            dmdg=0                    dmcgt=0
+ dwj=0                     xgw=0                     xgl=0
+ rshg=0.1                  gbmin=1e-012              rbpb=50
+ rbpd=50                   rbps=50                   rbdb=50
+ rbsb=50                   ngcon=1                   saref=0.63e-6
+ sbref=0.63e-6             kvsat=-0.9                wlod=0.8e-6
+ tku0=0.1                  ku0=1.3249e-7             llodku0=1
+ wlodku0=1                 lku0=1.33e-7              wku0=6.5e-7
+ pku0=0                    kvth0=-1.5e-9             stk2=4e-10
+ steta0=0                  lkvth0=-1.68e-15          wkvth0=0.5e-6
+ pkvth0=0                  llodvth=2                 wlodvth=1
+ lodk2=2                   lodeta0=1                 fnoimod=1
+ noia=1.635e+42            noib=7.241e+26            noic=8.75
+ em=1.50e+08               ef=1.19                   wpemod=wpeflag
+ kvth0we=-0.0028           lkvth0we=0                wkvth0we=0
+ pkvth0we=0                ku0we=-0.0045             lku0we=3.00e-10
+ wku0we=0                  pku0we=0                  k2we=0.00045
+ wk2we=0                   web=-180                  wec=-3000
+ scref=1.00e-06            ud=0                      tnoimod=0
+ minr=1e-3

     9: type=p
+ lmin=2.4000e-07-dxlp      lmax=5.0000e-07-dxlp      wmin=1.0000e-06-dxwp
+ wmax=1.0000e-05-dxwp      version=4.5               binunit=2
+ paramchk=1                mobmod=0                  capmod=2
+ igcmod=1                  igbmod=1                  diomod=1
+ rdsmod=0                  rbodymod=0                rgatemod=0
+ permod=1                  acnqsmod=0                trnqsmod=0
+ tnom=25                   toxe=toxp                 toxm=toxp
+ dtox=5.25e-010            epsrox=3.9                wint=5e-009
+ lint=2.5e-009             ll=0                      wl=0
+ lln=1                     wln=1                     lw=0
+ ww=0                      lwn=1                     wwn=1
+ lwl=0                     wwl=0                     llc=0
+ wlc=0                     lwc=0                     wwc=0
+ lwlc=0                    wwlc=0                    dlc=1.525e-008
+ dwc=0                     xpart=1                   toxref=3e-009
+ dlcig=2.5e-009            xl=-3.5e-08+dxlp          xw=1.5e-8+dxwp
+ vth0=-0.20491831+dvthp    lvth0=6.3183949e-009+dlvthp
+ wvth0=1.1034745e-008+dwvthp                         pvth0=-5.5345608e-016+dpvthp
+ k1=0.1623                 k2=0.03704809+dk2p        lk2=-6.0961795e-010
+ wk2=-2.1742917e-009       pk2=4.3485835e-016        k3=-0.58
+ k3b=0.8                   w0=0                      dvt0=10
+ dvt1=1.71                 dvt2=0.0928               dvt0w=0
+ dvt1w=0                   dvt2w=0                   dsub=0.5
+ minv=0                    voffl=0                   dvtp0=0
+ dvtp1=0                   lpe0=2.805e-007           lpeb=1e-007
+ xj=1.7000001e-007         ngate=8e019               ndep=1.7200001e017
+ nsd=1e020                 phin=0                    cdsc=0
+ cdscb=0                   cdscd=0                   lcdscd=0+dlcdscdp
+ cit=0.0010858974          lcit=-3.9512821e-011      wcit=-8.5940385e-010
+ pcit=3.9532577e-016       voff=-0.11337246          lvoff=-2.9263077e-009+dlvoffp
+ wvoff=-3.8157531e-009     pvoff=2.3719546e-015      nfactor=0.32897436
+ lnfactor=7.8671795e-008   wnfactor=1.7188077e-007   pnfactor=-7.9065154e-014
+ eta0=0.047807692          leta0=1.7108462e-008      weta0=2.5782115e-008
+ peta0=-1.1859773e-014     etab=-0.02                u0=0.0097958767
+ lu0=-5.3245e-011          wu0=-1.075458e-009        pu0=-1.3638739e-016
+ ua=-6.9476937e-010        lua=4.0704103e-019        wua=2.7784526e-017
+ pua=3.7160622e-024        ub=2.4554312e-018         lub=4.9421103e-026
+ wub=2.1579631e-025        pub=-8.0251131e-032       uc=9.0284615e-011
+ luc=6.2630769e-018        vsat=120000               a0=3.62
+ ags=-0.19915385           lags=1.4610308e-006       a1=0
+ a2=1                      b0=0                      b1=0
+ keta=-0.1405              lketa=-5.98e-009          dwg=0
+ dwb=0                     pclm=1.3769231            lpclm=-1.7338462e-007
+ pdiblc1=0                 pdiblc2=0.005             pdiblcb=0
+ drout=0                   pvag=0                    delta=0.02
+ pscbe1=9.264e008          pscbe2=1e-020             fprout=1000
+ pdits=0                   pditsd=0                  pditsl=0
+ rsh=9.68                  rdsw=210+drdswp           prwg=0
+ prwb=0                    wr=1                      alpha0=0
+ alpha1=0.06               beta0=12                  agidl=9e-008
+ bgidl=2.3e009             cgidl=0.5                 egidl=0.53
+ aigbacc=0.01069           bigbacc=0.003132          cigbacc=0.1498
+ nigbacc=4.049             aigbinv=0.35              bigbinv=0.03
+ cigbinv=0.006             eigbinv=1.1               nigbinv=1
+ aigc=0.00606              bigc=0.0007625            cigc=1e-010
+ aigsd=0.0045821833        waigsd=7.820575e-011      bigsd=0
+ cigsd=0.002267            nigc=1                    poxedge=1
+ pigcd=2.3                 ntox=ntoxp                xrcrg1=12
+ xrcrg2=1                  cgso=cgop                 cgdo=cgop
+ cgbo=0                    cgdl=cglp                 cgsl=cglp
+ clc=1e-007                cle=0.6                   cf=cfp
+ ckappas=0.6               acde=1.2                  moin=11.09
+ noff=2.175                voffcv=-0.03885           kt1=-0.30936496
+ lkt1=8.5529923e-009       wkt1=1.7196671e-008       pkt1=-3.4393342e-015
+ kt1l=0                    kt2=-0.022526154          lkt2=-3.2447692e-009
+ ute=-1.7860422            lute=8.7064436e-008       wute=-1.0424569e-007
+ pute=4.2299857e-014       ua1=8.1587736e-010        lua1=2.0842553e-016
+ wua1=-5.4058221e-016      pua1=1.0610544e-022       ub1=-3.7285068e-018
+ lub1=-5.2468308e-026      wub1=1.0819894e-025       pub1=-3.7951274e-032
+ uc1=-6.421e-011           prt=0                     at=355588.63
+ lat=-0.036692726          wat=-0.011507418          pat=5.6531585e-009
+ jss=1.245e-07             jsws=3.77e-13             jswgs=3.00e-12
+ njs=1                     ijthsfwd=0.01             ijthsrev=0.01
+ bvs=10                    xjbvs=1                   pbs=0.8
+ cjs=cjp                   mjs=0.36                  pbsws=0.8
+ cjsws=cjswp               mjsws=0.01                pbswgs=1
+ cjswgs=cjswgp             mjswgs=0.98               tpb=1.9e-03
+ tcj=8.54e-04              tpbsw=1.9e-03             tcjsw=3.57e-04
+ tpbswg=1.9e-03            tcjswg=3.12e-03           xtis=3
+ dmcg=9.25e-008            dmci=9.25e-008            dmdg=0
+ dmcgt=0                   dwj=0                     xgw=0
+ xgl=0                     rshg=0.1                  gbmin=1e-012
+ rbpb=50                   rbpd=50                   rbps=50
+ rbdb=50                   rbsb=50                   ngcon=1
+ saref=0.63e-6             sbref=0.63e-6             kvsat=-0.9
+ wlod=0.8e-6               tku0=0.1                  ku0=1.3249e-7
+ llodku0=1                 wlodku0=1                 lku0=1.33e-7
+ wku0=6.5e-7               pku0=0                    kvth0=-1.5e-9
+ stk2=4e-10                steta0=0                  lkvth0=-1.68e-15
+ wkvth0=0.5e-6             pkvth0=0                  llodvth=2
+ wlodvth=1                 lodk2=2                   lodeta0=1
+ fnoimod=1                 noia=1.635e+42            noib=7.241e+26
+ noic=8.75                 em=1.50e+08               ef=1.19
+ wpemod=wpeflag            kvth0we=-0.0028           lkvth0we=0
+ wkvth0we=0                pkvth0we=0                ku0we=-0.0045
+ lku0we=3.00e-10           wku0we=0                  pku0we=0
+ k2we=0.00045              wk2we=0                   web=-180
+ wec=-3000                 scref=1.00e-06            ud=0
+ tnoimod=0                 minr=1e-3

     10: type=p
+ lmin=1.000e-07            lmax=2.4000e-07-dxlp      wmin=1.0000e-06-dxwp
+ wmax=1.0000e-05-dxwp      version=4.5               binunit=2
+ paramchk=1                mobmod=0                  capmod=2
+ igcmod=1                  igbmod=1                  diomod=1
+ rdsmod=0                  rbodymod=0                rgatemod=0
+ permod=1                  acnqsmod=0                trnqsmod=0
+ tnom=25                   toxe=toxp                 toxm=toxp
+ dtox=5.25e-010            epsrox=3.9                wint=5e-009
+ lint=2.5e-009             ll=0                      wl=0
+ lln=1                     wln=1                     lw=0
+ ww=0                      lwn=1                     wwn=1
+ lwl=0                     wwl=0                     llc=0
+ wlc=0                     lwc=0                     wwc=0
+ lwlc=0                    wwlc=0                    dlc=1.525e-008
+ dwc=0                     xpart=1                   toxref=3e-009
+ dlcig=2.5e-009            xl=-3.5e-08+dxlp          xw=1.5e-8+dxwp
+ vth0=-0.17846119+dvthp    lvth0=1.0269714e-009+dlvthp
+ wvth0=1.7556393e-009+dwvthp                         pvth0=1.3023651e-015+dpvthp
+ k1=0.1623                 k2=0.035348786+dk2p       lk2=-2.6975714e-010
+ wk2=-2.3461725e-009       pk2=4.692345e-016         k3=-0.58
+ k3b=0.8                   w0=0                      dvt0=10
+ dvt1=1.71                 dvt2=0.0928               dvt0w=0
+ dvt1w=0                   dvt2w=0                   dsub=0.5
+ minv=0                    voffl=0                   dvtp0=0
+ dvtp1=0                   lpe0=2.805e-007           lpeb=1e-007
+ xj=1.7000001e-007         ngate=8e019               ndep=1.7200001e017
+ nsd=1e020                 phin=0                    cdsc=0
+ cdscb=0                   cdscd=0                   lcdscd=0+dlcdscdp
+ cit=-0.0008977381         lcit=3.5721429e-010       wcit=1.8354411e-009
+ pcit=-1.4364321e-016      voff=-0.11342636          lvoff=-2.9155286e-009+dlvoffp
+ wvoff=-4.4529396e-009     pvoff=2.4993919e-015      nfactor=0.47954762
+ lnfactor=4.8557143e-008   wnfactor=-3.6708821e-007  pnfactor=2.8728643e-014
+ eta0=0.15168929           leta0=-3.6678571e-009     weta0=-4.5487018e-008
+ peta0=2.3940536e-015      etab=-0.0097142857        letab=-2.0571429e-009
+ u0=0.0094954024           lu0=6.8498571e-012        wu0=-9.6879368e-010
+ pu0=-1.5772025e-016       ua=-8.2932574e-010        lua=2.7318314e-017
+ wua=1.6348194e-016        pua=-2.342342e-023        ub=2.6535202e-018
+ lub=9.8032857e-027        wub=3.9102875e-026        pub=-4.4912445e-032
+ uc=6.6109786e-011         luc=1.1098043e-017        wuc=5.6930594e-017
+ puc=-1.1386119e-023       vsat=120000               a0=3.62
+ ags=3.2548857             lags=7.7022286e-007       wags=2.6238827e-006
+ pags=-5.2477654e-013      a1=0                      a2=1
+ b0=0                      b1=0                      keta=-0.23782679
+ lketa=1.3485357e-008      wketa=-1.3167295e-008     pketa=2.6334589e-015
+ dwg=0                     dwb=0                     pclm=0.64285714
+ lpclm=-2.6571429e-008     pdiblc1=0                 pdiblc2=0.005
+ pdiblcb=0                 drout=0                   pvag=0
+ delta=0.02                pscbe1=9.264e008          pscbe2=1e-020
+ fprout=1000               pdits=0                   pditsd=0
+ pditsl=0                  rsh=9.68                  rdsw=210+drdswp
+ prwg=0                    prwb=0                    wr=1
+ alpha0=0                  alpha1=0.06               beta0=12
+ agidl=9e-008              bgidl=2.3e009             cgidl=0.5
+ egidl=0.53                aigbacc=0.01069           bigbacc=0.003132
+ cigbacc=0.1498            nigbacc=4.049             aigbinv=0.35
+ bigbinv=0.03              cigbinv=0.006             eigbinv=1.1
+ nigbinv=1                 aigc=0.00606              bigc=0.0007625
+ cigc=1e-010               aigsd=0.0045821833        waigsd=7.820575e-011
+ bigsd=0                   cigsd=0.002267            nigc=1
+ poxedge=1                 pigcd=2.3                 ntox=ntoxp
+ xrcrg1=12                 xrcrg2=1                  cgso=cgop
+ cgdo=cgop                 cgbo=0                    cgdl=cglp
+ cgsl=cglp                 clc=1e-007                cle=0.6
+ cf=cfp                    ckappas=0.6               acde=1.2
+ moin=11.09                noff=2.175                voffcv=-0.03885
+ kt1=-0.25631429           lkt1=-2.0571429e-009      kt1l=0
+ kt2=-0.03875              ute=-1.2411943            lute=-2.1905143e-008
+ wute=-8.8101171e-008      pute=3.9070954e-014       ua1=2.0505657e-009
+ lua1=-3.8512143e-017      wua1=-3.7155711e-016      pua1=7.2300418e-023
+ ub1=-3.7798976e-018       lub1=-4.2190143e-026      wub1=-3.6549218e-025
+ pub1=5.6786951e-032       uc1=-6.421e-011           prt=0
+ at=225009.05              lat=-0.01057681           wat=0.023935748
+ pat=-1.4354745e-009       jss=1.245e-07             jsws=3.77e-13
+ jswgs=3.00e-12            njs=1                     ijthsfwd=0.01
+ ijthsrev=0.01             bvs=10                    xjbvs=1
+ pbs=0.8                   cjs=cjp                   mjs=0.36
+ pbsws=0.8                 cjsws=cjswp               mjsws=0.01
+ pbswgs=1                  cjswgs=cjswgp             mjswgs=0.98
+ tpb=1.9e-03               tcj=8.54e-04              tpbsw=1.9e-03
+ tcjsw=3.57e-04            tpbswg=1.9e-03            tcjswg=3.12e-03
+ xtis=3                    dmcg=9.25e-008            dmci=9.25e-008
+ dmdg=0                    dmcgt=0                   dwj=0
+ xgw=0                     xgl=0                     rshg=0.1
+ gbmin=1e-012              rbpb=50                   rbpd=50
+ rbps=50                   rbdb=50                   rbsb=50
+ ngcon=1                   saref=0.63e-6             sbref=0.63e-6
+ kvsat=-0.9                wlod=0.8e-6               tku0=0.1
+ ku0=1.3249e-7             llodku0=1                 wlodku0=1
+ lku0=1.33e-7              wku0=6.5e-7               pku0=0
+ kvth0=-1.5e-9             stk2=4e-10                steta0=0
+ lkvth0=-1.68e-15          wkvth0=0.5e-6             pkvth0=0
+ llodvth=2                 wlodvth=1                 lodk2=2
+ lodeta0=1                 fnoimod=1                 noia=1.635e+42
+ noib=7.241e+26            noic=8.75                 em=1.50e+08
+ ef=1.19                   wpemod=wpeflag            kvth0we=-0.0028
+ lkvth0we=0                wkvth0we=0                pkvth0we=0
+ ku0we=-0.0045             lku0we=3.00e-10           wku0we=0
+ pku0we=0                  k2we=0.00045              wk2we=0
+ web=-180                  wec=-3000                 scref=1.00e-06
+ ud=0                      tnoimod=0                 minr=1e-3

     11: type=p
+ lmin=1.0000e-05-dxlp      lmax=2.001e-05            wmin=5.0000e-07-dxwp
+ wmax=1.0000e-06-dxwp      version=4.5               binunit=2
+ paramchk=1                mobmod=0                  capmod=2
+ igcmod=1                  igbmod=1                  diomod=1
+ rdsmod=0                  rbodymod=0                rgatemod=0
+ permod=1                  acnqsmod=0                trnqsmod=0
+ tnom=25                   toxe=toxp                 toxm=toxp
+ dtox=5.25e-010            epsrox=3.9                wint=5e-009
+ lint=2.5e-009             ll=0                      wl=0
+ lln=1                     wln=1                     lw=0
+ ww=0                      lwn=1                     wwn=1
+ lwl=0                     wwl=0                     llc=0
+ wlc=0                     lwc=0                     wwc=0
+ lwlc=0                    wwlc=0                    dlc=1.525e-008
+ dwc=0                     xpart=1                   toxref=3e-009
+ dlcig=2.5e-009            xl=-3.5e-08+dxlp          xw=1.5e-8+dxwp
+ vth0=-0.159795+dvthp      wvth0=-5.07525e-010+dwvthp
+ lvth0=0+dlvthp            pvth0=0+dpvthp            k1=0.1623
+ k2=0.013314+dk2p          wk2=-1.42107e-009         k3=-0.58
+ k3b=0.8                   w0=0                      dvt0=10
+ dvt1=1.71                 dvt2=0.0928               dvt0w=0
+ dvt1w=0                   dvt2w=0                   dsub=0.5
+ minv=0                    voffl=0                   dvtp0=0
+ dvtp1=0                   lpe0=2.805e-007           lpeb=1e-007
+ xj=1.7000001e-007         ngate=8e019               ndep=1.7200001e017
+ nsd=1e020                 phin=0                    cdsc=0
+ cdscb=0                   cdscd=0                   lcdscd=0+dlcdscdp
+ cit=-0.001                voff=-0.09669             nfactor=0.5
+ lvoff=0+dlvoffp           eta0=0.085                etab=-0.02
+ u0=0.00779738             wu0=-3.85719e-011         ua=-2.60176e-010
+ wua=-2.43612e-018         ub=1.98812e-018           wub=-1.136856e-025
+ uc=8.136e-011             vsat=120000               a0=3.62
+ ags=1.096                 a1=0                      a2=1
+ b0=0                      b1=0                      keta=-0.04058
+ dwg=0                     dwb=0                     pclm=0.2
+ pdiblc1=0                 pdiblc2=0.005             pdiblcb=0
+ drout=0                   pvag=0                    delta=0.02
+ pscbe1=9.264e008          pscbe2=1e-020             fprout=1000
+ pdits=0                   pditsd=0                  pditsl=0
+ rsh=9.68                  rdsw=210+drdswp           prwg=0
+ prwb=0                    wr=1                      alpha0=0
+ alpha1=0.06               beta0=12                  agidl=9e-008
+ bgidl=2.3e009             cgidl=0.5                 egidl=0.53
+ aigbacc=0.01069           bigbacc=0.003132          cigbacc=0.1498
+ nigbacc=4.049             aigbinv=0.35              bigbinv=0.03
+ cigbinv=0.006             eigbinv=1.1               nigbinv=1
+ aigc=0.00606              bigc=0.0007625            cigc=1e-010
+ aigsd=0.00462061          waigsd=3.958695e-011      bigsd=0
+ cigsd=0.002267            nigc=1                    poxedge=1
+ pigcd=2.3                 ntox=ntoxp                xrcrg1=12
+ xrcrg2=1                  cgso=cgop                 cgdo=cgop
+ cgbo=0                    cgdl=cglp                 cgsl=cglp
+ clc=1e-007                cle=0.6                   cf=cfp
+ ckappas=0.6               acde=1.2                  moin=11.09
+ noff=2.175                voffcv=-0.03885           kt1=-0.2435
+ kt1l=0                    kt2=-0.04696              ute=-1.18454
+ wute=5.48127e-008         ua1=2.8914e-009           wua1=2.63913e-016
+ ub1=-6.10585e-018         wub1=-2.1823575e-025      uc1=-6.421e-011
+ prt=0                     at=280000                 jss=1.245e-07
+ jsws=3.77e-13             jswgs=3.00e-12            njs=1
+ ijthsfwd=0.01             ijthsrev=0.01             bvs=10
+ xjbvs=1                   pbs=0.8                   cjs=cjp
+ mjs=0.36                  pbsws=0.8                 cjsws=cjswp
+ mjsws=0.01                pbswgs=1                  cjswgs=cjswgp
+ mjswgs=0.98               tpb=1.9e-03               tcj=8.54e-04
+ tpbsw=1.9e-03             tcjsw=3.57e-04            tpbswg=1.9e-03
+ tcjswg=3.12e-03           xtis=3                    dmcg=9.25e-008
+ dmci=9.25e-008            dmdg=0                    dmcgt=0
+ dwj=0                     xgw=0                     xgl=0
+ rshg=0.1                  gbmin=1e-012              rbpb=50
+ rbpd=50                   rbps=50                   rbdb=50
+ rbsb=50                   ngcon=1                   saref=0.63e-6
+ sbref=0.63e-6             kvsat=-0.9                wlod=0.8e-6
+ tku0=0.1                  ku0=1.3249e-7             llodku0=1
+ wlodku0=1                 lku0=1.33e-7              wku0=6.5e-7
+ pku0=0                    kvth0=-1.5e-9             stk2=4e-10
+ steta0=0                  lkvth0=-1.68e-15          wkvth0=0.5e-6
+ pkvth0=0                  llodvth=2                 wlodvth=1
+ lodk2=2                   lodeta0=1                 fnoimod=1
+ noia=1.635e+42            noib=7.241e+26            noic=8.75
+ em=1.50e+08               ef=1.19                   wpemod=wpeflag
+ kvth0we=-0.0028           lkvth0we=0                wkvth0we=0
+ pkvth0we=0                ku0we=-0.0045             lku0we=3.00e-10
+ wku0we=0                  pku0we=0                  k2we=0.00045
+ wk2we=0                   web=-180                  wec=-3000
+ scref=1.00e-06            ud=0                      tnoimod=0
+ minr=1e-3

     12: type=p
+ lmin=1.2000e-06-dxlp      lmax=1.0000e-05-dxlp      wmin=5.0000e-07-dxwp
+ wmax=1.0000e-06-dxwp      version=4.5               binunit=2
+ paramchk=1                mobmod=0                  capmod=2
+ igcmod=1                  igbmod=1                  diomod=1
+ rdsmod=0                  rbodymod=0                rgatemod=0
+ permod=1                  acnqsmod=0                trnqsmod=0
+ tnom=25                   toxe=toxp                 toxm=toxp
+ dtox=5.25e-010            epsrox=3.9                wint=5e-009
+ lint=2.5e-009             ll=0                      wl=0
+ lln=1                     wln=1                     lw=0
+ ww=0                      lwn=1                     wwn=1
+ lwl=0                     wwl=0                     llc=0
+ wlc=0                     lwc=0                     wwc=0
+ lwlc=0                    wwlc=0                    dlc=1.525e-008
+ dwc=0                     xpart=1                   toxref=3e-009
+ dlcig=2.5e-009            xl=-3.5e-08+dxlp          xw=1.5e-8+dxwp
+ vth0=-0.15866479+dvthp    lvth0=-1.1256883e-008+dlvthp
+ wvth0=-1.5963968e-010+dwvthp                        pvth0=-3.4649378e-015+dpvthp
+ k1=0.1623                 k2=0.010743414+dk2p       lk2=2.560304e-008
+ wk2=-1.4076898e-009       pk2=-1.3326684e-016       k3=-0.58
+ k3b=0.8                   w0=0                      dvt0=10
+ dvt1=1.71                 dvt2=0.0928               dvt0w=0
+ dvt1w=0                   dvt2w=0                   dsub=0.5
+ minv=0                    voffl=0                   dvtp0=0
+ dvtp1=0                   lpe0=2.805e-007           lpeb=1e-007
+ xj=1.7000001e-007         ngate=8e019               ndep=1.7200001e017
+ nsd=1e020                 phin=0                    cdsc=0
+ cdscb=0                   cdscd=0                   lcdscd=0+dlcdscdp
+ cit=-0.0013967727         lcit=3.9518564e-009       wcit=1.3380205e-010
+ pcit=-1.3326684e-015      voff=-0.096682223         lvoff=-7.7461636e-011+dlvoffp
+ wvoff=6.8239043e-010      pvoff=-6.7966087e-015     nfactor=0.5
+ eta0=0.085                etab=-0.02                u0=0.0076963163
+ lu0=1.0065943e-009        wu0=-5.6099968e-011       pu0=1.7457956e-016
+ ua=-2.5954459e-010        lua=-6.2888345e-018       wua=-2.302318e-018
+ pua=-1.3326684e-024       ub=1.9237163e-018         lub=6.4146112e-025
+ wub=-1.0592508e-025       pub=-7.7294766e-032       uc=7.1578827e-011
+ luc=9.742048e-017         wuc=3.5056136e-018        puc=-3.4915911e-023
+ vsat=120000               a0=3.62                   ags=1.0109773
+ lags=8.4682636e-007       a1=0                      a2=1
+ b0=0                      b1=0                      keta=-0.028068767
+ lketa=-1.2461188e-007     wketa=-2.8473075e-009     pketa=2.8359183e-014
+ dwg=0                     dwb=0                     pclm=0.094545455
+ lpclm=1.0503273e-006      pdiblc1=0                 pdiblc2=0.005
+ pdiblcb=0                 drout=0                   pvag=0
+ delta=0.02                pscbe1=9.264e008          pscbe2=1e-020
+ fprout=1000               pdits=0                   pditsd=0
+ pditsl=0                  rsh=9.68                  rdsw=210+drdswp
+ prwg=0                    prwb=0                    wr=1
+ alpha0=0                  alpha1=0.06               beta0=12
+ agidl=9e-008              bgidl=2.3e009             cgidl=0.5
+ egidl=0.53                aigbacc=0.01069           bigbacc=0.003132
+ cigbacc=0.1498            nigbacc=4.049             aigbinv=0.35
+ bigbinv=0.03              cigbinv=0.006             eigbinv=1.1
+ nigbinv=1                 aigc=0.00606              bigc=0.0007625
+ cigc=1e-010               aigsd=0.00462061          waigsd=3.958695e-011
+ bigsd=0                   cigsd=0.002267            nigc=1
+ poxedge=1                 pigcd=2.3                 ntox=ntoxp
+ xrcrg1=12                 xrcrg2=1                  cgso=cgop
+ cgdo=cgop                 cgbo=0                    cgdl=cglp
+ cgsl=cglp                 clc=1e-007                cle=0.6
+ cf=cfp                    ckappas=0.6               acde=1.2
+ moin=11.09                noff=2.175                voffcv=-0.03885
+ kt1=-0.23430805           lkt1=-9.1551777e-008      wkt1=-3.1042075e-009
+ pkt1=3.0917906e-014       kt1l=0                    kt2=-0.049251
+ lkt2=2.281836e-008        ute=-1.3306606            lute=1.455361e-006
+ wute=1.2574116e-007       pute=-7.064475e-013       ua1=2.529542e-009
+ lua1=3.6041061e-015       wua1=4.3959509e-016       pua1=-1.7497936e-021
+ ub1=-6.4614625e-018       lub1=3.5419005e-024       wub1=-1.1453916e-025
+ pub1=-1.032818e-030       uc1=-6.421e-011           prt=0
+ at=280000                 jss=1.245e-07             jsws=3.77e-13
+ jswgs=3.00e-12            njs=1                     ijthsfwd=0.01
+ ijthsrev=0.01             bvs=10                    xjbvs=1
+ pbs=0.8                   cjs=cjp                   mjs=0.36
+ pbsws=0.8                 cjsws=cjswp               mjsws=0.01
+ pbswgs=1                  cjswgs=cjswgp             mjswgs=0.98
+ tpb=1.9e-03               tcj=8.54e-04              tpbsw=1.9e-03
+ tcjsw=3.57e-04            tpbswg=1.9e-03            tcjswg=3.12e-03
+ xtis=3                    dmcg=9.25e-008            dmci=9.25e-008
+ dmdg=0                    dmcgt=0                   dwj=0
+ xgw=0                     xgl=0                     rshg=0.1
+ gbmin=1e-012              rbpb=50                   rbpd=50
+ rbps=50                   rbdb=50                   rbsb=50
+ ngcon=1                   saref=0.63e-6             sbref=0.63e-6
+ kvsat=-0.9                wlod=0.8e-6               tku0=0.1
+ ku0=1.3249e-7             llodku0=1                 wlodku0=1
+ lku0=1.33e-7              wku0=6.5e-7               pku0=0
+ kvth0=-1.5e-9             stk2=4e-10                steta0=0
+ lkvth0=-1.68e-15          wkvth0=0.5e-6             pkvth0=0
+ llodvth=2                 wlodvth=1                 lodk2=2
+ lodeta0=1                 fnoimod=1                 noia=1.635e+42
+ noib=7.241e+26            noic=8.75                 em=1.50e+08
+ ef=1.19                   wpemod=wpeflag            kvth0we=-0.0028
+ lkvth0we=0                wkvth0we=0                pkvth0we=0
+ ku0we=-0.0045             lku0we=3.00e-10           wku0we=0
+ pku0we=0                  k2we=0.00045              wk2we=0
+ web=-180                  wec=-3000                 scref=1.00e-06
+ ud=0                      tnoimod=0                 minr=1e-3

     13: type=p
+ lmin=5.0000e-07-dxlp      lmax=1.2000e-06-dxlp      wmin=5.0000e-07-dxwp
+ wmax=1.0000e-06-dxwp      version=4.5               binunit=2
+ paramchk=1                mobmod=0                  capmod=2
+ igcmod=1                  igbmod=1                  diomod=1
+ rdsmod=0                  rbodymod=0                rgatemod=0
+ permod=1                  acnqsmod=0                trnqsmod=0
+ tnom=25                   toxe=toxp                 toxm=toxp
+ dtox=5.25e-010            epsrox=3.9                wint=5e-009
+ lint=2.5e-009             ll=0                      wl=0
+ lln=1                     wln=1                     lw=0
+ ww=0                      lwn=1                     wwn=1
+ lwl=0                     wwl=0                     llc=0
+ wlc=0                     lwc=0                     wwc=0
+ lwlc=0                    wwlc=0                    dlc=1.525e-008
+ dwc=0                     xpart=1                   toxref=3e-009
+ dlcig=2.5e-009            xl=-3.5e-08+dxlp          xw=1.5e-8+dxwp
+ vth0=-0.16040311+dvthp    lvth0=-9.2404274e-009+dlvthp
+ wvth0=-4.6141273e-009+dwvthp                        pvth0=1.7022679e-015+dpvthp
+ k1=0.1623                 k2=0.030380286+dk2p       lk2=2.8242686e-009
+ wk2=-1.1890586e-009       pk2=-3.8687906e-016       k3=-0.58
+ k3b=0.8                   w0=0                      dvt0=10
+ dvt1=1.71                 dvt2=0.0928               dvt0w=0
+ dvt1w=0                   dvt2w=0                   dsub=0.5
+ minv=0                    voffl=0                   dvtp0=0
+ dvtp1=0                   lpe0=2.805e-007           lpeb=1e-007
+ xj=1.7000001e-007         ngate=8e019               ndep=1.7200001e017
+ nsd=1e020                 phin=0                    cdsc=0
+ cdscb=0                   cdscd=0                   lcdscd=0+dlcdscdp
+ cit=0.0026737143          lcit=-7.6990857e-010      wcit=-1.6820829e-009
+ pcit=7.7375811e-016       voff=-0.0825212           lvoff=-1.6504248e-008+dlvoffp
+ wvoff=-8.5786226e-009     pvoff=3.9461664e-015      nfactor=0.5
+ eta0=0.085                etab=-0.02                u0=0.008798762
+ lu0=-2.7224272e-010       wu0=8.506119e-011         pu0=1.0832614e-017
+ ua=-6.6878286e-012        lua=-2.9960268e-016       wua=-5.5856751e-018
+ pua=2.476026e-024         ub=2.3897271e-018         lub=1.0088851e-025
+ wub=-2.8261892e-025       pub=1.2767009e-031        uc=1.8951131e-010
+ luc=-3.9381205e-017       wuc=-4.4070571e-017       puc=2.0272463e-023
+ vsat=120000               a0=3.62                   ags=0.92877143
+ lags=9.4218514e-007       a1=0                      a2=1
+ b0=0                      b1=0                      keta=-0.1236595
+ lketa=-1.3726631e-008     wketa=3.5794723e-008      pketa=-1.6465573e-014
+ dwg=0                     dwb=0                     pclm=1
+ pdiblc1=0                 pdiblc2=0.005             pdiblcb=0
+ drout=0                   pvag=0                    delta=0.02
+ pscbe1=9.264e008          pscbe2=1e-020             fprout=1000
+ pdits=0                   pditsd=0                  pditsl=0
+ rsh=9.68                  rdsw=210+drdswp           prwg=0
+ prwb=0                    wr=1                      alpha0=0
+ alpha1=0.06               beta0=12                  agidl=9e-008
+ bgidl=2.3e009             cgidl=0.5                 egidl=0.53
+ aigbacc=0.01069           bigbacc=0.003132          cigbacc=0.1498
+ nigbacc=4.049             aigbinv=0.35              bigbinv=0.03
+ cigbinv=0.006             eigbinv=1.1               nigbinv=1
+ aigc=0.00606              bigc=0.0007625            cigc=1e-010
+ aigsd=0.00462061          waigsd=3.958695e-011      bigsd=0
+ cigsd=0.002267            nigc=1                    poxedge=1
+ pigcd=2.3                 ntox=ntoxp                xrcrg1=12
+ xrcrg2=1                  cgso=cgop                 cgdo=cgop
+ cgbo=0                    cgdl=cglp                 cgsl=cglp
+ clc=1e-007                cle=0.6                   cf=cfp
+ ckappas=0.6               acde=1.2                  moin=11.09
+ noff=2.175                voffcv=-0.03885           kt1=-0.33434731
+ lkt1=2.4493765e-008       wkt1=3.9024322e-008       pkt1=-1.7951188e-014
+ kt1l=0                    kt2=-0.02958              ute=0.90876909
+ lute=-1.1423774e-006      wute=-7.7816053e-007      pute=3.4207846e-013
+ ua1=8.7058327e-009        lua1=-3.5603911e-015      wua1=-1.7677647e-015
+ pua1=8.1074375e-022       ub1=-3.1758986e-018       lub1=-2.6935366e-025
+ wub1=-1.6285752e-024      pub1=7.2346384e-031       uc1=-6.421e-011
+ prt=0                     at=280375.89              lat=-0.00043602743
+ wat=0.001867692           pat=-2.1665227e-009       jss=1.245e-07
+ jsws=3.77e-13             jswgs=3.00e-12            njs=1
+ ijthsfwd=0.01             ijthsrev=0.01             bvs=10
+ xjbvs=1                   pbs=0.8                   cjs=cjp
+ mjs=0.36                  pbsws=0.8                 cjsws=cjswp
+ mjsws=0.01                pbswgs=1                  cjswgs=cjswgp
+ mjswgs=0.98               tpb=1.9e-03               tcj=8.54e-04
+ tpbsw=1.9e-03             tcjsw=3.57e-04            tpbswg=1.9e-03
+ tcjswg=3.12e-03           xtis=3                    dmcg=9.25e-008
+ dmci=9.25e-008            dmdg=0                    dmcgt=0
+ dwj=0                     xgw=0                     xgl=0
+ rshg=0.1                  gbmin=1e-012              rbpb=50
+ rbpd=50                   rbps=50                   rbdb=50
+ rbsb=50                   ngcon=1                   saref=0.63e-6
+ sbref=0.63e-6             kvsat=-0.9                wlod=0.8e-6
+ tku0=0.1                  ku0=1.3249e-7             llodku0=1
+ wlodku0=1                 lku0=1.33e-7              wku0=6.5e-7
+ pku0=0                    kvth0=-1.5e-9             stk2=4e-10
+ steta0=0                  lkvth0=-1.68e-15          wkvth0=0.5e-6
+ pkvth0=0                  llodvth=2                 wlodvth=1
+ lodk2=2                   lodeta0=1                 fnoimod=1
+ noia=1.635e+42            noib=7.241e+26            noic=8.75
+ em=1.50e+08               ef=1.19                   wpemod=wpeflag
+ kvth0we=-0.0028           lkvth0we=0                wkvth0we=0
+ pkvth0we=0                ku0we=-0.0045             lku0we=3.00e-10
+ wku0we=0                  pku0we=0                  k2we=0.00045
+ wk2we=0                   web=-180                  wec=-3000
+ scref=1.00e-06            ud=0                      tnoimod=0
+ minr=1e-3

     14: type=p
+ lmin=2.4000e-07-dxlp      lmax=5.0000e-07-dxlp      wmin=5.0000e-07-dxwp
+ wmax=1.0000e-06-dxwp      version=4.5               binunit=2
+ paramchk=1                mobmod=0                  capmod=2
+ igcmod=1                  igbmod=1                  diomod=1
+ rdsmod=0                  rbodymod=0                rgatemod=0
+ permod=1                  acnqsmod=0                trnqsmod=0
+ tnom=25                   toxe=toxp                 toxm=toxp
+ dtox=5.25e-010            epsrox=3.9                wint=5e-009
+ lint=2.5e-009             ll=0                      wl=0
+ lln=1                     wln=1                     lw=0
+ ww=0                      lwn=1                     wwn=1
+ lwl=0                     wwl=0                     llc=0
+ wlc=0                     lwc=0                     wwc=0
+ lwlc=0                    wwlc=0                    dlc=1.525e-008
+ dwc=0                     xpart=1                   toxref=3e-009
+ dlcig=2.5e-009            xl=-3.5e-08+dxlp          xw=1.5e-8+dxwp
+ vth0=-0.19302946+dvthp    lvth0=5.7676923e-009+dlvthp
+ wvth0=-9.13545e-010+dwvthp                          pvth0=-9.9690128e-030+dpvthp
+ k1=0.1623                 k2=0.037370769+dk2p       lk2=-3.9135385e-010
+ wk2=-2.4985846e-009       pk2=2.1550292e-016        k3=-0.58
+ k3b=0.8                   w0=0                      dvt0=10
+ dvt1=1.71                 dvt2=0.0928               dvt0w=0
+ dvt1w=0                   dvt2w=0                   dsub=0.5
+ minv=0                    voffl=0                   dvtp0=0
+ dvtp1=0                   lpe0=2.805e-007           lpeb=1e-007
+ xj=1.7000001e-007         ngate=8e019               ndep=1.7200001e017
+ nsd=1e020                 phin=0                    cdsc=0
+ cdscb=0                   cdscd=0                   lcdscd=0+dlcdscdp
+ cit=-0.00054615385        lcit=7.1123077e-010       wcit=7.8080769e-010
+ pcit=-3.5917154e-016      voff=-0.12190846          lvoff=1.6138923e-009+dlvoffp
+ wvoff=4.7629269e-009      pvoff=-2.1909464e-015     nfactor=0.5
+ eta0=0.042384615          leta0=1.9603077e-008      weta0=3.1232308e-008
+ peta0=-1.4366862e-014     etab=-0.02                u0=0.0081018223
+ lu0=4.8349538e-011        wu0=6.2706666e-010        pu0=-2.384899e-016
+ ua=-6.5666569e-010        lua=-6.1286154e-019       wua=-1.0509672e-017
+ pua=4.7410643e-024        ub=2.4739808e-018         lub=6.2131846e-026
+ wub=1.9715394e-025        pub=-9.3025428e-032       uc=7.1389846e-011
+ luc=1.4954671e-017        wuc=1.8989243e-017        puc=-8.7350518e-024
+ vsat=120000               a0=3.62                   ags=-0.19915385
+ lags=1.4610308e-006       a1=0                      a2=1
+ b0=0                      b1=0                      keta=-0.1405
+ lketa=-5.98e-009          dwg=0                     dwb=0
+ pclm=1.3769231            lpclm=-1.7338462e-007     pdiblc1=0
+ pdiblc2=0.005             pdiblcb=0                 drout=0
+ pvag=0                    delta=0.02                pscbe1=9.264e008
+ pscbe2=1e-020             fprout=1000               pdits=0
+ pditsd=0                  pditsl=0                  rsh=9.68
+ rdsw=210+drdswp           prwg=0                    prwb=0
+ wr=1                      alpha0=0                  alpha1=0.06
+ beta0=12                  agidl=9e-008              bgidl=2.3e009
+ cgidl=0.5                 egidl=0.53                aigbacc=0.01069
+ bigbacc=0.003132          cigbacc=0.1498            nigbacc=4.049
+ aigbinv=0.35              bigbinv=0.03              cigbinv=0.006
+ eigbinv=1.1               nigbinv=1                 aigc=0.00606
+ bigc=0.0007625            cigc=1e-010               aigsd=0.00462061
+ waigsd=3.958695e-011      bigsd=0                   cigsd=0.002267
+ nigc=1                    poxedge=1                 pigcd=2.3
+ ntox=ntoxp                xrcrg1=12                 xrcrg2=1
+ cgso=cgop                 cgdo=cgop                 cgbo=0
+ cgdl=cglp                 cgsl=cglp                 clc=1e-007
+ cle=0.6                   cf=cfp                    ckappas=0.6
+ acde=1.2                  moin=11.09                noff=2.175
+ voffcv=-0.03885           kt1=-0.29225385           lkt1=5.1307692e-009
+ kt1l=0                    kt2=-0.022526154          lkt2=-3.2447692e-009
+ ute=-1.8663062            lute=1.3415723e-007       wute=-2.3580392e-008
+ pute=-5.0284015e-015      ua1=-1.4546954e-010       lua1=5.1120791e-016
+ wua1=4.2557142e-016       pua1=-1.9819085e-022      ub1=-2.9546346e-018
+ lub1=-3.7113508e-025      wub1=-6.695426e-025       pub1=2.8230883e-031
+ uc1=-6.421e-011           prt=0                     at=365457.23
+ lat=-0.039573446          wat=-0.021425363          pat=8.5482826e-009
+ jss=1.245e-07             jsws=3.77e-13             jswgs=3.00e-12
+ njs=1                     ijthsfwd=0.01             ijthsrev=0.01
+ bvs=10                    xjbvs=1                   pbs=0.8
+ cjs=cjp                   mjs=0.36                  pbsws=0.8
+ cjsws=cjswp               mjsws=0.01                pbswgs=1
+ cjswgs=cjswgp             mjswgs=0.98               tpb=1.9e-03
+ tcj=8.54e-04              tpbsw=1.9e-03             tcjsw=3.57e-04
+ tpbswg=1.9e-03            tcjswg=3.12e-03           xtis=3
+ dmcg=9.25e-008            dmci=9.25e-008            dmdg=0
+ dmcgt=0                   dwj=0                     xgw=0
+ xgl=0                     rshg=0.1                  gbmin=1e-012
+ rbpb=50                   rbpd=50                   rbps=50
+ rbdb=50                   rbsb=50                   ngcon=1
+ saref=0.63e-6             sbref=0.63e-6             kvsat=-0.9
+ wlod=0.8e-6               tku0=0.1                  ku0=1.3249e-7
+ llodku0=1                 wlodku0=1                 lku0=1.33e-7
+ wku0=6.5e-7               pku0=0                    kvth0=-1.5e-9
+ stk2=4e-10                steta0=0                  lkvth0=-1.68e-15
+ wkvth0=0.5e-6             pkvth0=0                  llodvth=2
+ wlodvth=1                 lodk2=2                   lodeta0=1
+ fnoimod=1                 noia=1.635e+42            noib=7.241e+26
+ noic=8.75                 em=1.50e+08               ef=1.19
+ wpemod=wpeflag            kvth0we=-0.0028           lkvth0we=0
+ wkvth0we=0                pkvth0we=0                ku0we=-0.0045
+ lku0we=3.00e-10           wku0we=0                  pku0we=0
+ k2we=0.00045              wk2we=0                   web=-180
+ wec=-3000                 scref=1.00e-06            ud=0
+ tnoimod=0                 minr=1e-3

     15: type=p
+ lmin=1.000e-07            lmax=2.4000e-07-dxlp      wmin=5.0000e-07-dxwp
+ wmax=1.0000e-06-dxwp      version=4.5               binunit=2
+ paramchk=1                mobmod=0                  capmod=2
+ igcmod=1                  igbmod=1                  diomod=1
+ rdsmod=0                  rbodymod=0                rgatemod=0
+ permod=1                  acnqsmod=0                trnqsmod=0
+ tnom=25                   toxe=toxp                 toxm=toxp
+ dtox=5.25e-010            epsrox=3.9                wint=5e-009
+ lint=2.5e-009             ll=0                      wl=0
+ lln=1                     wln=1                     lw=0
+ ww=0                      lwn=1                     wwn=1
+ lwl=0                     wwl=0                     llc=0
+ wlc=0                     lwc=0                     wwc=0
+ lwlc=0                    wwlc=0                    dlc=1.525e-008
+ dwc=0                     xpart=1                   toxref=3e-009
+ dlcig=2.5e-009            xl=-3.5e-08+dxlp          xw=1.5e-8+dxwp
+ vth0=-0.17416043+dvthp    lvth0=1.9938857e-009+dlvthp
+ wvth0=-2.5666264e-009+dwvthp                        pvth0=3.3061629e-016+dpvthp
+ k1=0.1623                 k2=0.036419429+dk2p       lk2=-2.0108571e-010
+ wk2=-3.4221686e-009       pk2=4.0021971e-016        k3=-0.58
+ k3b=0.8                   w0=0                      dvt0=10
+ dvt1=1.71                 dvt2=0.0928               dvt0w=0
+ dvt1w=0                   dvt2w=0                   dsub=0.5
+ minv=0                    voffl=0                   dvtp0=0
+ dvtp1=0                   lpe0=2.805e-007           lpeb=1e-007
+ xj=1.7000001e-007         ngate=8e019               ndep=1.7200001e017
+ nsd=1e020                 phin=0                    cdsc=0
+ cdscb=0                   cdscd=0                   lcdscd=0+dlcdscdp
+ cit=0.002155              lcit=1.71e-010            wcit=-1.2325607e-009
+ pcit=4.3502143e-017       voff=-0.10948857          lvoff=-8.7008571e-010+dlvoffp
+ wvoff=-8.4104143e-009     pvoff=4.4372186e-016      nfactor=0.11428571
+ lnfactor=7.7142857e-008   eta0=0.15981429           leta0=-3.8828571e-009
+ weta0=-5.3652643e-008     peta0=2.6101286e-015      etab=-0.0040005714
+ letab=-3.1998857e-009     wetab=-5.7422829e-009     petab=1.1484566e-015
+ u0=0.0088070143           lu0=-9.2688857e-011       wu0=-2.7696364e-010
+ pu0=-5.7683841e-017       ua=-8.69898e-010          lua=4.20336e-017
+ wua=2.0425706e-016        pua=-3.8212282e-023       ub=3.0902243e-018
+ lub=-6.1116857e-026       wub=-3.9978469e-025       pub=2.6362299e-032
+ uc=1.5784743e-010         luc=-2.3368457e-018       wuc=-3.5265737e-017
+ puc=2.1159442e-024        vsat=120000               a0=3.62
+ ags=8.03                  lags=-1.848e-007          wags=-2.1751071e-006
+ pags=4.3502143e-013       a1=0                      a2=1
+ b0=0                      b1=0                      keta=-0.25092857
+ lketa=1.6105714e-008      dwg=0                     dwb=0
+ pclm=0.64285714           lpclm=-2.6571429e-008     pdiblc1=0
+ pdiblc2=0.005             pdiblcb=0                 drout=0
+ pvag=0                    delta=0.02                pscbe1=9.264e008
+ pscbe2=1e-020             fprout=1000               pdits=0
+ pditsd=0                  pditsl=0                  rsh=9.68
+ rdsw=210+drdswp           prwg=0                    prwb=0
+ wr=1                      alpha0=0                  alpha1=0.06
+ beta0=12                  agidl=9e-008              bgidl=2.3e009
+ cgidl=0.5                 egidl=0.53                aigbacc=0.01069
+ bigbacc=0.003132          cigbacc=0.1498            nigbacc=4.049
+ aigbinv=0.35              bigbinv=0.03              cigbinv=0.006
+ eigbinv=1.1               nigbinv=1                 aigc=0.00606
+ bigc=0.0007625            cigc=1e-010               aigsd=0.00462061
+ waigsd=3.958695e-011      bigsd=0                   cigsd=0.002267
+ nigc=1                    poxedge=1                 pigcd=2.3
+ ntox=ntoxp                xrcrg1=12                 xrcrg2=1
+ cgso=cgop                 cgdo=cgop                 cgbo=0
+ cgdl=cglp                 cgsl=cglp                 clc=1e-007
+ cle=0.6                   cf=cfp                    ckappas=0.6
+ acde=1.2                  moin=11.09                noff=2.175
+ voffcv=-0.03885           kt1=-0.26891043           lkt1=4.6208571e-010
+ wkt1=1.2659124e-008       pkt1=-2.5318247e-015      kt1l=0
+ kt2=-0.03875              ute=-1.2968257            lute=2.0261143e-008
+ wute=-3.2191586e-008      pute=-3.3061629e-015      ua1=2.13175e-009
+ lua1=5.5764e-017          wua1=-4.5314732e-016      pua1=-2.2447106e-023
+ ub1=-4.6277943e-018       lub1=-3.6503143e-026      wub1=4.8664397e-025
+ pub1=5.1071516e-032       uc1=-6.421e-011           prt=0
+ at=220283.11              lat=-0.010538623          wat=0.028685313
+ pat=-1.4738526e-009       jss=1.245e-07             jsws=3.77e-13
+ jswgs=3.00e-12            njs=1                     ijthsfwd=0.01
+ ijthsrev=0.01             bvs=10                    xjbvs=1
+ pbs=0.8                   cjs=cjp                   mjs=0.36
+ pbsws=0.8                 cjsws=cjswp               mjsws=0.01
+ pbswgs=1                  cjswgs=cjswgp             mjswgs=0.98
+ tpb=1.9e-03               tcj=8.54e-04              tpbsw=1.9e-03
+ tcjsw=3.57e-04            tpbswg=1.9e-03            tcjswg=3.12e-03
+ xtis=3                    dmcg=9.25e-008            dmci=9.25e-008
+ dmdg=0                    dmcgt=0                   dwj=0
+ xgw=0                     xgl=0                     rshg=0.1
+ gbmin=1e-012              rbpb=50                   rbpd=50
+ rbps=50                   rbdb=50                   rbsb=50
+ ngcon=1                   saref=0.63e-6             sbref=0.63e-6
+ kvsat=-0.9                wlod=0.8e-6               tku0=0.1
+ ku0=1.3249e-7             llodku0=1                 wlodku0=1
+ lku0=1.33e-7              wku0=6.5e-7               pku0=0
+ kvth0=-1.5e-9             stk2=4e-10                steta0=0
+ lkvth0=-1.68e-15          wkvth0=0.5e-6             pkvth0=0
+ llodvth=2                 wlodvth=1                 lodk2=2
+ lodeta0=1                 fnoimod=1                 noia=1.635e+42
+ noib=7.241e+26            noic=8.75                 em=1.50e+08
+ ef=1.19                   wpemod=wpeflag            kvth0we=-0.0028
+ lkvth0we=0                wkvth0we=0                pkvth0we=0
+ ku0we=-0.0045             lku0we=3.00e-10           wku0we=0
+ pku0we=0                  k2we=0.00045              wk2we=0
+ web=-180                  wec=-3000                 scref=1.00e-06
+ ud=0                      tnoimod=0                 minr=1e-3

     16: type=p
+ lmin=1.0000e-05-dxlp      lmax=2.001e-05            wmin=2.4000e-07-dxwp
+ wmax=5.0000e-07-dxwp      version=4.5               binunit=2
+ paramchk=1                mobmod=0                  capmod=2
+ igcmod=1                  igbmod=1                  diomod=1
+ rdsmod=0                  rbodymod=0                rgatemod=0
+ permod=1                  acnqsmod=0                trnqsmod=0
+ tnom=25                   toxe=toxp                 toxm=toxp
+ dtox=5.25e-010            epsrox=3.9                wint=5e-009
+ lint=2.5e-009             ll=0                      wl=0
+ lln=1                     wln=1                     lw=0
+ ww=0                      lwn=1                     wwn=1
+ lwl=0                     wwl=0                     llc=0
+ wlc=0                     lwc=0                     wwc=0
+ lwlc=0                    wwlc=0                    dlc=1.525e-008
+ dwc=0                     xpart=1                   toxref=3e-009
+ dlcig=2.5e-009            xl=-3.5e-08+dxlp          xw=1.5e-8+dxwp
+ vth0=-0.16315577+dvthp    wvth0=1.1896635e-009+dwvthp
+ lvth0=0+dlvthp            pvth0=0+dpvthp            k1=0.1623
+ k2=0.013044231+dk2p       wk2=-1.2848365e-009       k3=-0.58
+ k3b=0.8                   w0=0                      dvt0=10
+ dvt1=1.71                 dvt2=0.0928               dvt0w=0
+ dvt1w=0                   dvt2w=0                   dsub=0.5
+ minv=0                    voffl=0                   dvtp0=0
+ dvtp1=0                   lpe0=2.805e-007           lpeb=1e-007
+ xj=1.7000001e-007         ngate=8e019               ndep=1.7200001e017
+ nsd=1e020                 phin=0                    cdsc=0
+ cdscb=0                   cdscd=0                   lcdscd=0+dlcdscdp
+ cit=-0.001                voff=-0.09669             nfactor=0.5
+ lvoff=0+dlvoffp           eta0=0.085                etab=-0.02
+ u0=0.0075023846           wu0=1.1040077e-010        ua=-2.5915769e-010
+ wua=-2.9503654e-018       ub=2.0343846e-018         wub=-1.3704923e-025
+ uc=1.2787231e-010         wuc=-2.3488715e-017       vsat=120000
+ a0=3.62                   ags=1.096                 a1=0
+ a2=1                      b0=0                      b1=0
+ keta=-0.04058             dwg=0                     dwb=0
+ pclm=0.2                  pdiblc1=0                 pdiblc2=0.005
+ pdiblcb=0                 drout=0                   pvag=0
+ delta=0.02                pscbe1=9.264e008          pscbe2=1e-020
+ fprout=1000               pdits=0                   pditsd=0
+ pditsl=0                  rsh=9.68                  rdsw=210+drdswp
+ prwg=0                    prwb=0                    wr=1
+ alpha0=0                  alpha1=0.06               beta0=12
+ agidl=9e-008              bgidl=2.3e009             cgidl=0.5
+ egidl=0.53                aigbacc=0.01069           bigbacc=0.003132
+ cigbacc=0.1498            nigbacc=4.049             aigbinv=0.35
+ bigbinv=0.03              cigbinv=0.006             eigbinv=1.1
+ nigbinv=1                 aigc=0.00606              bigc=0.0007625
+ cigc=1e-010               aigsd=0.0045661346        waigsd=6.7097019e-011
+ bigsd=0                   cigsd=0.002267            nigc=1
+ poxedge=1                 pigcd=2.3                 ntox=ntoxp
+ xrcrg1=12                 xrcrg2=1                  cgso=cgop
+ cgdo=cgop                 cgbo=0                    cgdl=cglp
+ cgsl=cglp                 clc=1e-007                cle=0.6
+ cf=cfp                    ckappas=0.6               acde=1.2
+ moin=11.09                noff=2.175                voffcv=-0.03885
+ kt1=-0.2435               kt1l=0                    kt2=-0.064656538
+ wkt2=8.9367519e-009       ute=-1.5306635            wute=2.2960505e-007
+ ua1=8.6882692e-010        wua1=1.2853124e-015       ub1=-3.8731538e-018
+ wub1=-1.3457473e-024      uc1=-6.421e-011           prt=0
+ at=280000                 jss=1.245e-07             jsws=3.77e-13
+ jswgs=3.00e-12            njs=1                     ijthsfwd=0.01
+ ijthsrev=0.01             bvs=10                    xjbvs=1
+ pbs=0.8                   cjs=cjp                   mjs=0.36
+ pbsws=0.8                 cjsws=cjswp               mjsws=0.01
+ pbswgs=1                  cjswgs=cjswgp             mjswgs=0.98
+ tpb=1.9e-03               tcj=8.54e-04              tpbsw=1.9e-03
+ tcjsw=3.57e-04            tpbswg=1.9e-03            tcjswg=3.12e-03
+ xtis=3                    dmcg=9.25e-008            dmci=9.25e-008
+ dmdg=0                    dmcgt=0                   dwj=0
+ xgw=0                     xgl=0                     rshg=0.1
+ gbmin=1e-012              rbpb=50                   rbpd=50
+ rbps=50                   rbdb=50                   rbsb=50
+ ngcon=1                   saref=0.63e-6             sbref=0.63e-6
+ kvsat=-0.9                wlod=0.8e-6               tku0=0.1
+ ku0=1.3249e-7             llodku0=1                 wlodku0=1
+ lku0=1.33e-7              wku0=6.5e-7               pku0=0
+ kvth0=-1.5e-9             stk2=4e-10                steta0=0
+ lkvth0=-1.68e-15          wkvth0=0.5e-6             pkvth0=0
+ llodvth=2                 wlodvth=1                 lodk2=2
+ lodeta0=1                 fnoimod=1                 noia=1.635e+42
+ noib=7.241e+26            noic=8.75                 em=1.50e+08
+ ef=1.19                   wpemod=wpeflag            kvth0we=-0.0028
+ lkvth0we=0                wkvth0we=0                pkvth0we=0
+ ku0we=-0.0045             lku0we=3.00e-10           wku0we=0
+ pku0we=0                  k2we=0.00045              wk2we=0
+ web=-180                  wec=-3000                 scref=1.00e-06
+ ud=0                      tnoimod=0                 minr=1e-3

     17: type=p
+ lmin=1.2000e-06-dxlp      lmax=1.0000e-05-dxlp      wmin=2.4000e-07-dxwp
+ wmax=5.0000e-07-dxwp      version=4.5               binunit=2
+ paramchk=1                mobmod=0                  capmod=2
+ igcmod=1                  igbmod=1                  diomod=1
+ rdsmod=0                  rbodymod=0                rgatemod=0
+ permod=1                  acnqsmod=0                trnqsmod=0
+ tnom=25                   toxe=toxp                 toxm=toxp
+ dtox=5.25e-010            epsrox=3.9                wint=5e-009
+ lint=2.5e-009             ll=0                      wl=0
+ lln=1                     wln=1                     lw=0
+ ww=0                      lwn=1                     wwn=1
+ lwl=0                     wwl=0                     llc=0
+ wlc=0                     lwc=0                     wwc=0
+ lwlc=0                    wwlc=0                    dlc=1.525e-008
+ dwc=0                     xpart=1                   toxref=3e-009
+ dlcig=2.5e-009            xl=-3.5e-08+dxlp          xw=1.5e-8+dxwp
+ vth0=-0.16127457+dvthp    lvth0=-1.8736728e-008+dlvthp
+ wvth0=1.1582996e-009+dwvthp                         pvth0=3.1238399e-016+dpvthp
+ k1=0.1623                 k2=0.010326241+dk2p       lk2=2.7071176e-008
+ wk2=-1.1970177e-009       pk2=-8.7467519e-016       k3=-0.58
+ k3b=0.8                   w0=0                      dvt0=10
+ dvt1=1.71                 dvt2=0.0928               dvt0w=0
+ dvt1w=0                   dvt2w=0                   dsub=0.5
+ minv=0                    voffl=0                   dvtp0=0
+ dvtp1=0                   lpe0=2.805e-007           lpeb=1e-007
+ xj=1.7000001e-007         ngate=8e019               ndep=1.7200001e017
+ nsd=1e020                 phin=0                    cdsc=0
+ cdscb=0                   cdscd=0                   lcdscd=0+dlcdscdp
+ cit=-0.0011318182         lcit=1.3129091e-009       voff=-0.094933472
+ lvoff=-1.7495019e-008+dlvoffp                       wvoff=-2.0072867e-010
+ pvoff=1.9992576e-015      nfactor=0.5               eta0=0.085
+ etab=-0.02                u0=0.0073512094           lu0=1.5057047e-009
+ wu0=1.1817901e-010        pu0=-7.7471231e-017       ua=-2.5827375e-010
+ lua=-8.8040654e-018       wua=-2.9440926e-018       pua=-6.2476799e-026
+ ub=1.9841061e-018         lub=5.0077383e-025        wub=-1.3642195e-025
+ pub=-6.2476799e-033       uc=1.2811219e-010         luc=-2.3892421e-018
+ wuc=-2.5043735e-017       puc=1.5487998e-023        vsat=120000
+ a0=3.62                   ags=1.0109773             lags=8.4682636e-007
+ a1=0                      a2=1                      b0=0
+ b1=0                      keta=-0.033707            lketa=-6.845508e-008
+ dwg=0                     dwb=0                     pclm=0.094545455
+ lpclm=1.0503273e-006      pdiblc1=0                 pdiblc2=0.0053726399
+ lpdiblc2=-3.711493e-009   wpdiblc2=-1.8818313e-010  ppdiblc2=1.874304e-015
+ pdiblcb=0                 drout=0                   pvag=0
+ delta=0.02                pscbe1=9.264e008          pscbe2=1e-020
+ fprout=1000               pdits=0                   pditsd=0
+ pditsl=0                  rsh=9.68                  rdsw=210+drdswp
+ prwg=0                    prwb=0                    wr=1
+ alpha0=0                  alpha1=0.06               beta0=12
+ agidl=9e-008              bgidl=2.3e009             cgidl=0.5
+ egidl=0.53                aigbacc=0.01069           bigbacc=0.003132
+ cigbacc=0.1498            nigbacc=4.049             aigbinv=0.35
+ bigbinv=0.03              cigbinv=0.006             eigbinv=1.1
+ nigbinv=1                 aigc=0.00606              bigc=0.0007625
+ cigc=1e-010               aigsd=0.0045661346        waigsd=6.7097019e-011
+ bigsd=0                   cigsd=0.002267            nigc=1
+ poxedge=1                 pigcd=2.3                 ntox=ntoxp
+ xrcrg1=12                 xrcrg2=1                  cgso=cgop
+ cgdo=cgop                 cgbo=0                    cgdl=cglp
+ cgsl=cglp                 clc=1e-007                cle=0.6
+ cf=cfp                    ckappas=0.6               acde=1.2
+ moin=11.09                noff=2.175                voffcv=-0.03885
+ kt1=-0.240455             lkt1=-3.03282e-008        kt1l=0
+ kt2=-0.069280264          lkt2=4.6052306e-008       wkt2=1.0114778e-008
+ pkt2=-1.1733143e-014      ute=-1.6265726            lute=9.5525498e-007
+ wute=2.7517673e-007       pute=-4.5389394e-013      ua1=3.7228558e-010
+ lua1=4.9455518e-015       wua1=1.5290096e-015       pua1=-2.4272236e-021
+ ub1=-3.5409822e-018       lub1=-3.3084299e-024      wub1=-1.5893817e-024
+ pub1=2.4265989e-030       uc1=-6.421e-011           prt=0
+ at=280000                 jss=1.245e-07             jsws=3.77e-13
+ jswgs=3.00e-12            njs=1                     ijthsfwd=0.01
+ ijthsrev=0.01             bvs=10                    xjbvs=1
+ pbs=0.8                   cjs=cjp                   mjs=0.36
+ pbsws=0.8                 cjsws=cjswp               mjsws=0.01
+ pbswgs=1                  cjswgs=cjswgp             mjswgs=0.98
+ tpb=1.9e-03               tcj=8.54e-04              tpbsw=1.9e-03
+ tcjsw=3.57e-04            tpbswg=1.9e-03            tcjswg=3.12e-03
+ xtis=3                    dmcg=9.25e-008            dmci=9.25e-008
+ dmdg=0                    dmcgt=0                   dwj=0
+ xgw=0                     xgl=0                     rshg=0.1
+ gbmin=1e-012              rbpb=50                   rbpd=50
+ rbps=50                   rbdb=50                   rbsb=50
+ ngcon=1                   saref=0.63e-6             sbref=0.63e-6
+ kvsat=-0.9                wlod=0.8e-6               tku0=0.1
+ ku0=1.3249e-7             llodku0=1                 wlodku0=1
+ lku0=1.33e-7              wku0=6.5e-7               pku0=0
+ kvth0=-1.5e-9             stk2=4e-10                steta0=0
+ lkvth0=-1.68e-15          wkvth0=0.5e-6             pkvth0=0
+ llodvth=2                 wlodvth=1                 lodk2=2
+ lodeta0=1                 fnoimod=1                 noia=1.635e+42
+ noib=7.241e+26            noic=8.75                 em=1.50e+08
+ ef=1.19                   wpemod=wpeflag            kvth0we=-0.0028
+ lkvth0we=0                wkvth0we=0                pkvth0we=0
+ ku0we=-0.0045             lku0we=3.00e-10           wku0we=0
+ pku0we=0                  k2we=0.00045              wk2we=0
+ web=-180                  wec=-3000                 scref=1.00e-06
+ ud=0                      tnoimod=0                 minr=1e-3

     18: type=p
+ lmin=5.0000e-07-dxlp      lmax=1.2000e-06-dxlp      wmin=2.4000e-07-dxwp
+ wmax=5.0000e-07-dxwp      version=4.5               binunit=2
+ paramchk=1                mobmod=0                  capmod=2
+ igcmod=1                  igbmod=1                  diomod=1
+ rdsmod=0                  rbodymod=0                rgatemod=0
+ permod=1                  acnqsmod=0                trnqsmod=0
+ tnom=25                   toxe=toxp                 toxm=toxp
+ dtox=5.25e-010            epsrox=3.9                wint=5e-009
+ lint=2.5e-009             ll=0                      wl=0
+ lln=1                     wln=1                     lw=0
+ ww=0                      lwn=1                     wwn=1
+ lwl=0                     wwl=0                     llc=0
+ wlc=0                     lwc=0                     wwc=0
+ lwlc=0                    wwlc=0                    dlc=1.525e-008
+ dwc=0                     xpart=1                   toxref=3e-009
+ dlcig=2.5e-009            xl=-3.5e-08+dxlp          xw=1.5e-8+dxwp
+ vth0=-0.170695+dvthp      lvth0=-7.8090308e-009+dlvthp
+ wvth0=5.83275e-010+dwvthp pvth0=9.7941254e-016+dpvthp
+ k1=0.1623                 k2=0.033746868+dk2p       lk2=-9.6751648e-011
+ wk2=-2.8891827e-009       pk2=1.0882362e-015        k3=-0.58
+ k3b=0.8                   w0=0                      dvt0=10
+ dvt1=1.71                 dvt2=0.0928               dvt0w=0
+ dvt1w=0                   dvt2w=0                   dsub=0.5
+ minv=0                    voffl=0                   dvtp0=0
+ dvtp1=0                   lpe0=2.805e-007           lpeb=1e-007
+ xj=1.7000001e-007         ngate=8e019               ndep=1.7200001e017
+ nsd=1e020                 phin=0                    cdsc=0
+ cdscb=0                   cdscd=0                   lcdscd=0+dlcdscdp
+ cit=-0.00065714286        lcit=7.6228571e-010       voff=-0.10394819
+ lvoff=-7.0379495e-009+dlvoffp                       wvoff=2.2420058e-009
+ pvoff=-8.3431438e-016     nfactor=0.5               eta0=0.085
+ etab=-0.02                u0=0.0087725462           lu0=-1.4304585e-010
+ wu0=9.8300192e-011        pu0=-5.4411808e-017       ua=-1.1068956e-011
+ lua=-2.9556163e-016       wua=-3.3732058e-018       pua=4.3529446e-025
+ ub=2.1344242e-018         lub=3.2640488e-025        wub=-1.5369092e-025
+ pub=1.3784325e-032        uc=1.4060986e-010         luc=-1.6886534e-017
+ wuc=-1.9375335e-017       puc=8.9126541e-024        vsat=120000
+ a0=3.62                   ags=0.92877143            lags=9.4218514e-007
+ a1=0                      a2=1                      b0=0
+ b1=0                      keta=-0.052778857         lketa=-4.6331726e-008
+ dwg=0                     dwb=0                     pclm=1
+ pdiblc1=0                 pdiblc2=0.00031538462     lpdiblc2=2.1549231e-009
+ wpdiblc2=2.3657308e-009   ppdiblc2=-1.0882362e-015  pdiblcb=0
+ drout=0                   pvag=0                    delta=0.02
+ pscbe1=9.264e008          pscbe2=1e-020             fprout=1000
+ pdits=0                   pditsd=0                  pditsl=0
+ rsh=9.68                  rdsw=210+drdswp           prwg=0
+ prwb=0                    wr=1                      alpha0=0
+ alpha1=0.06               beta0=12                  agidl=9e-008
+ bgidl=2.3e009             cgidl=0.5                 egidl=0.53
+ aigbacc=0.01069           bigbacc=0.003132          cigbacc=0.1498
+ nigbacc=4.049             aigbinv=0.35              bigbinv=0.03
+ cigbinv=0.006             eigbinv=1.1               nigbinv=1
+ aigc=0.00606              bigc=0.0007625            cigc=1e-010
+ aigsd=0.0045661346        waigsd=6.7097019e-011     bigsd=0
+ cigsd=0.002267            nigc=1                    poxedge=1
+ pigcd=2.3                 ntox=ntoxp                xrcrg1=12
+ xrcrg2=1                  cgso=cgop                 cgdo=cgop
+ cgbo=0                    cgdl=cglp                 cgsl=cglp
+ clc=1e-007                cle=0.6                   cf=cfp
+ ckappas=0.6               acde=1.2                  moin=11.09
+ noff=2.175                voffcv=-0.03885           kt1=-0.25707143
+ lkt1=-1.1053143e-008      kt1l=0                    kt2=-0.02958
+ ute=-0.1953967            lute=-7.0490905e-007      wute=-2.2055681e-007
+ pute=1.2115696e-013       ua1=7.2310224e-009        lua1=-3.0105829e-015
+ wua1=-1.0229855e-015      pua1=5.3309062e-022       ub1=-7.9872423e-018
+ lub1=1.8492318e-024       wub1=8.0115337e-025       pub1=-3.4642184e-031
+ uc1=-6.421e-011           prt=0                     at=285126.98
+ lat=-0.0059472945         wat=-0.00053160962        pat=6.1666715e-010
+ jss=1.245e-07             jsws=3.77e-13             jswgs=3.00e-12
+ njs=1                     ijthsfwd=0.01             ijthsrev=0.01
+ bvs=10                    xjbvs=1                   pbs=0.8
+ cjs=cjp                   mjs=0.36                  pbsws=0.8
+ cjsws=cjswp               mjsws=0.01                pbswgs=1
+ cjswgs=cjswgp             mjswgs=0.98               tpb=1.9e-03
+ tcj=8.54e-04              tpbsw=1.9e-03             tcjsw=3.57e-04
+ tpbswg=1.9e-03            tcjswg=3.12e-03           xtis=3
+ dmcg=9.25e-008            dmci=9.25e-008            dmdg=0
+ dmcgt=0                   dwj=0                     xgw=0
+ xgl=0                     rshg=0.1                  gbmin=1e-012
+ rbpb=50                   rbpd=50                   rbps=50
+ rbdb=50                   rbsb=50                   ngcon=1
+ saref=0.63e-6             sbref=0.63e-6             kvsat=-0.9
+ wlod=0.8e-6               tku0=0.1                  ku0=1.3249e-7
+ llodku0=1                 wlodku0=1                 lku0=1.33e-7
+ wku0=6.5e-7               pku0=0                    kvth0=-1.5e-9
+ stk2=4e-10                steta0=0                  lkvth0=-1.68e-15
+ wkvth0=0.5e-6             pkvth0=0                  llodvth=2
+ wlodvth=1                 lodk2=2                   lodeta0=1
+ fnoimod=1                 noia=1.635e+42            noib=7.241e+26
+ noic=8.75                 em=1.50e+08               ef=1.19
+ wpemod=wpeflag            kvth0we=-0.0028           lkvth0we=0
+ wkvth0we=0                pkvth0we=0                ku0we=-0.0045
+ lku0we=3.00e-10           wku0we=0                  pku0we=0
+ k2we=0.00045              wk2we=0                   web=-180
+ wec=-3000                 scref=1.00e-06            ud=0
+ tnoimod=0                 minr=1e-3

     19: type=p
+ lmin=2.4000e-07-dxlp      lmax=5.0000e-07-dxlp      wmin=2.4000e-07-dxwp
+ wmax=5.0000e-07-dxwp      version=4.5               binunit=2
+ paramchk=1                mobmod=0                  capmod=2
+ igcmod=1                  igbmod=1                  diomod=1
+ rdsmod=0                  rbodymod=0                rgatemod=0
+ permod=1                  acnqsmod=0                trnqsmod=0
+ tnom=25                   toxe=toxp                 toxm=toxp
+ dtox=5.25e-010            epsrox=3.9                wint=5e-009
+ lint=2.5e-009             ll=0                      wl=0
+ lln=1                     wln=1                     lw=0
+ ww=0                      lwn=1                     wwn=1
+ lwl=0                     wwl=0                     llc=0
+ wlc=0                     lwc=0                     wwc=0
+ lwlc=0                    wwlc=0                    dlc=1.525e-008
+ dwc=0                     xpart=1                   toxref=3e-009
+ dlcig=2.5e-009            xl=-3.5e-08+dxlp          xw=1.5e-8+dxwp
+ vth0=-0.20347145+dvthp    lvth0=7.2681361e-009+dlvthp
+ wvth0=4.359659e-009+dwvthp                          pvth0=-7.5772411e-016+dpvthp
+ k1=0.1623                 k2=0.032807249+dk2p       lk2=3.3547337e-010
+ wk2=-1.9400666e-010       pk2=-1.5154482e-016       k3=-0.58
+ k3b=0.8                   w0=0                      dvt0=10
+ dvt1=1.71                 dvt2=0.0928               dvt0w=0
+ dvt1w=0                   dvt2w=0                   dsub=0.5
+ minv=0                    voffl=0                   dvtp0=0
+ dvtp1=0                   lpe0=2.805e-007           lpeb=1e-007
+ xj=1.7000001e-007         ngate=8e019               ndep=1.7200001e017
+ nsd=1e020                 phin=0                    cdsc=0
+ cdscb=0                   cdscd=0                   lcdscd=0+dlcdscdp
+ cit=0.001                 voff=-0.11115044          lvoff=-3.7249112e-009+dlvoffp
+ wvoff=-6.6987204e-010     pvoff=5.0514941e-016      nfactor=1.0073964
+ lnfactor=-2.3340237e-007  wnfactor=-2.5623521e-007  pnfactor=1.178682e-013
+ eta0=0.096982249          leta0=-5.5118343e-009     weta0=3.660503e-009
+ peta0=-1.6838314e-015     etab=-0.02                u0=0.0094787959
+ lu0=-4.6792071e-010       wu0=-6.8304985e-011       pu0=2.2226574e-017
+ ua=-6.7136642e-010        lua=8.1752071e-018        wua=-3.085804e-018
+ pua=3.0308964e-025        ub=3.1876686e-018         lub=-1.5808757e-025
+ wub=-1.6325843e-025       pub=1.8185379e-032        uc=8.5724556e-011
+ luc=8.3607041e-018        wuc=1.1750214e-017        puc=-5.4050987e-024
+ vsat=120000               a0=3.62                   ags=-0.19915385
+ lags=1.4610308e-006       a1=0                      a2=1
+ b0=0                      b1=0                      keta=-0.1405
+ lketa=-5.98e-009          dwg=0                     dwb=0
+ pclm=1.3769231            lpclm=-1.7338462e-007     pdiblc1=0
+ pdiblc2=0.005             pdiblcb=0                 drout=0
+ pvag=0                    delta=0.02                pscbe1=9.264e008
+ pscbe2=1e-020             fprout=1000               pdits=0
+ pditsd=0                  pditsl=0                  rsh=9.68
+ rdsw=210+drdswp           prwg=0                    prwb=0
+ wr=1                      alpha0=0                  alpha1=0.06
+ beta0=12                  agidl=9e-008              bgidl=2.3e009
+ cgidl=0.5                 egidl=0.53                aigbacc=0.01069
+ bigbacc=0.003132          cigbacc=0.1498            nigbacc=4.049
+ aigbinv=0.35              bigbinv=0.03              cigbinv=0.006
+ eigbinv=1.1               nigbinv=1                 aigc=0.00606
+ bigc=0.0007625            cigc=1e-010               aigsd=0.0045661346
+ waigsd=6.7097019e-011     bigsd=0                   cigsd=0.002267
+ nigc=1                    poxedge=1                 pigcd=2.3
+ ntox=ntoxp                xrcrg1=12                 xrcrg2=1
+ cgso=cgop                 cgdo=cgop                 cgbo=0
+ cgdl=cglp                 cgsl=cglp                 clc=1e-007
+ cle=0.6                   cf=cfp                    ckappas=0.6
+ acde=1.2                  moin=11.09                noff=2.175
+ voffcv=-0.03885           kt1=-0.29225385           lkt1=5.1307692e-009
+ kt1l=0                    kt2=-0.022526154          lkt2=-3.2447692e-009
+ ute=-1.9332959            lute=9.4524556e-008       wute=1.0249408e-008
+ pute=1.4986099e-014       ua1=6.8935976e-010        lua1=-1.4181065e-018
+ wua1=3.9826272e-018       pua1=6.0685282e-023       ub1=-4.7279127e-018
+ lub1=3.4994024e-025       wub1=2.2596285e-025       pub1=-8.1834204e-032
+ uc1=-6.421e-011           prt=0                     at=317007.25
+ lat=-0.020612219          wat=0.003041878           pat=-1.0271371e-009
+ jss=1.245e-07             jsws=3.77e-13             jswgs=3.00e-12
+ njs=1                     ijthsfwd=0.01             ijthsrev=0.01
+ bvs=10                    xjbvs=1                   pbs=0.8
+ cjs=cjp                   mjs=0.36                  pbsws=0.8
+ cjsws=cjswp               mjsws=0.01                pbswgs=1
+ cjswgs=cjswgp             mjswgs=0.98               tpb=1.9e-03
+ tcj=8.54e-04              tpbsw=1.9e-03             tcjsw=3.57e-04
+ tpbswg=1.9e-03            tcjswg=3.12e-03           xtis=3
+ dmcg=9.25e-008            dmci=9.25e-008            dmdg=0
+ dmcgt=0                   dwj=0                     xgw=0
+ xgl=0                     rshg=0.1                  gbmin=1e-012
+ rbpb=50                   rbpd=50                   rbps=50
+ rbdb=50                   rbsb=50                   ngcon=1
+ saref=0.63e-6             sbref=0.63e-6             kvsat=-0.9
+ wlod=0.8e-6               tku0=0.1                  ku0=1.3249e-7
+ llodku0=1                 wlodku0=1                 lku0=1.33e-7
+ wku0=6.5e-7               pku0=0                    kvth0=-1.5e-9
+ stk2=4e-10                steta0=0                  lkvth0=-1.68e-15
+ wkvth0=0.5e-6             pkvth0=0                  llodvth=2
+ wlodvth=1                 lodk2=2                   lodeta0=1
+ fnoimod=1                 noia=1.635e+42            noib=7.241e+26
+ noic=8.75                 em=1.50e+08               ef=1.19
+ wpemod=wpeflag            kvth0we=-0.0028           lkvth0we=0
+ wkvth0we=0                pkvth0we=0                ku0we=-0.0045
+ lku0we=3.00e-10           wku0we=0                  pku0we=0
+ k2we=0.00045              wk2we=0                   web=-180
+ wec=-3000                 scref=1.00e-06            ud=0
+ tnoimod=0                 minr=1e-3

     20: type=p
+ lmin=1.000e-07            lmax=2.4000e-07-dxlp      wmin=2.4000e-07-dxwp
+ wmax=5.0000e-07-dxwp      version=4.5               binunit=2
+ paramchk=1                mobmod=0                  capmod=2
+ igcmod=1                  igbmod=1                  diomod=1
+ rdsmod=0                  rbodymod=0                rgatemod=0
+ permod=1                  acnqsmod=0                trnqsmod=0
+ tnom=25                   toxe=toxp                 toxm=toxp
+ dtox=5.25e-010            epsrox=3.9                wint=5e-009
+ lint=2.5e-009             ll=0                      wl=0
+ lln=1                     wln=1                     lw=0
+ ww=0                      lwn=1                     wwn=1
+ lwl=0                     wwl=0                     llc=0
+ wlc=0                     lwc=0                     wwc=0
+ lwlc=0                    wwlc=0                    dlc=1.525e-008
+ dwc=0                     xpart=1                   toxref=3e-009
+ dlcig=2.5e-009            xl=-3.5e-08+dxlp          xw=1.5e-8+dxwp
+ vth0=-0.18731978+dvthp    lvth0=4.0378022e-009+dlvthp
+ wvth0=4.0788462e-009+dwvthp                         pvth0=-7.0156154e-016+dpvthp
+ k1=0.1623                 k2=0.030154396+dk2p       lk2=8.6604396e-010
+ wk2=-2.5832692e-010       pk2=-1.3868077e-016       k3=-0.58
+ k3b=0.8                   w0=0                      dvt0=10
+ dvt1=1.71                 dvt2=0.0928               dvt0w=0
+ dvt1w=0                   dvt2w=0                   dsub=0.5
+ minv=0                    voffl=0                   dvtp0=0
+ dvtp1=0                   lpe0=2.805e-007           lpeb=1e-007
+ xj=1.7000001e-007         ngate=8e019               ndep=1.7200001e017
+ nsd=1e020                 phin=0                    cdsc=0
+ cdscb=0                   cdscd=0                   lcdscd=0+dlcdscdp
+ cit=-0.00028571429        lcit=2.5714286e-010       voff=-0.14156978
+ lvoff=2.358956e-009+dlvoffp                         wvoff=7.7905962e-009
+ pvoff=-1.1869442e-015     nfactor=-1.1914835        lnfactor=2.0637363e-007
+ wnfactor=6.5941346e-007   pnfactor=-6.5261538e-014  eta0=0.060975275
+ leta0=1.6895604e-009      weta0=-3.7389423e-009     peta0=-2.0394231e-016
+ etab=-0.015371429         letab=-9.2571429e-010     u0=0.0082666484
+ lu0=-2.2549121e-010       wu0=-4.0788462e-012       pu0=9.3813462e-018
+ ua=-4.196728e-010         lua=-4.2163516e-017       wua=-2.3106663e-017
+ pua=4.3072615e-024        ub=2.5266099e-018         lub=-2.5875824e-026
+ wub=-1.1515942e-025       pub=8.5655769e-033        uc=1.2018063e-010
+ luc=1.469489e-018         wuc=-1.6244005e-017       puc=1.9374519e-025
+ vsat=120000               a0=3.62                   ags=5.7420879
+ lags=2.7278242e-007       wags=-1.0197115e-006      pags=2.0394231e-013
+ a1=0                      a2=1                      b0=0
+ b1=0                      keta=-0.25759203          lketa=1.7438407e-008
+ wketa=3.3650481e-009      pketa=-6.7300962e-016     dwg=0
+ dwb=0                     pclm=0.64285714           lpclm=-2.6571429e-008
+ pdiblc1=0                 pdiblc2=0.005             pdiblcb=0
+ drout=0                   pvag=0                    delta=0.02
+ pscbe1=9.264e008          pscbe2=1e-020             fprout=1000
+ pdits=0                   pditsd=0                  pditsl=0
+ rsh=9.68                  rdsw=210+drdswp           prwg=0
+ prwb=0                    wr=1                      alpha0=0
+ alpha1=0.06               beta0=12                  agidl=9e-008
+ bgidl=2.3e009             cgidl=0.5                 egidl=0.53
+ aigbacc=0.01069           bigbacc=0.003132          cigbacc=0.1498
+ nigbacc=4.049             aigbinv=0.35              bigbinv=0.03
+ cigbinv=0.006             eigbinv=1.1               nigbinv=1
+ aigc=0.00606              bigc=0.0007625            cigc=1e-010
+ aigsd=0.0045661346        waigsd=6.7097019e-011     bigsd=0
+ cigsd=0.002267            nigc=1                    poxedge=1
+ pigcd=2.3                 ntox=ntoxp                xrcrg1=12
+ xrcrg2=1                  cgso=cgop                 cgdo=cgop
+ cgbo=0                    cgdl=cglp                 cgsl=cglp
+ clc=1e-007                cle=0.6                   cf=cfp
+ ckappas=0.6               acde=1.2                  moin=11.09
+ noff=2.175                voffcv=-0.03885           kt1=-0.22575055
+ lkt1=-8.1698901e-009      wkt1=-9.1366154e-009      pkt1=1.8273231e-015
+ kt1l=0                    kt2=-0.03875              ute=-1.6088022
+ lute=2.9625824e-008       wute=1.2535654e-007       pute=-8.0353269e-015
+ ua1=6.2287088e-010        lua1=1.187967e-017        wua1=3.0883663e-016
+ pua1=-2.8551923e-025      ub1=-3.630489e-018        lub1=1.3045549e-025
+ wub1=-1.6995192e-026      pub1=-3.3242596e-032      uc1=-6.421e-011
+ prt=0                     at=283012.83              lat=-0.013813335
+ wat=-0.0029931933         pat=1.7987712e-010        jss=1.245e-07
+ jsws=3.77e-13             jswgs=3.00e-12            njs=1
+ ijthsfwd=0.01             ijthsrev=0.01             bvs=10
+ xjbvs=1                   pbs=0.8                   cjs=cjp
+ mjs=0.36                  pbsws=0.8                 cjsws=cjswp
+ mjsws=0.01                pbswgs=1                  cjswgs=cjswgp
+ mjswgs=0.98               tpb=1.9e-03               tcj=8.54e-04
+ tpbsw=1.9e-03             tcjsw=3.57e-04            tpbswg=1.9e-03
+ tcjswg=3.12e-03           xtis=3                    dmcg=9.25e-008
+ dmci=9.25e-008            dmdg=0                    dmcgt=0
+ dwj=0                     xgw=0                     xgl=0
+ rshg=0.1                  gbmin=1e-012              rbpb=50
+ rbpd=50                   rbps=50                   rbdb=50
+ rbsb=50                   ngcon=1                   saref=0.63e-6
+ sbref=0.63e-6             kvsat=-0.9                wlod=0.8e-6
+ tku0=0.1                  ku0=1.3249e-7             llodku0=1
+ wlodku0=1                 lku0=1.33e-7              wku0=6.5e-7
+ pku0=0                    kvth0=-1.5e-9             stk2=4e-10
+ steta0=0                  lkvth0=-1.68e-15          wkvth0=0.5e-6
+ pkvth0=0                  llodvth=2                 wlodvth=1
+ lodk2=2                   lodeta0=1                 fnoimod=1
+ noia=1.635e+42            noib=7.241e+26            noic=8.75
+ em=1.50e+08               ef=1.19                   wpemod=wpeflag
+ kvth0we=-0.0028           lkvth0we=0                wkvth0we=0
+ pkvth0we=0                ku0we=-0.0045             lku0we=3.00e-10
+ wku0we=0                  pku0we=0                  k2we=0.00045
+ wk2we=0                   web=-180                  wec=-3000
+ scref=1.00e-06            ud=0                      tnoimod=0
+ minr=1e-3

     21: type=p
+ lmin=1.0000e-05-dxlp      lmax=2.001e-05            wmin=1.200e-07
+ wmax=2.4000e-07-dxwp      version=4.5               binunit=2
+ paramchk=1                mobmod=0                  capmod=2
+ igcmod=1                  igbmod=1                  diomod=1
+ rdsmod=0                  rbodymod=0                rgatemod=0
+ permod=1                  acnqsmod=0                trnqsmod=0
+ tnom=25                   toxe=toxp                 toxm=toxp
+ dtox=5.25e-010            epsrox=3.9                wint=5e-009
+ lint=2.5e-009             ll=0                      wl=0
+ lln=1                     wln=1                     lw=0
+ ww=0                      lwn=1                     wwn=1
+ lwl=0                     wwl=0                     llc=0
+ wlc=0                     lwc=0                     wwc=0
+ lwlc=0                    wwlc=0                    dlc=1.525e-008
+ dwc=0                     xpart=1                   toxref=3e-009
+ dlcig=2.5e-009            xl=-3.5e-08+dxlp          xw=1.5e-8+dxwp
+ vth0=-0.15246667+dvthp    wvth0=-1.4291667e-009+dwvthp
+ lvth0=0+dlvthp            pvth0=0+dpvthp            k1=0.1623
+ k2=0.0131125+dk2p         wk2=-1.3015625e-009       k3=-0.58
+ k3b=0.8                   w0=0                      dvt0=10
+ dvt1=1.71                 dvt2=0.0928               dvt0w=0
+ dvt1w=0                   dvt2w=0                   dsub=0.5
+ minv=0                    voffl=0                   dvtp0=0
+ dvtp1=0                   lpe0=2.805e-007           lpeb=1e-007
+ xj=1.7000001e-007         ngate=8e019               ndep=1.7200001e017
+ nsd=1e020                 phin=0                    cdsc=0
+ cdscb=0                   cdscd=0                   lcdscd=0+dlcdscdp
+ cit=-0.001                voff=-0.09669             nfactor=0.5
+ lvoff=0+dlvoffp           eta0=0.085                etab=-0.02
+ u0=0.0072884167           wu0=1.6282292e-010        ua=-2.577625e-010
+ wua=-3.2921875e-018       ub=1.6645833e-018         wub=-4.6447917e-026
+ uc=3.2e-011               vsat=120000               a0=3.62
+ ags=1.096                 a1=0                      a2=1
+ b0=0                      b1=0                      keta=-0.04058
+ dwg=0                     dwb=0                     pclm=0.2
+ pdiblc1=0                 pdiblc2=0.005             pdiblcb=0
+ drout=0                   pvag=0                    delta=0.02
+ pscbe1=9.264e008          pscbe2=1e-020             fprout=1000
+ pdits=0                   pditsd=0                  pditsl=0
+ rsh=9.68                  rdsw=210+drdswp           prwg=0
+ prwb=0                    wr=1                      alpha0=0
+ alpha1=0.06               beta0=12                  agidl=9e-008
+ bgidl=2.3e009             cgidl=0.5                 egidl=0.53
+ aigbacc=0.01069           bigbacc=0.003132          cigbacc=0.1498
+ nigbacc=4.049             aigbinv=0.35              bigbinv=0.03
+ cigbinv=0.006             eigbinv=1.1               nigbinv=1
+ aigc=0.00606              bigc=0.0007625            cigc=1e-010
+ aigsd=0.00479             waigsd=1.225e-011         bigsd=0
+ cigsd=0.002267            nigc=1                    poxedge=1
+ pigcd=2.3                 ntox=ntoxp                xrcrg1=12
+ xrcrg2=1                  cgso=cgop                 cgdo=cgop
+ cgbo=0                    cgdl=cglp                 cgsl=cglp
+ clc=1e-007                cle=0.6                   cf=cfp
+ ckappas=0.6               acde=1.2                  moin=11.09
+ noff=2.175                voffcv=-0.03885           kt1=-0.2435
+ kt1l=0                    kt2=-0.040825833          wkt2=3.0982292e-009
+ ute=0.032020833           wute=-1.532526e-007       ua1=9.6410417e-009
+ wua1=-8.6388021e-016      ub1=-1.3735792e-017       wub1=1.070599e-024
+ uc1=-6.421e-011           prt=0                     at=280000
+ jss=1.245e-07             jsws=3.77e-13             jswgs=3.00e-12
+ njs=1                     ijthsfwd=0.01             ijthsrev=0.01
+ bvs=10                    xjbvs=1                   pbs=0.8
+ cjs=cjp                   mjs=0.36                  pbsws=0.8
+ cjsws=cjswp               mjsws=0.01                pbswgs=1
+ cjswgs=cjswgp             mjswgs=0.98               tpb=1.9e-03
+ tcj=8.54e-04              tpbsw=1.9e-03             tcjsw=3.57e-04
+ tpbswg=1.9e-03            tcjswg=3.12e-03           xtis=3
+ dmcg=9.25e-008            dmci=9.25e-008            dmdg=0
+ dmcgt=0                   dwj=0                     xgw=0
+ xgl=0                     rshg=0.1                  gbmin=1e-012
+ rbpb=50                   rbpd=50                   rbps=50
+ rbdb=50                   rbsb=50                   ngcon=1
+ saref=0.63e-6             sbref=0.63e-6             kvsat=-0.9
+ wlod=0.8e-6               tku0=0.1                  ku0=1.3249e-7
+ llodku0=1                 wlodku0=1                 lku0=1.33e-7
+ wku0=6.5e-7               pku0=0                    kvth0=-1.5e-9
+ stk2=4e-10                steta0=0                  lkvth0=-1.68e-15
+ wkvth0=0.5e-6             pkvth0=0                  llodvth=2
+ wlodvth=1                 lodk2=2                   lodeta0=1
+ fnoimod=1                 noia=1.635e+42            noib=7.241e+26
+ noic=8.75                 em=1.50e+08               ef=1.19
+ wpemod=wpeflag            kvth0we=-0.0028           lkvth0we=0
+ wkvth0we=0                pkvth0we=0                ku0we=-0.0045
+ lku0we=3.00e-10           wku0we=0                  pku0we=0
+ k2we=0.00045              wk2we=0                   web=-180
+ wec=-3000                 scref=1.00e-06            ud=0
+ tnoimod=0                 minr=1e-3

     22: type=p
+ lmin=1.2000e-06-dxlp      lmax=1.0000e-05-dxlp      wmin=1.200e-07
+ wmax=2.4000e-07-dxwp      version=4.5               binunit=2
+ paramchk=1                mobmod=0                  capmod=2
+ igcmod=1                  igbmod=1                  diomod=1
+ rdsmod=0                  rbodymod=0                rgatemod=0
+ permod=1                  acnqsmod=0                trnqsmod=0
+ tnom=25                   toxe=toxp                 toxm=toxp
+ dtox=5.25e-010            epsrox=3.9                wint=5e-009
+ lint=2.5e-009             ll=0                      wl=0
+ lln=1                     wln=1                     lw=0
+ ww=0                      lwn=1                     wwn=1
+ lwl=0                     wwl=0                     llc=0
+ wlc=0                     lwc=0                     wwc=0
+ lwlc=0                    wwlc=0                    dlc=1.525e-008
+ dwc=0                     xpart=1                   toxref=3e-009
+ dlcig=2.5e-009            xl=-3.5e-08+dxlp          xw=1.5e-8+dxwp
+ vth0=-0.14884606+dvthp    lvth0=-3.6061236e-008+dlvthp
+ wvth0=-1.8866856e-009+dwvthp                        pvth0=4.5568886e-015+dpvthp
+ k1=0.1623                 k2=0.01082161+dk2p        lk2=2.2817266e-008
+ wk2=-1.318383e-009        pk2=1.6753267e-016        k3=-0.58
+ k3b=0.8                   w0=0                      dvt0=10
+ dvt1=1.71                 dvt2=0.0928               dvt0w=0
+ dvt1w=0                   dvt2w=0                   dsub=0.5
+ minv=0                    voffl=0                   dvtp0=0
+ dvtp1=0                   lpe0=2.805e-007           lpeb=1e-007
+ xj=1.7000001e-007         ngate=8e019               ndep=1.7200001e017
+ nsd=1e020                 phin=0                    cdsc=0
+ cdscb=0                   cdscd=0                   lcdscd=0+dlcdscdp
+ cit=-0.0011318182         lcit=1.3129091e-009       voff=-0.094613095
+ lvoff=-2.0685977e-008+dlvoffp                       wvoff=-2.7922112e-010
+ pvoff=2.7810423e-015      nfactor=0.63731061        lnfactor=-1.3676136e-006
+ wnfactor=-3.3641098e-008  pnfactor=3.3506534e-013   eta0=0.085
+ etab=-0.02                u0=0.0070875642           lu0=2.0004905e-009
+ wu0=1.8277209e-010        pu0=-1.9869375e-016       ua=-2.5613894e-010
+ lua=-1.6170664e-017       wua=-3.4671212e-018       pua=1.7423398e-024
+ ub=1.5913254e-018         lub=7.2964923e-025        wub=-4.0190672e-026
+ pub=-6.2322153e-032       uc=2.1762561e-011         luc=1.019649e-016
+ wuc=1.0119242e-018        puc=-1.0078765e-023       vsat=120000
+ a0=3.62                   ags=1.0109773             lags=8.4682636e-007
+ a1=0                      a2=1                      b0=0
+ b1=0                      keta=-0.031287587         lketa=-9.2552432e-008
+ wketa=-5.9275616e-010     pketa=5.9038513e-015      dwg=0
+ dwb=0                     pclm=0.094545455          lpclm=1.0503273e-006
+ pdiblc1=0                 pdiblc2=0.0041926136      lpdiblc2=8.0415682e-009
+ wpdiblc2=1.009233e-010    ppdiblc2=-1.005196e-015   pdiblcb=0
+ drout=0                   pvag=0                    delta=0.02
+ pscbe1=9.264e008          pscbe2=1e-020             fprout=1000
+ pdits=0                   pditsd=0                  pditsl=0
+ rsh=9.68                  rdsw=210+drdswp           prwg=0
+ prwb=0                    wr=1                      alpha0=0
+ alpha1=0.06               beta0=12                  agidl=9e-008
+ bgidl=2.3e009             cgidl=0.5                 egidl=0.53
+ aigbacc=0.01069           bigbacc=0.003132          cigbacc=0.1498
+ nigbacc=4.049             aigbinv=0.35              bigbinv=0.03
+ cigbinv=0.006             eigbinv=1.1               nigbinv=1
+ aigc=0.00606              bigc=0.0007625            cigc=1e-010
+ aigsd=0.00479             waigsd=1.225e-011         bigsd=0
+ cigsd=0.002267            nigc=1                    poxedge=1
+ pigcd=2.3                 ntox=ntoxp                xrcrg1=12
+ xrcrg2=1                  cgso=cgop                 cgdo=cgop
+ cgbo=0                    cgdl=cglp                 cgsl=cglp
+ clc=1e-007                cle=0.6                   cf=cfp
+ ckappas=0.6               acde=1.2                  moin=11.09
+ noff=2.175                voffcv=-0.03885           kt1=-0.240455
+ lkt1=-3.03282e-008        kt1l=0                    kt2=-0.042308239
+ lkt2=1.4764757e-008       wkt2=3.5066321e-009       pkt2=-4.0676932e-015
+ ute=0.19866922            lute=-1.659818e-006       wute=-1.7200752e-007
+ pute=1.8679893e-013       ua1=1.055592e-008         lua1=-9.1121908e-015
+ wua1=-9.6598094e-016      pua1=1.0169233e-021       ub1=-1.4889344e-017
+ lub1=1.1489377e-023       wub1=1.1909668e-024       pub1=-1.1988638e-030
+ uc1=-6.421e-011           prt=0                     at=280000
+ jss=1.245e-07             jsws=3.77e-13             jswgs=3.00e-12
+ njs=1                     ijthsfwd=0.01             ijthsrev=0.01
+ bvs=10                    xjbvs=1                   pbs=0.8
+ cjs=cjp                   mjs=0.36                  pbsws=0.8
+ cjsws=cjswp               mjsws=0.01                pbswgs=1
+ cjswgs=cjswgp             mjswgs=0.98               tpb=1.9e-03
+ tcj=8.54e-04              tpbsw=1.9e-03             tcjsw=3.57e-04
+ tpbswg=1.9e-03            tcjswg=3.12e-03           xtis=3
+ dmcg=9.25e-008            dmci=9.25e-008            dmdg=0
+ dmcgt=0                   dwj=0                     xgw=0
+ xgl=0                     rshg=0.1                  gbmin=1e-012
+ rbpb=50                   rbpd=50                   rbps=50
+ rbdb=50                   rbsb=50                   ngcon=1
+ saref=0.63e-6             sbref=0.63e-6             kvsat=-0.9
+ wlod=0.8e-6               tku0=0.1                  ku0=1.3249e-7
+ llodku0=1                 wlodku0=1                 lku0=1.33e-7
+ wku0=6.5e-7               pku0=0                    kvth0=-1.5e-9
+ stk2=4e-10                steta0=0                  lkvth0=-1.68e-15
+ wkvth0=0.5e-6             pkvth0=0                  llodvth=2
+ wlodvth=1                 lodk2=2                   lodeta0=1
+ fnoimod=1                 noia=1.635e+42            noib=7.241e+26
+ noic=8.75                 em=1.50e+08               ef=1.19
+ wpemod=wpeflag            kvth0we=-0.0028           lkvth0we=0
+ wkvth0we=0                pkvth0we=0                ku0we=-0.0045
+ lku0we=3.00e-10           wku0we=0                  pku0we=0
+ k2we=0.00045              wk2we=0                   web=-180
+ wec=-3000                 scref=1.00e-06            ud=0
+ tnoimod=0                 minr=1e-3

     23: type=p
+ lmin=5.0000e-07-dxlp      lmax=1.2000e-06-dxlp      wmin=1.200e-07
+ wmax=2.4000e-07-dxwp      version=4.5               binunit=2
+ paramchk=1                mobmod=0                  capmod=2
+ igcmod=1                  igbmod=1                  diomod=1
+ rdsmod=0                  rbodymod=0                rgatemod=0
+ permod=1                  acnqsmod=0                trnqsmod=0
+ tnom=25                   toxe=toxp                 toxm=toxp
+ dtox=5.25e-010            epsrox=3.9                wint=5e-009
+ lint=2.5e-009             ll=0                      wl=0
+ lln=1                     wln=1                     lw=0
+ ww=0                      lwn=1                     wwn=1
+ lwl=0                     wwl=0                     llc=0
+ wlc=0                     lwc=0                     wwc=0
+ lwlc=0                    wwlc=0                    dlc=1.525e-008
+ dwc=0                     xpart=1                   toxref=3e-009
+ dlcig=2.5e-009            xl=-3.5e-08+dxlp          xw=1.5e-8+dxwp
+ vth0=-0.17664762+dvthp    lvth0=-3.8114286e-009+dlvthp
+ wvth0=2.0416667e-009+dwvthp                         pvth0=0+dpvthp
+ k1=0.1623                 k2=0.02640369+dk2p        lk2=4.7420524e-009
+ wk2=-1.0901042e-009       pk2=-9.7270833e-017       k3=-0.58
+ k3b=0.8                   w0=0                      dvt0=10
+ dvt1=1.71                 dvt2=0.0928               dvt0w=0
+ dvt1w=0                   dvt2w=0                   dsub=0.5
+ minv=0                    voffl=0                   dvtp0=0
+ dvtp1=0                   lpe0=2.805e-007           lpeb=1e-007
+ xj=1.7000001e-007         ngate=8e019               ndep=1.7200001e017
+ nsd=1e020                 phin=0                    cdsc=0
+ cdscb=0                   cdscd=0                   lcdscd=0+dlcdscdp
+ cit=-0.00065714286        lcit=7.6228571e-010       voff=-0.10097869
+ lvoff=-1.3301886e-008+dlvoffp                       wvoff=1.5144792e-009
+ pvoff=7.0035e-016         nfactor=-0.88392857       lnfactor=3.9702381e-007
+ wnfactor=3.390625e-007    pnfactor=-9.7270833e-014  eta0=0.085
+ etab=-0.02                u0=0.0090372238           lu0=-2.6111462e-010
+ wu0=3.3454167e-011        pu0=-2.5484958e-017       ua=-1.6063333e-011
+ lua=-2.9465837e-016       wua=-2.1495833e-018       pua=2.1399583e-025
+ ub=1.9178286e-018         lub=3.5090552e-025        wub=-1.00625e-025
+ pub=7.7816667e-033        uc=9.211406e-011          luc=2.0357158e-017
+ wuc=-7.4938646e-018       puc=-2.1205042e-025       vsat=120000
+ a0=3.62                   ags=0.92877143            lags=9.4218514e-007
+ a1=0                      a2=1                      b0=0
+ b1=0                      keta=-0.065328262         lketa=-5.306525e-008
+ wketa=3.0746042e-009      pketa=1.6497133e-015      dwg=0
+ dwb=0                     pclm=1                    pdiblc1=0
+ pdiblc2=0.01515           lpdiblc2=-4.669e-009      wpdiblc2=-1.26875e-009
+ ppdiblc2=5.83625e-016     pdiblcb=0                 drout=0
+ pvag=0                    delta=0.02                pscbe1=9.264e008
+ pscbe2=1e-020             fprout=1000               pdits=0
+ pditsd=0                  pditsl=0                  rsh=9.68
+ rdsw=210+drdswp           prwg=0                    prwb=0
+ wr=1                      alpha0=0                  alpha1=0.06
+ beta0=12                  agidl=9e-008              bgidl=2.3e009
+ cgidl=0.5                 egidl=0.53                aigbacc=0.01069
+ bigbacc=0.003132          cigbacc=0.1498            nigbacc=4.049
+ aigbinv=0.35              bigbinv=0.03              cigbinv=0.006
+ eigbinv=1.1               nigbinv=1                 aigc=0.00606
+ bigc=0.0007625            cigc=1e-010               aigsd=0.00479
+ waigsd=1.225e-011         bigsd=0                   cigsd=0.002267
+ nigc=1                    poxedge=1                 pigcd=2.3
+ ntox=ntoxp                xrcrg1=12                 xrcrg2=1
+ cgso=cgop                 cgdo=cgop                 cgbo=0
+ cgdl=cglp                 cgsl=cglp                 clc=1e-007
+ cle=0.6                   cf=cfp                    ckappas=0.6
+ acde=1.2                  moin=11.09                noff=2.175
+ voffcv=-0.03885           kt1=-0.25707143           lkt1=-1.1053143e-008
+ kt1l=0                    kt2=-0.02958              ute=-0.92077738
+ lute=-3.612599e-007       wute=-4.2838542e-008      pute=3.6962917e-014
+ ua1=3.9061667e-009        lua1=-1.3984767e-015      wua1=-2.0839583e-016
+ pua1=1.3812458e-022       ub1=-5.723419e-018        lub1=8.5690443e-025
+ wub1=2.4651667e-025       pub1=-1.0330162e-031      uc1=-6.421e-011
+ prt=0                     at=277138.69              lat=0.003319119
+ wat=0.0014255208          pat=-1.6536042e-009       jss=1.245e-07
+ jsws=3.77e-13             jswgs=3.00e-12            njs=1
+ ijthsfwd=0.01             ijthsrev=0.01             bvs=10
+ xjbvs=1                   pbs=0.8                   cjs=cjp
+ mjs=0.36                  pbsws=0.8                 cjsws=cjswp
+ mjsws=0.01                pbswgs=1                  cjswgs=cjswgp
+ mjswgs=0.98               tpb=1.9e-03               tcj=8.54e-04
+ tpbsw=1.9e-03             tcjsw=3.57e-04            tpbswg=1.9e-03
+ tcjswg=3.12e-03           xtis=3                    dmcg=9.25e-008
+ dmci=9.25e-008            dmdg=0                    dmcgt=0
+ dwj=0                     xgw=0                     xgl=0
+ rshg=0.1                  gbmin=1e-012              rbpb=50
+ rbpd=50                   rbps=50                   rbdb=50
+ rbsb=50                   ngcon=1                   saref=0.63e-6
+ sbref=0.63e-6             kvsat=-0.9                wlod=0.8e-6
+ tku0=0.1                  ku0=1.3249e-7             llodku0=1
+ wlodku0=1                 lku0=1.33e-7              wku0=6.5e-7
+ pku0=0                    kvth0=-1.5e-9             stk2=4e-10
+ steta0=0                  lkvth0=-1.68e-15          wkvth0=0.5e-6
+ pkvth0=0                  llodvth=2                 wlodvth=1
+ lodk2=2                   lodeta0=1                 fnoimod=1
+ noia=1.635e+42            noib=7.241e+26            noic=8.75
+ em=1.50e+08               ef=1.19                   wpemod=wpeflag
+ kvth0we=-0.0028           lkvth0we=0                wkvth0we=0
+ pkvth0we=0                ku0we=-0.0045             lku0we=3.00e-10
+ wku0we=0                  pku0we=0                  k2we=0.00045
+ wk2we=0                   web=-180                  wec=-3000
+ scref=1.00e-06            ud=0                      tnoimod=0
+ minr=1e-3

     24: type=p
+ lmin=2.4000e-07-dxlp      lmax=5.0000e-07-dxlp      wmin=1.200e-07
+ wmax=2.4000e-07-dxwp      version=4.5               binunit=2
+ paramchk=1                mobmod=0                  capmod=2
+ igcmod=1                  igbmod=1                  diomod=1
+ rdsmod=0                  rbodymod=0                rgatemod=0
+ permod=1                  acnqsmod=0                trnqsmod=0
+ tnom=25                   toxe=toxp                 toxm=toxp
+ dtox=5.25e-010            epsrox=3.9                wint=5e-009
+ lint=2.5e-009             ll=0                      wl=0
+ lln=1                     wln=1                     lw=0
+ ww=0                      lwn=1                     wwn=1
+ lwl=0                     wwl=0                     llc=0
+ wlc=0                     lwc=0                     wwc=0
+ lwlc=0                    wwlc=0                    dlc=1.525e-008
+ dwc=0                     xpart=1                   toxref=3e-009
+ dlcig=2.5e-009            xl=-3.5e-08+dxlp          xw=1.5e-8+dxwp
+ vth0=-0.19088526+dvthp    lvth0=2.7378846e-009+dlvthp
+ wvth0=1.2760417e-009+dwvthp                         pvth0=3.521875e-016+dpvthp
+ k1=0.1623                 k2=0.037247756+dk2p       lk2=-2.4621795e-010
+ wk2=-1.2819311e-009       pk2=-9.0304487e-018       k3=-0.58
+ k3b=0.8                   w0=0                      dvt0=10
+ dvt1=1.71                 dvt2=0.0928               dvt0w=0
+ dvt1w=0                   dvt2w=0                   dsub=0.5
+ minv=0                    voffl=0                   dvtp0=0
+ dvtp1=0                   lpe0=2.805e-007           lpeb=1e-007
+ xj=1.7000001e-007         ngate=8e019               ndep=1.7200001e017
+ nsd=1e020                 phin=0                    cdsc=0
+ cdscb=0                   cdscd=0                   lcdscd=0+dlcdscdp
+ cit=0.001                 voff=-0.12555929          lvoff=-1.9948077e-009+dlvoffp
+ wvoff=2.8602965e-009      pvoff=8.1274038e-017      nfactor=-1.0400641
+ lnfactor=4.6884615e-007   wnfactor=2.4539263e-007   pnfactor=-5.4182692e-014
+ eta0=0.10391026           leta0=-8.6987179e-009     weta0=1.963141e-009
+ peta0=-9.0304487e-016     etab=-0.02                u0=0.0089923077
+ lu0=-2.4045321e-010       wu0=5.0884615e-011        pu0=-3.3502965e-017
+ ua=-7.7131731e-010        lua=5.2758462e-017        wua=2.1402163e-017
+ pua=-1.0619808e-023       ub=2.9559231e-018         lub=-1.2661795e-025
+ wub=-1.0648077e-025       pub=1.0475321e-032        uc=1.9112933e-010
+ luc=-2.5189865e-017       wuc=-1.4073954e-017       puc=2.8147909e-024
+ vsat=120000               a0=3.62                   ags=-0.19915385
+ lags=1.4610308e-006       a1=0                      a2=1
+ b0=0                      b1=0                      keta=-0.18860096
+ lketa=3.6401923e-009      wketa=1.1784736e-008      pketa=-2.3569471e-015
+ dwg=0                     dwb=0                     pclm=1.3769231
+ lpclm=-1.7338462e-007     pdiblc1=0                 pdiblc2=0.005
+ pdiblcb=0                 drout=0                   pvag=0
+ delta=0.02                pscbe1=9.264e008          pscbe2=1e-020
+ fprout=1000               pdits=0                   pditsd=0
+ pditsl=0                  rsh=9.68                  rdsw=210+drdswp
+ prwg=0                    prwb=0                    wr=1
+ alpha0=0                  alpha1=0.06               beta0=12
+ agidl=9e-008              bgidl=2.3e009             cgidl=0.5
+ egidl=0.53                aigbacc=0.01069           bigbacc=0.003132
+ cigbacc=0.1498            nigbacc=4.049             aigbinv=0.35
+ bigbinv=0.03              cigbinv=0.006             eigbinv=1.1
+ nigbinv=1                 aigc=0.00606              bigc=0.0007625
+ cigc=1e-010               aigsd=0.00479             waigsd=1.225e-011
+ bigsd=0                   cigsd=0.002267            nigc=1
+ poxedge=1                 pigcd=2.3                 ntox=ntoxp
+ xrcrg1=12                 xrcrg2=1                  cgso=cgop
+ cgdo=cgop                 cgbo=0                    cgdl=cglp
+ cgsl=cglp                 clc=1e-007                cle=0.6
+ cf=cfp                    ckappas=0.6               acde=1.2
+ moin=11.09                noff=2.175                voffcv=-0.03885
+ kt1=-0.29225385           lkt1=5.1307692e-009       kt1l=0
+ kt2=-0.022526154          lkt2=-3.2447692e-009      ute=-2.162375
+ lute=2.09875e-007         wute=6.6373798e-008       pute=-1.327476e-014
+ ua1=4.2153846e-011        lua1=3.7896923e-016       wua1=1.6254808e-016
+ pua1=-3.2509615e-023      ub1=-3.964109e-018        lub1=4.7621795e-026
+ wub1=3.8830929e-026       pub1=-7.7661859e-033      uc1=-6.421e-011
+ prt=0                     at=345088.14              lat=-0.027937628
+ wat=-0.0038379407         pat=7.6758814e-010        jss=1.245e-07
+ jsws=3.77e-13             jswgs=3.00e-12            njs=1
+ ijthsfwd=0.01             ijthsrev=0.01             bvs=10
+ xjbvs=1                   pbs=0.8                   cjs=cjp
+ mjs=0.36                  pbsws=0.8                 cjsws=cjswp
+ mjsws=0.01                pbswgs=1                  cjswgs=cjswgp
+ mjswgs=0.98               tpb=1.9e-03               tcj=8.54e-04
+ tpbsw=1.9e-03             tcjsw=3.57e-04            tpbswg=1.9e-03
+ tcjswg=3.12e-03           xtis=3                    dmcg=9.25e-008
+ dmci=9.25e-008            dmdg=0                    dmcgt=0
+ dwj=0                     xgw=0                     xgl=0
+ rshg=0.1                  gbmin=1e-012              rbpb=50
+ rbpd=50                   rbps=50                   rbdb=50
+ rbsb=50                   ngcon=1                   saref=0.63e-6
+ sbref=0.63e-6             kvsat=-0.9                wlod=0.8e-6
+ tku0=0.1                  ku0=1.3249e-7             llodku0=1
+ wlodku0=1                 lku0=1.33e-7              wku0=6.5e-7
+ pku0=0                    kvth0=-1.5e-9             stk2=4e-10
+ steta0=0                  lkvth0=-1.68e-15          wkvth0=0.5e-6
+ pkvth0=0                  llodvth=2                 wlodvth=1
+ lodk2=2                   lodeta0=1                 fnoimod=1
+ noia=1.635e+42            noib=7.241e+26            noic=8.75
+ em=1.50e+08               ef=1.19                   wpemod=wpeflag
+ kvth0we=-0.0028           lkvth0we=0                wkvth0we=0
+ pkvth0we=0                ku0we=-0.0045             lku0we=3.00e-10
+ wku0we=0                  pku0we=0                  k2we=0.00045
+ wk2we=0                   web=-180                  wec=-3000
+ scref=1.00e-06            ud=0                      tnoimod=0
+ minr=1e-3

     25: type=p
+ lmin=1.000e-07            lmax=2.4000e-07-dxlp      wmin=1.200e-07
+ wmax=2.4000e-07-dxwp      version=4.5               binunit=2
+ paramchk=1                mobmod=0                  capmod=2
+ igcmod=1                  igbmod=1                  diomod=1
+ rdsmod=0                  rbodymod=0                rgatemod=0
+ permod=1                  acnqsmod=0                trnqsmod=0
+ tnom=25                   toxe=toxp                 toxm=toxp
+ dtox=5.25e-010            epsrox=3.9                wint=5e-009
+ lint=2.5e-009             ll=0                      wl=0
+ lln=1                     wln=1                     lw=0
+ ww=0                      lwn=1                     wwn=1
+ lwl=0                     wwl=0                     llc=0
+ wlc=0                     lwc=0                     wwc=0
+ lwlc=0                    wwlc=0                    dlc=1.525e-008
+ dwc=0                     xpart=1                   toxref=3e-009
+ dlcig=2.5e-009            xl=-3.5e-08+dxlp          xw=1.5e-8+dxwp
+ vth0=-0.17583512+dvthp    lvth0=-2.7214286e-010+dlvthp
+ wvth0=1.2651042e-009+dwvthp                         pvth0=3.54375e-016+dpvthp
+ k1=0.1623                 k2=0.035097024+dk2p       lk2=1.8392857e-010
+ wk2=-1.4692708e-009       pk2=2.84375e-017          k3=-0.58
+ k3b=0.8                   w0=0                      dvt0=10
+ dvt1=1.71                 dvt2=0.0928               dvt0w=0
+ dvt1w=0                   dvt2w=0                   dsub=0.5
+ minv=0                    voffl=0                   dvtp0=0
+ dvtp1=0                   lpe0=2.805e-007           lpeb=1e-007
+ xj=1.7000001e-007         ngate=8e019               ndep=1.7200001e017
+ nsd=1e020                 phin=0                    cdsc=0
+ cdscb=0                   cdscd=0                   lcdscd=0+dlcdscdp
+ cit=-0.00073214286        lcit=3.4642857e-010       wcit=1.09375e-010
+ pcit=-2.1875e-017         voff=-0.11060476          lvoff=-4.9857143e-009+dlvoffp
+ wvoff=2.0416667e-010      pvoff=6.125e-016          nfactor=1.9166667
+ lnfactor=-1.225e-007      wnfactor=-1.0208333e-007  pnfactor=1.53125e-014
+ eta0=0.060595238          leta0=-3.5714286e-011     weta0=-3.6458333e-009
+ peta0=2.1875e-016         etab=-0.0089071429        letab=-2.2185714e-009
+ wetab=-1.58375e-009       petab=3.1675e-016         u0=0.0087872024
+ lu0=-1.9943214e-010       wu0=-1.3161458e-010       pu0=2.996875e-018
+ ua=-3.2947679e-010        lua=-3.5609643e-017       wua=-4.5204687e-017
+ pua=2.7015625e-024        ub=2.3671369e-018         lub=-8.8607143e-027
+ wub=-7.6088542e-026       pub=4.396875e-033         uc=5.3878571e-011
+ luc=2.2602857e-018        vsat=120000               a0=3.62
+ ags=6.0442857             lags=2.1234286e-007       wags=-1.09375e-006
+ pags=2.1875e-013          a1=0                      a2=1
+ b0=0                      b1=0                      keta=-0.27108929
+ lketa=2.0137857e-008      wketa=6.671875e-009       pketa=-1.334375e-015
+ dwg=0                     dwb=0                     pclm=0.64285714
+ lpclm=-2.6571429e-008     pdiblc1=0                 pdiblc2=0.005
+ pdiblcb=0                 drout=0                   pvag=0
+ delta=0.02                pscbe1=9.264e008          pscbe2=1e-020
+ fprout=1000               pdits=0                   pditsd=0
+ pditsl=0                  rsh=9.68                  rdsw=210+drdswp
+ prwg=0                    prwb=0                    wr=1
+ alpha0=0                  alpha1=0.06               beta0=12
+ agidl=9e-008              bgidl=2.3e009             cgidl=0.5
+ egidl=0.53                aigbacc=0.01069           bigbacc=0.003132
+ cigbacc=0.1498            nigbacc=4.049             aigbinv=0.35
+ bigbinv=0.03              cigbinv=0.006             eigbinv=1.1
+ nigbinv=1                 aigc=0.00606              bigc=0.0007625
+ cigc=1e-010               aigsd=0.00479             waigsd=1.225e-011
+ bigsd=0                   cigsd=0.002267            nigc=1
+ poxedge=1                 pigcd=2.3                 ntox=ntoxp
+ xrcrg1=12                 xrcrg2=1                  cgso=cgop
+ cgdo=cgop                 cgbo=0                    cgdl=cglp
+ cgsl=cglp                 clc=1e-007                cle=0.6
+ cf=cfp                    ckappas=0.6               acde=1.2
+ moin=11.09                noff=2.175                voffcv=-0.03885
+ kt1=-0.26304286           lkt1=-7.1142857e-010      kt1l=0
+ kt2=-0.03875              ute=-0.98558036           lute=-2.5483929e-008
+ wute=-2.7332812e-008      pute=5.4665625e-015       ua1=2.0481607e-009
+ lua1=-2.2232143e-017      wua1=-4.0359375e-017      pua1=8.071875e-024
+ ub1=-3.6998571e-018       lub1=-5.2285714e-027      uc1=-6.421e-011
+ prt=0                     at=270800.18              lat=-0.013080036
+ wat=-1.09375e-006         pat=2.1875e-013           jss=1.245e-07
+ jsws=3.77e-13             jswgs=3.00e-12            njs=1
+ ijthsfwd=0.01             ijthsrev=0.01             bvs=10
+ xjbvs=1                   pbs=0.8                   cjs=cjp
+ mjs=0.36                  pbsws=0.8                 cjsws=cjswp
+ mjsws=0.01                pbswgs=1                  cjswgs=cjswgp
+ mjswgs=0.98               tpb=1.9e-03               tcj=8.54e-04
+ tpbsw=1.9e-03             tcjsw=3.57e-04            tpbswg=1.9e-03
+ tcjswg=3.12e-03           xtis=3                    dmcg=9.25e-008
+ dmci=9.25e-008            dmdg=0                    dmcgt=0
+ dwj=0                     xgw=0                     xgl=0
+ rshg=0.1                  gbmin=1e-012              rbpb=50
+ rbpd=50                   rbps=50                   rbdb=50
+ rbsb=50                   ngcon=1                   saref=0.63e-6
+ sbref=0.63e-6             kvsat=-0.9                wlod=0.8e-6
+ tku0=0.1                  ku0=1.3249e-7             llodku0=1
+ wlodku0=1                 lku0=1.33e-7              wku0=6.5e-7
+ pku0=0                    kvth0=-1.5e-9             stk2=4e-10
+ steta0=0                  lkvth0=-1.68e-15          wkvth0=0.5e-6
+ pkvth0=0                  llodvth=2                 wlodvth=1
+ lodk2=2                   lodeta0=1                 fnoimod=1
+ noia=1.635e+42            noib=7.241e+26            noic=8.75
+ em=1.50e+08               ef=1.19                   wpemod=wpeflag
+ kvth0we=-0.0028           lkvth0we=0                wkvth0we=0
+ pkvth0we=0                ku0we=-0.0045             lku0we=3.00e-10
+ wku0we=0                  pku0we=0                  k2we=0.00045
+ wk2we=0                   web=-180                  wec=-3000
+ scref=1.00e-06            ud=0                      tnoimod=0
+ minr=1e-3

     }
endsection mos

//  *****************************************************************************************
//
//             *
//                                 1.0V HIGH VT DEVICE MODELS
//             *
//
//             *
//  *****************************************************************************************
//

section mos_hvt
//
//  *****************************************************************************************
//
//             *
//                               1.0V HIGH VT NMOS DEVICE MODELS
//             *
//
//             *
//  *****************************************************************************************

model nch_hvt bsim4  {
     1: type=n
+ lmin=1.0000e-05-dxln_hvt  lmax=2.001e-05            wmin=1.0000e-05-dxwn_hvt
+ wmax=9.001e-04            version=4.5               binunit=2
+ paramchk=1                mobmod=0                  capmod=2
+ igcmod=1                  igbmod=1                  geomod=0
+ diomod=1                  rdsmod=0                  rbodymod=0
+ rgatemod=0                permod=1                  acnqsmod=0
+ trnqsmod=0                tnom=25                   toxe=toxn_hvt
+ toxm=toxn_hvt             dtox=3.03e-010            epsrox=3.9
+ wint=6e-009               lint=2.5e-009             ll=0
+ wl=0                      lln=1                     wln=1
+ lw=0                      ww=0                      lwn=1
+ wwn=1                     lwl=0                     wwl=0
+ llc=0                     wlc=0                     lwc=0
+ wwc=0                     lwlc=0                    wwlc=0
+ dlc=1.124e-008            dwc=0                     xpart=1
+ toxref=3e-009             dlcig=2.5e-009            xl=-3.5e-08+dxln_hvt
+ xw=1.5e-8+dxwn_hvt        vth0=0.354+dvthn_hvt      wvth0=0+dwvthn_hvt
+ lvth0=0+dlvthn_hvt        pvth0=0+dpvthn_hvt        k1=0.33
+ k2=0.032+dk2n_hvt         k3=-2.45                  k3b=1.2
+ w0=-5.5e-008              dvt0=18.2                 dvt1=1.35
+ dvt2=0.12                 dvt0w=0                   dvt1w=0
+ dvt2w=0                   dsub=0.5                  minv=0
+ voffl=0                   dvtp0=7e-007              dvtp1=0
+ lpe0=1.5e-008             lpeb=0                    xj=1.5e-007
+ ngate=4e020               ndep=8.3687e017           nsd=1e020
+ phin=0                    cdsc=0                    cdscb=0
+ cdscd=0                   lcdscd=0+dlcdscdn_hvt     cit=0
+ voff=-0.13                lvoff=0+dlvoffn_hvt       lcit=0+dlcitn_hvt
+ pvoff=0+dpvoffn_hvt       nfactor=0.6569            eta0=0.13+deta0n_hvt
+ etab=-0.08                u0=0.0373                 ua=-4.28e-010
+ ub=1.414e-018             uc=1.435e-010             vsat=106750.56
+ lvsat=-1.117198e-005      wvsat=-0.00050374826      pvsat=1.0054815e-008+dpvsatn_hvt
+ a0=2.33                   ags=0.8506                a1=0
+ a2=1                      b0=0                      b1=0
+ keta=-0.0164              dwg=0                     dwb=0
+ pclm=1.01                 pdiblc1=0.1691            pdiblc2=0.0001103
+ pdiblcb=-0.1              drout=0.5                 pvag=1.252
+ delta=0.0075              pscbe1=9.264e008          pscbe2=1e-020
+ fprout=0                  pdits=0                   pditsd=0
+ pditsl=0                  rsh=10.5                  rdsw=150
+ prwg=0                    prwb=0                    wr=1
+ alpha0=0                  alpha1=0.03               beta0=8.7
+ agidl=2.593e-009          bgidl=1.698e009           cgidl=0.25
+ egidl=0.2624              aigbacc=0.01238           bigbacc=0.006109
+ cigbacc=0.2809            nigbacc=4.05              aigbinv=0.35
+ bigbinv=0.03              cigbinv=0.006             eigbinv=1.1
+ nigbinv=1                 aigc=0.009898             bigc=0.001383
+ cigc=1.515e-005           aigsd=0.0086              bigsd=0.0004353
+ cigsd=3.925e-020          nigc=1                    poxedge=1
+ pigcd=1.672               ntox=ntoxn_hvt            xrcrg1=12
+ xrcrg2=1                  cgso=cgon_hvt             cgdo=cgon_hvt
+ cgbo=0                    cgdl=cgln_hvt             cgsl=cgln_hvt
+ clc=1e-007                cle=0.6                   cf=cfn_hvt
+ ckappas=0.6               acde=1.2                  moin=12.6
+ noff=1.686                voffcv=-0.05472           kt1=-0.1987
+ kt1l=0                    kt2=-0.0522               ute=-0.75
+ ua1=3.72e-009             ub1=-2.49e-018            uc1=2.4e-010
+ prt=0                     at=90000                  jss=2.00e-07
+ jsws=6.71e-13             jswgs=5.40e-11            njs=1
+ ijthsfwd=0.01             ijthsrev=0.01             bvs=10
+ xjbvs=1                   pbs=0.496                 cjs=cjn_hvt
+ mjs=0.336                 pbsws=0.8                 cjsws=cjswn_hvt
+ mjsws=0.01                pbswgs=1.0004             cjswgs=cjswgn_hvt
+ mjswgs=0.5561             tpb=1.00e-03              tcj=8.34e-04
+ tpbsw=1.00e-03            tcjsw=3.57e-04            tpbswg=1.50e-03
+ tcjswg=7.67e-04           xtis=3                    dmcg=9.25e-008
+ dmci=9.25e-008            dmdg=0                    dmcgt=0
+ dwj=0                     xgw=0                     xgl=0
+ rshg=0.1                  gbmin=1e-012              rbpb=50
+ rbpd=50                   rbps=50                   rbdb=50
+ rbsb=50                   ngcon=1                   saref=0.63e-6
+ sbref=0.63e-6             kvsat=0.1                 wlod=0.8e-6
+ tku0=0.01                 ku0=-7.01e-8              llodku0=1
+ wlodku0=1                 lku0=4.027e-7             wku0=8e-7
+ pku0=-2.0e-13             kvth0=3.5e-9              stk2=1.65e-9
+ steta0=0                  lkvth0=-2.68e-11          wkvth0=1.5e-6
+ pkvth0=0                  llodvth=1                 wlodvth=1
+ lodk2=0.5                 lodeta0=1                 fnoimod=1
+ noia=3.75e+41             noib=6.25e+24             noic=8.75
+ em=1.00e+08               ef=0.9                    wpemod=wpeflag_hvt
+ kvth0we=0.00323           lkvth0we=0                wkvth0we=0
+ pkvth0we=0                ku0we=-0.0015             lku0we=6.00e-10
+ wku0we=0                  pku0we=0                  k2we=0.0015
+ wk2we=0                   web=-210                  wec=-3500
+ scref=1.00e-06            ud=0                      tnoimod=0
+ minr=1e-3

     2: type=n
+ lmin=1.2000e-06-dxln_hvt  lmax=1.0000e-05-dxln_hvt  wmin=1.0000e-05-dxwn_hvt
+ wmax=9.001e-04            version=4.5               binunit=2
+ paramchk=1                mobmod=0                  capmod=2
+ igcmod=1                  igbmod=1                  geomod=0
+ diomod=1                  rdsmod=0                  rbodymod=0
+ rgatemod=0                permod=1                  acnqsmod=0
+ trnqsmod=0                tnom=25                   toxe=toxn_hvt
+ toxm=toxn_hvt             dtox=3.03e-010            epsrox=3.9
+ wint=6e-009               lint=2.5e-009             ll=0
+ wl=0                      lln=1                     wln=1
+ lw=0                      ww=0                      lwn=1
+ wwn=1                     lwl=0                     wwl=0
+ llc=0                     wlc=0                     lwc=0
+ wwc=0                     lwlc=0                    wwlc=0
+ dlc=1.124e-008            dwc=0                     xpart=1
+ toxref=3e-009             dlcig=2.5e-009            xl=-3.5e-08+dxln_hvt
+ xw=1.5e-8+dxwn_hvt        vth0=0.35347273+dvthn_hvt wvth0=0+dwvthn_hvt
+ lvth0=5.2516364e-009+dlvthn_hvt                     pvth0=0+dpvthn_hvt
+ k1=0.33                   k2=0.031971+dk2n_hvt      lk2=2.8884e-010
+ k3=-2.45                  k3b=1.2                   w0=-5.5e-008
+ dvt0=18.2                 dvt1=1.35                 dvt2=0.12
+ dvt0w=0                   dvt1w=0                   dvt2w=0
+ dsub=0.5                  minv=0                    voffl=0
+ dvtp0=7e-007              dvtp1=0                   lpe0=1.5e-008
+ lpeb=0                    xj=1.5e-007               ngate=4e020
+ ndep=8.3687e017           nsd=1e020                 phin=0
+ cdsc=0                    cdscb=0                   cdscd=0
+ lcdscd=0+dlcdscdn_hvt     cit=-3.0318182e-005       lcit=3.0196909e-010+dlcitn_hvt
+ voff=-0.13052727          lvoff=5.2516364e-009+dlvoffn_hvt
+ pvoff=0+dpvoffn_hvt       nfactor=0.6569            eta0=0.13+deta0n_hvt
+ etab=-0.08                u0=0.037347455            lu0=-4.7264727e-010
+ ua=-4.28e-010             ub=1.414e-018             uc=1.4651864e-010
+ luc=-3.0065618e-017       vsat=106742.77            lvsat=6.6383265e-005
+ wvsat=0.00057244121       pvsat=-6.640318e-010+dpvsatn_hvt
+ a0=2.4060591              la0=-7.5754855e-007       ags=0.841465
+ lags=9.09846e-008         a1=0                      a2=1
+ b0=0                      b1=0                      keta=-0.016616182
+ lketa=2.1531709e-009      dwg=0                     dwb=0
+ pclm=1.01                 pdiblc1=0.1691            pdiblc2=6.8882727e-005
+ lpdiblc2=4.1251604e-010   pdiblcb=-0.1              drout=0.5
+ pvag=1.252                delta=0.0075              pscbe1=9.264e008
+ pscbe2=1e-020             fprout=0                  pdits=0
+ pditsd=0                  pditsl=0                  rsh=10.5
+ rdsw=150                  prwg=0                    prwb=0
+ wr=1                      alpha0=0                  alpha1=0.03
+ beta0=8.7                 agidl=2.593e-009          bgidl=1.698e009
+ cgidl=0.25                egidl=0.2624              aigbacc=0.01238
+ bigbacc=0.006109          cigbacc=0.2809            nigbacc=4.05
+ aigbinv=0.35              bigbinv=0.03              cigbinv=0.006
+ eigbinv=1.1               nigbinv=1                 aigc=0.009898
+ bigc=0.001383             cigc=1.515e-005           aigsd=0.0086
+ bigsd=0.0004353           cigsd=3.925e-020          nigc=1
+ poxedge=1                 pigcd=1.672               ntox=ntoxn_hvt
+ xrcrg1=12                 xrcrg2=1                  cgso=cgon_hvt
+ cgdo=cgon_hvt             cgbo=0                    cgdl=cgln_hvt
+ cgsl=cgln_hvt             clc=1e-007                cle=0.6
+ cf=cfn_hvt                ckappas=0.6               acde=1.2
+ moin=12.6                 noff=1.686                voffcv=-0.05472
+ kt1=-0.19457409           lkt1=-4.1094055e-008      kt1l=0
+ kt2=-0.052885455          lkt2=6.8271273e-009       ute=-0.74340909
+ lute=-6.5645455e-008      ua1=3.7476818e-009        lua1=-2.7571091e-016
+ ub1=-2.4847273e-018       lub1=-5.2516364e-026      uc1=2.5581818e-010
+ luc1=-1.5754909e-016      prt=0                     at=90000
+ jss=2.00e-07              jsws=6.71e-13             jswgs=5.40e-11
+ njs=1                     ijthsfwd=0.01             ijthsrev=0.01
+ bvs=10                    xjbvs=1                   pbs=0.496
+ cjs=cjn_hvt               mjs=0.336                 pbsws=0.8
+ cjsws=cjswn_hvt           mjsws=0.01                pbswgs=1.0004
+ cjswgs=cjswgn_hvt         mjswgs=0.5561             tpb=1.00e-03
+ tcj=8.34e-04              tpbsw=1.00e-03            tcjsw=3.57e-04
+ tpbswg=1.50e-03           tcjswg=7.67e-04           xtis=3
+ dmcg=9.25e-008            dmci=9.25e-008            dmdg=0
+ dmcgt=0                   dwj=0                     xgw=0
+ xgl=0                     rshg=0.1                  gbmin=1e-012
+ rbpb=50                   rbpd=50                   rbps=50
+ rbdb=50                   rbsb=50                   ngcon=1
+ saref=0.63e-6             sbref=0.63e-6             kvsat=0.1
+ wlod=0.8e-6               tku0=0.01                 ku0=-7.01e-8
+ llodku0=1                 wlodku0=1                 lku0=4.027e-7
+ wku0=8e-7                 pku0=-2.0e-13             kvth0=3.5e-9
+ stk2=1.65e-9              steta0=0                  lkvth0=-2.68e-11
+ wkvth0=1.5e-6             pkvth0=0                  llodvth=1
+ wlodvth=1                 lodk2=0.5                 lodeta0=1
+ fnoimod=1                 noia=3.75e+41             noib=6.25e+24
+ noic=8.75                 em=1.00e+08               ef=0.9
+ wpemod=wpeflag_hvt        kvth0we=0.00323           lkvth0we=0
+ wkvth0we=0                pkvth0we=0                ku0we=-0.0015
+ lku0we=6.00e-10           wku0we=0                  pku0we=0
+ k2we=0.0015               wk2we=0                   web=-210
+ wec=-3500                 scref=1.00e-06            ud=0
+ tnoimod=0                 minr=1e-3

     3: type=n
+ lmin=5.0000e-07-dxln_hvt  lmax=1.2000e-06-dxln_hvt  wmin=1.0000e-05-dxwn_hvt
+ wmax=9.001e-04            version=4.5               binunit=2
+ paramchk=1                mobmod=0                  capmod=2
+ igcmod=1                  igbmod=1                  geomod=0
+ diomod=1                  rdsmod=0                  rbodymod=0
+ rgatemod=0                permod=1                  acnqsmod=0
+ trnqsmod=0                tnom=25                   toxe=toxn_hvt
+ toxm=toxn_hvt             dtox=3.03e-010            epsrox=3.9
+ wint=6e-009               lint=2.5e-009             ll=0
+ wl=0                      lln=1                     wln=1
+ lw=0                      ww=0                      lwn=1
+ wwn=1                     lwl=0                     wwl=0
+ llc=0                     wlc=0                     lwc=0
+ wwc=0                     lwlc=0                    wwlc=0
+ dlc=1.124e-008            dwc=0                     xpart=1
+ toxref=3e-009             dlcig=2.5e-009            xl=-3.5e-08+dxln_hvt
+ xw=1.5e-8+dxwn_hvt        vth0=0.358+dvthn_hvt      wvth0=0+dwvthn_hvt
+ lvth0=0+dlvthn_hvt        pvth0=0+dpvthn_hvt        k1=0.33
+ k2=0.034546286+dk2n_hvt   lk2=-2.6984914e-009       k3=-2.45
+ k3b=1.2                   w0=-5.5e-008              dvt0=18.2
+ dvt1=1.35                 dvt2=0.12                 dvt0w=0
+ dvt1w=0                   dvt2w=0                   dsub=0.5
+ minv=0                    voffl=0                   dvtp0=7e-007
+ dvtp1=0                   lpe0=1.5e-008             lpeb=0
+ xj=1.5e-007               ngate=4e020               ndep=8.3687e017
+ nsd=1e020                 phin=0                    cdsc=0
+ cdscb=0                   cdscd=0                   lcdscd=0+dlcdscdn_hvt
+ cit=-0.00014457143        lcit=4.3450286e-010+dlcitn_hvt
+ voff=-0.12757714          lvoff=1.8294857e-009+dlvoffn_hvt
+ pvoff=0+dpvoffn_hvt       nfactor=0.6569            eta0=0.13+deta0n_hvt
+ etab=-0.08                u0=0.036230286            lu0=8.2326857e-010
+ ua=-4.2931429e-010        lua=1.5245714e-018        ub=1.4153143e-018
+ lub=-1.5245714e-027       uc=1.206e-010             vsat=106800
+ a0=1.7983429              pvsat=0+dpvsatn_hvt       la0=-5.2597714e-008
+ ags=0.93751143            lags=-2.0429257e-008      a1=0
+ a2=1                      b0=0                      b1=0
+ keta=-0.013833429         lketa=-1.0748229e-009     dwg=0
+ dwb=0                     pclm=1.01                 pdiblc1=0.1691
+ pdiblc2=0.00037718571     lpdiblc2=5.4884571e-011   pdiblcb=-0.1
+ drout=0.5                 pvag=1.252                delta=0.0075
+ pscbe1=9.264e008          pscbe2=1e-020             fprout=0
+ pdits=0                   pditsd=0                  pditsl=0
+ rsh=10.5                  rdsw=150                  prwg=0
+ prwb=0                    wr=1                      alpha0=0
+ alpha1=0.03               beta0=8.7                 agidl=2.593e-009
+ bgidl=1.698e009           cgidl=0.25                egidl=0.2624
+ aigbacc=0.01238           bigbacc=0.006109          cigbacc=0.2809
+ nigbacc=4.05              aigbinv=0.35              bigbinv=0.03
+ cigbinv=0.006             eigbinv=1.1               nigbinv=1
+ aigc=0.009898             bigc=0.001383             cigc=1.515e-005
+ aigsd=0.0086              bigsd=0.0004353           cigsd=3.925e-020
+ nigc=1                    poxedge=1                 pigcd=1.672
+ ntox=ntoxn_hvt            xrcrg1=12                 xrcrg2=1
+ cgso=cgon_hvt             cgdo=cgon_hvt             cgbo=0
+ cgdl=cgln_hvt             cgsl=cgln_hvt             clc=1e-007
+ cle=0.6                   cf=cfn_hvt                ckappas=0.6
+ acde=1.2                  moin=12.6                 noff=1.686
+ voffcv=-0.05472           kt1=-0.21968286           lkt1=-1.1967886e-008
+ kt1l=0                    kt2=-0.048550857          lkt2=1.7989943e-009
+ ute=-0.8                  ua1=3.5717714e-009        lua1=-7.1654857e-017
+ ub1=-2.5162e-018          lub1=-1.6008e-026         uc1=1.5153629e-010
+ luc1=-3.6582091e-017      prt=0                     at=90000
+ jss=2.00e-07              jsws=6.71e-13             jswgs=5.40e-11
+ njs=1                     ijthsfwd=0.01             ijthsrev=0.01
+ bvs=10                    xjbvs=1                   pbs=0.496
+ cjs=cjn_hvt               mjs=0.336                 pbsws=0.8
+ cjsws=cjswn_hvt           mjsws=0.01                pbswgs=1.0004
+ cjswgs=cjswgn_hvt         mjswgs=0.5561             tpb=1.00e-03
+ tcj=8.34e-04              tpbsw=1.00e-03            tcjsw=3.57e-04
+ tpbswg=1.50e-03           tcjswg=7.67e-04           xtis=3
+ dmcg=9.25e-008            dmci=9.25e-008            dmdg=0
+ dmcgt=0                   dwj=0                     xgw=0
+ xgl=0                     rshg=0.1                  gbmin=1e-012
+ rbpb=50                   rbpd=50                   rbps=50
+ rbdb=50                   rbsb=50                   ngcon=1
+ saref=0.63e-6             sbref=0.63e-6             kvsat=0.1
+ wlod=0.8e-6               tku0=0.01                 ku0=-7.01e-8
+ llodku0=1                 wlodku0=1                 lku0=4.027e-7
+ wku0=8e-7                 pku0=-2.0e-13             kvth0=3.5e-9
+ stk2=1.65e-9              steta0=0                  lkvth0=-2.68e-11
+ wkvth0=1.5e-6             pkvth0=0                  llodvth=1
+ wlodvth=1                 lodk2=0.5                 lodeta0=1
+ fnoimod=1                 noia=3.75e+41             noib=6.25e+24
+ noic=8.75                 em=1.00e+08               ef=0.9
+ wpemod=wpeflag_hvt        kvth0we=0.00323           lkvth0we=0
+ wkvth0we=0                pkvth0we=0                ku0we=-0.0015
+ lku0we=6.00e-10           wku0we=0                  pku0we=0
+ k2we=0.0015               wk2we=0                   web=-210
+ wec=-3500                 scref=1.00e-06            ud=0
+ tnoimod=0                 minr=1e-3

     4: type=n
+ lmin=2.4000e-07-dxln_hvt  lmax=5.0000e-07-dxln_hvt  wmin=1.0000e-05-dxwn_hvt
+ wmax=9.001e-04            version=4.5               binunit=2
+ paramchk=1                mobmod=0                  capmod=2
+ igcmod=1                  igbmod=1                  geomod=0
+ diomod=1                  rdsmod=0                  rbodymod=0
+ rgatemod=0                permod=1                  acnqsmod=0
+ trnqsmod=0                tnom=25                   toxe=toxn_hvt
+ toxm=toxn_hvt             dtox=3.03e-010            epsrox=3.9
+ wint=6e-009               lint=2.5e-009             ll=0
+ wl=0                      lln=1                     wln=1
+ lw=0                      ww=0                      lwn=1
+ wwn=1                     lwl=0                     wwl=0
+ llc=0                     wlc=0                     lwc=0
+ wwc=0                     lwlc=0                    wwlc=0
+ dlc=1.124e-008            dwc=0                     xpart=1
+ toxref=3e-009             dlcig=2.5e-009            xl=-3.5e-08+dxln_hvt
+ xw=1.5e-8+dxwn_hvt        vth0=0.36338462+dvthn_hvt wvth0=0+dwvthn_hvt
+ lvth0=-2.4769231e-009+dlvthn_hvt                    pvth0=0+dpvthn_hvt
+ k1=0.33                   k2=0.031895385+dk2n_hvt   lk2=-1.4790769e-009
+ k3=-2.45                  k3b=1.2                   w0=-5.5e-008
+ dvt0=18.2                 dvt1=1.35                 dvt2=0.12
+ dvt0w=0                   dvt1w=0                   dvt2w=0
+ dsub=0.5                  minv=0                    voffl=0
+ dvtp0=7e-007              dvtp1=0                   lpe0=1.5e-008
+ lpeb=0                    xj=1.5e-007               ngate=4e020
+ ndep=8.3687e017           nsd=1e020                 phin=0
+ cdsc=0                    cdscb=0                   cdscd=0
+ lcdscd=0+dlcdscdn_hvt     cit=0.00045384615         lcit=1.5923077e-010+dlcitn_hvt
+ voff=-0.11467692          lvoff=-4.1046154e-009+dlvoffn_hvt
+ pvoff=0+dpvoffn_hvt       nfactor=0.6569            eta0=0.13+deta0n_hvt
+ etab=-0.08                u0=0.037504615            lu0=2.3707692e-010
+ ua=-4.2907692e-010        lua=1.4153846e-018        ub=1.4181538e-018
+ lub=-2.8307692e-027       uc=1.0883077e-010         luc=5.4138462e-018
+ vsat=106838.89            lvsat=-1.7891157e-005     wvsat=-0.00038905488
+ pvsat=1.7896525e-010+dpvsatn_hvt                    a0=1.1870769
+ la0=2.2858462e-007        ags=0.92579231            lags=-1.5038462e-008
+ a1=0                      a2=1                      b0=0
+ b1=0                      keta=-0.029185385         lketa=5.9870769e-009
+ dwg=0                     dwb=0                     pclm=1.01
+ pdiblc1=0.1691            pdiblc2=0.00051411538     lpdiblc2=-8.1030769e-012
+ pdiblcb=-0.1              drout=0.5                 pvag=1.252
+ delta=0.0075              pscbe1=9.264e008          pscbe2=1e-020
+ fprout=0                  pdits=0                   pditsd=0
+ pditsl=0                  rsh=10.5                  rdsw=150
+ prwg=0                    prwb=0                    wr=1
+ alpha0=0                  alpha1=0.03               beta0=8.7
+ agidl=2.593e-009          bgidl=1.698e009           cgidl=0.25
+ egidl=0.2624              aigbacc=0.01238           bigbacc=0.006109
+ cigbacc=0.2809            nigbacc=4.05              aigbinv=0.35
+ bigbinv=0.03              cigbinv=0.006             eigbinv=1.1
+ nigbinv=1                 aigc=0.009898             bigc=0.001383
+ cigc=1.515e-005           aigsd=0.0086              bigsd=0.0004353
+ cigsd=3.925e-020          nigc=1                    poxedge=1
+ pigcd=1.672               ntox=ntoxn_hvt            xrcrg1=12
+ xrcrg2=1                  cgso=cgon_hvt             cgdo=cgon_hvt
+ cgbo=0                    cgdl=cgln_hvt             cgsl=cgln_hvt
+ clc=1e-007                cle=0.6                   cf=cfn_hvt
+ ckappas=0.6               acde=1.2                  moin=12.6
+ noff=1.686                voffcv=-0.05472           kt1=-0.22839231
+ lkt1=-7.9615385e-009      kt1l=0                    kt2=-0.049101538
+ lkt2=2.0523077e-009       ute=-0.8                  ua1=3.4167692e-009
+ lua1=-3.5384615e-019      ub1=-2.4194615e-018       lub1=-6.0507692e-026
+ uc1=9.4402308e-011        luc1=-1.0300462e-017      prt=0
+ at=115615.38              lat=-0.011783077          jss=2.00e-07
+ jsws=6.71e-13             jswgs=5.40e-11            njs=1
+ ijthsfwd=0.01             ijthsrev=0.01             bvs=10
+ xjbvs=1                   pbs=0.496                 cjs=cjn_hvt
+ mjs=0.336                 pbsws=0.8                 cjsws=cjswn_hvt
+ mjsws=0.01                pbswgs=1.0004             cjswgs=cjswgn_hvt
+ mjswgs=0.5561             tpb=1.00e-03              tcj=8.34e-04
+ tpbsw=1.00e-03            tcjsw=3.57e-04            tpbswg=1.50e-03
+ tcjswg=7.67e-04           xtis=3                    dmcg=9.25e-008
+ dmci=9.25e-008            dmdg=0                    dmcgt=0
+ dwj=0                     xgw=0                     xgl=0
+ rshg=0.1                  gbmin=1e-012              rbpb=50
+ rbpd=50                   rbps=50                   rbdb=50
+ rbsb=50                   ngcon=1                   saref=0.63e-6
+ sbref=0.63e-6             kvsat=0.1                 wlod=0.8e-6
+ tku0=0.01                 ku0=-7.01e-8              llodku0=1
+ wlodku0=1                 lku0=4.027e-7             wku0=8e-7
+ pku0=-2.0e-13             kvth0=3.5e-9              stk2=1.65e-9
+ steta0=0                  lkvth0=-2.68e-11          wkvth0=1.5e-6
+ pkvth0=0                  llodvth=1                 wlodvth=1
+ lodk2=0.5                 lodeta0=1                 fnoimod=1
+ noia=3.75e+41             noib=6.25e+24             noic=8.75
+ em=1.00e+08               ef=0.9                    wpemod=wpeflag_hvt
+ kvth0we=0.00323           lkvth0we=0                wkvth0we=0
+ pkvth0we=0                ku0we=-0.0015             lku0we=6.00e-10
+ wku0we=0                  pku0we=0                  k2we=0.0015
+ wk2we=0                   web=-210                  wec=-3500
+ scref=1.00e-06            ud=0                      tnoimod=0
+ minr=1e-3

     5: type=n
+ lmin=1.0e-07              lmax=2.4000e-07-dxln_hvt  wmin=1.0000e-05-dxwn_hvt
+ wmax=9.001e-04            version=4.5               binunit=2
+ paramchk=1                mobmod=0                  capmod=2
+ igcmod=1                  igbmod=1                  geomod=0
+ diomod=1                  rdsmod=0                  rbodymod=0
+ rgatemod=0                permod=1                  acnqsmod=0
+ trnqsmod=0                tnom=25                   toxe=toxn_hvt
+ toxm=toxn_hvt             dtox=3.03e-010            epsrox=3.9
+ wint=6e-009               lint=2.5e-009             ll=0
+ wl=0                      lln=1                     wln=1
+ lw=0                      ww=0                      lwn=1
+ wwn=1                     lwl=0                     wwl=0
+ llc=0                     wlc=0                     lwc=0
+ wwc=0                     lwlc=0                    wwlc=0
+ dlc=1.124e-008            dwc=0                     xpart=1
+ toxref=3e-009             dlcig=2.5e-009            xl=-3.5e-08+dxln_hvt
+ xw=1.5e-8+dxwn_hvt        vth0=0.351+dvthn_hvt      wvth0=0+dwvthn_hvt
+ lvth0=0+dlvthn_hvt        pvth0=0+dpvthn_hvt        k1=0.33
+ k2=0.032+dk2n_hvt         lk2=-1.5e-009             k3=-2.45
+ k3b=1.2                   w0=-5.5e-008              dvt0=18.2
+ dvt1=1.35                 dvt2=0.12                 dvt0w=0
+ dvt1w=0                   dvt2w=0                   dsub=0.5
+ minv=0                    voffl=0                   dvtp0=7e-007
+ dvtp1=0                   lpe0=1.5e-008             lpeb=0
+ xj=1.5e-007               ngate=4e020               ndep=8.3687e017
+ nsd=1e020                 phin=0                    cdsc=0
+ cdscb=0                   cdscd=0                   lcdscd=0+dlcdscdn_hvt
+ cit=-0.00015271429        lcit=2.8054286e-010+dlcitn_hvt
+ voff=-0.12311429          lvoff=-2.4171429e-009+dlvoffn_hvt
+ pvoff=0+dpvoffn_hvt       nfactor=0.6569            eta0=0.12391429+deta0n_hvt
+ leta0=1.2171429e-009      etab=-0.08                u0=0.040057143
+ lu0=-2.7342857e-010       ua=-4.2457143e-010        lua=5.1428571e-019
+ ub=1.4005714e-018         lub=6.8571429e-028        uc=1.4957143e-010
+ luc=-2.7342857e-018       vsat=106213.48            lvsat=0.00010719103
+ wvsat=0.0007225305        pvsat=-4.335183e-011+dpvsatn_hvt
+ a0=2.8785714              la0=-1.0971429e-007       ags=0.8506
+ a1=0                      a2=1                      b0=0
+ b1=0                      keta=-0.016907143         lketa=3.5314286e-009
+ dwg=0                     dwb=0                     pclm=1.01
+ pdiblc1=0.1691            pdiblc2=0.00058202857     lpdiblc2=-2.1685714e-011
+ pdiblcb=-0.1              drout=0.5                 pvag=1.252
+ delta=0.0075              pscbe1=9.264e008          pscbe2=1e-020
+ fprout=0                  pdits=0                   pditsd=0
+ pditsl=0                  rsh=10.5                  rdsw=150
+ prwg=0                    prwb=0                    wr=1
+ alpha0=0                  alpha1=0.03               beta0=8.7
+ agidl=2.593e-009          bgidl=1.698e009           cgidl=0.25
+ egidl=0.2624              aigbacc=0.01238           bigbacc=0.006109
+ cigbacc=0.2809            nigbacc=4.05              aigbinv=0.35
+ bigbinv=0.03              cigbinv=0.006             eigbinv=1.1
+ nigbinv=1                 aigc=0.009898             bigc=0.001383
+ cigc=1.515e-005           aigsd=0.0086              bigsd=0.0004353
+ cigsd=3.925e-020          nigc=1                    poxedge=1
+ pigcd=1.672               ntox=ntoxn_hvt            xrcrg1=12
+ xrcrg2=1                  cgso=cgon_hvt             cgdo=cgon_hvt
+ cgbo=0                    cgdl=cgln_hvt             cgsl=cgln_hvt
+ clc=1e-007                cle=0.6                   cf=cfn_hvt
+ ckappas=0.6               acde=1.2                  moin=12.6
+ noff=1.686                voffcv=-0.05472           kt1=-0.25517143
+ lkt1=-2.6057143e-009      kt1l=0                    kt2=-0.041917143
+ lkt2=6.1542857e-010       ute=-0.8                  ua1=4.0968571e-009
+ lua1=-1.3637143e-016      ub1=-3.6643857e-018       lub1=1.8847714e-025
+ uc1=-3.0171429e-011       luc1=1.4614286e-017       prt=0
+ at=57085.714              lat=-7.7142857e-005       jss=2.00e-07
+ jsws=6.71e-13             jswgs=5.40e-11            njs=1
+ ijthsfwd=0.01             ijthsrev=0.01             bvs=10
+ xjbvs=1                   pbs=0.496                 cjs=cjn_hvt
+ mjs=0.336                 pbsws=0.8                 cjsws=cjswn_hvt
+ mjsws=0.01                pbswgs=1.0004             cjswgs=cjswgn_hvt
+ mjswgs=0.5561             tpb=1.00e-03              tcj=8.34e-04
+ tpbsw=1.00e-03            tcjsw=3.57e-04            tpbswg=1.50e-03
+ tcjswg=7.67e-04           xtis=3                    dmcg=9.25e-008
+ dmci=9.25e-008            dmdg=0                    dmcgt=0
+ dwj=0                     xgw=0                     xgl=0
+ rshg=0.1                  gbmin=1e-012              rbpb=50
+ rbpd=50                   rbps=50                   rbdb=50
+ rbsb=50                   ngcon=1                   saref=0.63e-6
+ sbref=0.63e-6             kvsat=0.1                 wlod=0.8e-6
+ tku0=0.01                 ku0=-7.01e-8              llodku0=1
+ wlodku0=1                 lku0=4.027e-7             wku0=8e-7
+ pku0=-2.0e-13             kvth0=3.5e-9              stk2=1.65e-9
+ steta0=0                  lkvth0=-2.68e-11          wkvth0=1.5e-6
+ pkvth0=0                  llodvth=1                 wlodvth=1
+ lodk2=0.5                 lodeta0=1                 fnoimod=1
+ noia=3.75e+41             noib=6.25e+24             noic=8.75
+ em=1.00e+08               ef=0.9                    wpemod=wpeflag_hvt
+ kvth0we=0.00323           lkvth0we=0                wkvth0we=0
+ pkvth0we=0                ku0we=-0.0015             lku0we=6.00e-10
+ wku0we=0                  pku0we=0                  k2we=0.0015
+ wk2we=0                   web=-210                  wec=-3500
+ scref=1.00e-06            ud=0                      tnoimod=0
+ minr=1e-3

     6: type=n
+ lmin=1.0000e-05-dxln_hvt  lmax=2.001e-05            wmin=1.0000e-06-dxwn_hvt
+ wmax=1.0000e-05-dxwn_hvt  version=4.5               binunit=2
+ paramchk=1                mobmod=0                  capmod=2
+ igcmod=1                  igbmod=1                  geomod=0
+ diomod=1                  rdsmod=0                  rbodymod=0
+ rgatemod=0                permod=1                  acnqsmod=0
+ trnqsmod=0                tnom=25                   toxe=toxn_hvt
+ toxm=toxn_hvt             dtox=3.03e-010            epsrox=3.9
+ wint=6e-009               lint=2.5e-009             ll=0
+ wl=0                      lln=1                     wln=1
+ lw=0                      ww=0                      lwn=1
+ wwn=1                     lwl=0                     wwl=0
+ llc=0                     wlc=0                     lwc=0
+ wwc=0                     lwlc=0                    wwlc=0
+ dlc=1.124e-008            dwc=0                     xpart=1
+ toxref=3e-009             dlcig=2.5e-009            xl=-3.5e-08+dxln_hvt
+ xw=1.5e-8+dxwn_hvt        vth0=0.35266267+dvthn_hvt wvth0=1.3377345e-008+dwvthn_hvt
+ lvth0=0+dlvthn_hvt        pvth0=0+dpvthn_hvt        k1=0.33
+ k2=0.031874068+dk2n_hvt   wk2=1.2597e-009           k3=-2.45
+ k3b=1.2                   w0=-5.5e-008              dvt0=18.2
+ dvt1=1.35                 dvt2=0.12                 dvt0w=0
+ dvt1w=0                   dvt2w=0                   dsub=0.5
+ minv=0                    voffl=0                   dvtp0=7e-007
+ dvtp1=0                   lpe0=1.5e-008             lpeb=0
+ xj=1.5e-007               ngate=4e020               ndep=8.3687e017
+ nsd=1e020                 phin=0                    cdsc=0
+ cdscb=0                   cdscd=0                   lcdscd=0+dlcdscdn_hvt
+ cit=0                     voff=-0.12942049          wvoff=-5.7968496e-009
+ lvoff=0+dlvoffn_hvt       lcit=0+dlcitn_hvt         pvoff=0+dpvoffn_hvt
+ nfactor=0.6569            eta0=0.13+deta0n_hvt      etab=-0.08
+ u0=0.03773129             wu0=-4.3141939e-009       ua=-4.28e-010
+ ub=1.414e-018             uc=1.435e-010             vsat=106694.65
+ lvsat=0.0011047847        wvsat=5.5515983e-005      pvsat=-1.108099e-009+dpvsatn_hvt
+ a0=2.33                   ags=0.8506                a1=0
+ a2=1                      b0=0                      b1=0
+ keta=-0.0164              dwg=0                     dwb=0
+ pclm=1.01                 pdiblc1=0.1691            pdiblc2=0.0001103
+ pdiblcb=-0.1              drout=0.5                 pvag=1.252
+ delta=0.0075              pscbe1=9.264e008          pscbe2=1e-020
+ fprout=0                  pdits=0                   pditsd=0
+ pditsl=0                  rsh=10.5                  rdsw=150
+ prwg=0                    prwb=0                    wr=1
+ alpha0=0                  alpha1=0.03               beta0=8.7
+ agidl=2.593e-009          bgidl=1.698e009           cgidl=0.25
+ egidl=0.2624              aigbacc=0.01238           bigbacc=0.006109
+ cigbacc=0.2809            nigbacc=4.05              aigbinv=0.35
+ bigbinv=0.03              cigbinv=0.006             eigbinv=1.1
+ nigbinv=1                 aigc=0.009898             bigc=0.001383
+ cigc=1.515e-005           aigsd=0.0086              bigsd=0.0004353
+ cigsd=3.925e-020          nigc=1                    poxedge=1
+ pigcd=1.672               ntox=ntoxn_hvt            xrcrg1=12
+ xrcrg2=1                  cgso=cgon_hvt             cgdo=cgon_hvt
+ cgbo=0                    cgdl=cgln_hvt             cgsl=cgln_hvt
+ clc=1e-007                cle=0.6                   cf=cfn_hvt
+ ckappas=0.6               acde=1.2                  moin=12.6
+ noff=1.686                voffcv=-0.05472           kt1=-0.1987
+ kt1l=0                    kt2=-0.0522               ute=-0.75
+ ua1=3.72e-009             ub1=-2.49e-018            uc1=2.4e-010
+ prt=0                     at=90000                  jss=2.00e-07
+ jsws=6.71e-13             jswgs=5.40e-11            njs=1
+ ijthsfwd=0.01             ijthsrev=0.01             bvs=10
+ xjbvs=1                   pbs=0.496                 cjs=cjn_hvt
+ mjs=0.336                 pbsws=0.8                 cjsws=cjswn_hvt
+ mjsws=0.01                pbswgs=1.0004             cjswgs=cjswgn_hvt
+ mjswgs=0.5561             tpb=1.00e-03              tcj=8.34e-04
+ tpbsw=1.00e-03            tcjsw=3.57e-04            tpbswg=1.50e-03
+ tcjswg=7.67e-04           xtis=3                    dmcg=9.25e-008
+ dmci=9.25e-008            dmdg=0                    dmcgt=0
+ dwj=0                     xgw=0                     xgl=0
+ rshg=0.1                  gbmin=1e-012              rbpb=50
+ rbpd=50                   rbps=50                   rbdb=50
+ rbsb=50                   ngcon=1                   saref=0.63e-6
+ sbref=0.63e-6             kvsat=0.1                 wlod=0.8e-6
+ tku0=0.01                 ku0=-7.01e-8              llodku0=1
+ wlodku0=1                 lku0=4.027e-7             wku0=8e-7
+ pku0=-2.0e-13             kvth0=3.5e-9              stk2=1.65e-9
+ steta0=0                  lkvth0=-2.68e-11          wkvth0=1.5e-6
+ pkvth0=0                  llodvth=1                 wlodvth=1
+ lodk2=0.5                 lodeta0=1                 fnoimod=1
+ noia=3.75e+41             noib=6.25e+24             noic=8.75
+ em=1.00e+08               ef=0.9                    wpemod=wpeflag_hvt
+ kvth0we=0.00323           lkvth0we=0                wkvth0we=0
+ pkvth0we=0                ku0we=-0.0015             lku0we=6.00e-10
+ wku0we=0                  pku0we=0                  k2we=0.0015
+ wk2we=0                   web=-210                  wec=-3500
+ scref=1.00e-06            ud=0                      tnoimod=0
+ minr=1e-3

     7: type=n
+ lmin=1.2000e-06-dxln_hvt  lmax=1.0000e-05-dxln_hvt  wmin=1.0000e-06-dxwn_hvt
+ wmax=1.0000e-05-dxwn_hvt  version=4.5               binunit=2
+ paramchk=1                mobmod=0                  capmod=2
+ igcmod=1                  igbmod=1                  geomod=0
+ diomod=1                  rdsmod=0                  rbodymod=0
+ rgatemod=0                permod=1                  acnqsmod=0
+ trnqsmod=0                tnom=25                   toxe=toxn_hvt
+ toxm=toxn_hvt             dtox=3.03e-010            epsrox=3.9
+ wint=6e-009               lint=2.5e-009             ll=0
+ wl=0                      lln=1                     wln=1
+ lw=0                      ww=0                      lwn=1
+ wwn=1                     lwl=0                     wwl=0
+ llc=0                     wlc=0                     lwc=0
+ wwc=0                     lwlc=0                    wwlc=0
+ dlc=1.124e-008            dwc=0                     xpart=1
+ toxref=3e-009             dlcig=2.5e-009            xl=-3.5e-08+dxln_hvt
+ xw=1.5e-8+dxwn_hvt        vth0=0.35215008+dvthn_hvt lvth0=5.1053199e-009+dlvthn_hvt
+ wvth0=1.3230397e-008+dwvthn_hvt                     pvth0=1.4636032e-015+dpvthn_hvt
+ k1=0.33                   k2=0.031828468+dk2n_hvt   lk2=4.5417756e-010
+ wk2=1.4257514e-009        pk2=-1.6538716e-015       k3=-2.45
+ k3b=1.2                   w0=-5.5e-008              dvt0=18.2
+ dvt1=1.35                 dvt2=0.12                 dvt0w=0
+ dvt1w=0                   dvt2w=0                   dsub=0.5
+ minv=0                    voffl=0                   dvtp0=7e-007
+ dvtp1=0                   lpe0=1.5e-008             lpeb=0
+ xj=1.5e-007               ngate=4e020               ndep=8.3687e017
+ nsd=1e020                 phin=0                    cdsc=0
+ cdscb=0                   cdscd=0                   lcdscd=0+dlcdscdn_hvt
+ cit=-3.0318182e-005       lcit=3.0196909e-010+dlcitn_hvt
+ voff=-0.13011817          lvoff=6.9489069e-009+dlvoffn_hvt
+ wvoff=-4.0922515e-009     pvoff=-1.6977797e-014+dpvoffn_hvt
+ nfactor=0.6569            eta0=0.13+deta0n_hvt      etab=-0.08
+ u0=0.037803424            lu0=-7.1845887e-010       wu0=-4.5610667e-009
+ pu0=2.4588534e-015        ua=-4.28e-010             ub=1.414e-018
+ uc=1.4651864e-010         luc=-3.0065618e-017       vsat=106805.57
+ pvsat=0+dpvsatn_hvt       wvsat=-5.5738939e-005     a0=2.4094966
+ la0=-7.9178659e-007       wa0=-3.4385858e-008       pa0=3.4248315e-013
+ ags=0.841465              lags=9.09846e-008         a1=0
+ a2=1                      b0=0                      b1=0
+ keta=-0.016616182         lketa=2.1531709e-009      dwg=0
+ dwb=0                     pclm=1.01                 pdiblc1=0.1691
+ pdiblc2=6.8882727e-005    lpdiblc2=4.1251604e-010   pdiblcb=-0.1
+ drout=0.5                 pvag=1.252                delta=0.0075
+ pscbe1=9.264e008          pscbe2=1e-020             fprout=0
+ pdits=0                   pditsd=0                  pditsl=0
+ rsh=10.5                  rdsw=150                  prwg=0
+ prwb=0                    wr=1                      alpha0=0
+ alpha1=0.03               beta0=8.7                 agidl=2.593e-009
+ bgidl=1.698e009           cgidl=0.25                egidl=0.2624
+ aigbacc=0.01238           bigbacc=0.006109          cigbacc=0.2809
+ nigbacc=4.05              aigbinv=0.35              bigbinv=0.03
+ cigbinv=0.006             eigbinv=1.1               nigbinv=1
+ aigc=0.009898             bigc=0.001383             cigc=1.515e-005
+ aigsd=0.0086              bigsd=0.0004353           cigsd=3.925e-020
+ nigc=1                    poxedge=1                 pigcd=1.672
+ ntox=ntoxn_hvt            xrcrg1=12                 xrcrg2=1
+ cgso=cgon_hvt             cgdo=cgon_hvt             cgbo=0
+ cgdl=cgln_hvt             cgsl=cgln_hvt             clc=1e-007
+ cle=0.6                   cf=cfn_hvt                ckappas=0.6
+ acde=1.2                  moin=12.6                 noff=1.686
+ voffcv=-0.05472           kt1=-0.19457409           lkt1=-4.1094055e-008
+ kt1l=0                    kt2=-0.052885455          lkt2=6.8271273e-009
+ ute=-0.74340909           lute=-6.5645455e-008      ua1=3.7485632e-009
+ lua1=-2.8448989e-016      wua1=-8.8168867e-018      pua1=8.7816192e-023
+ ub1=-2.486637e-018        lub1=-3.3495228e-026      wub1=1.9103255e-026
+ pub1=-1.9026841e-031      uc1=2.5581818e-010        luc1=-1.5754909e-016
+ prt=0                     at=90000                  jss=2.00e-07
+ jsws=6.71e-13             jswgs=5.40e-11            njs=1
+ ijthsfwd=0.01             ijthsrev=0.01             bvs=10
+ xjbvs=1                   pbs=0.496                 cjs=cjn_hvt
+ mjs=0.336                 pbsws=0.8                 cjsws=cjswn_hvt
+ mjsws=0.01                pbswgs=1.0004             cjswgs=cjswgn_hvt
+ mjswgs=0.5561             tpb=1.00e-03              tcj=8.34e-04
+ tpbsw=1.00e-03            tcjsw=3.57e-04            tpbswg=1.50e-03
+ tcjswg=7.67e-04           xtis=3                    dmcg=9.25e-008
+ dmci=9.25e-008            dmdg=0                    dmcgt=0
+ dwj=0                     xgw=0                     xgl=0
+ rshg=0.1                  gbmin=1e-012              rbpb=50
+ rbpd=50                   rbps=50                   rbdb=50
+ rbsb=50                   ngcon=1                   saref=0.63e-6
+ sbref=0.63e-6             kvsat=0.1                 wlod=0.8e-6
+ tku0=0.01                 ku0=-7.01e-8              llodku0=1
+ wlodku0=1                 lku0=4.027e-7             wku0=8e-7
+ pku0=-2.0e-13             kvth0=3.5e-9              stk2=1.65e-9
+ steta0=0                  lkvth0=-2.68e-11          wkvth0=1.5e-6
+ pkvth0=0                  llodvth=1                 wlodvth=1
+ lodk2=0.5                 lodeta0=1                 fnoimod=1
+ noia=3.75e+41             noib=6.25e+24             noic=8.75
+ em=1.00e+08               ef=0.9                    wpemod=wpeflag_hvt
+ kvth0we=0.00323           lkvth0we=0                wkvth0we=0
+ pkvth0we=0                ku0we=-0.0015             lku0we=6.00e-10
+ wku0we=0                  pku0we=0                  k2we=0.0015
+ wk2we=0                   web=-210                  wec=-3500
+ scref=1.00e-06            ud=0                      tnoimod=0
+ minr=1e-3

     8: type=n
+ lmin=5.0000e-07-dxln_hvt  lmax=1.2000e-06-dxln_hvt  wmin=1.0000e-06-dxwn_hvt
+ wmax=1.0000e-05-dxwn_hvt  version=4.5               binunit=2
+ paramchk=1                mobmod=0                  capmod=2
+ igcmod=1                  igbmod=1                  geomod=0
+ diomod=1                  rdsmod=0                  rbodymod=0
+ rgatemod=0                permod=1                  acnqsmod=0
+ trnqsmod=0                tnom=25                   toxe=toxn_hvt
+ toxm=toxn_hvt             dtox=3.03e-010            epsrox=3.9
+ wint=6e-009               lint=2.5e-009             ll=0
+ wl=0                      lln=1                     wln=1
+ lw=0                      ww=0                      lwn=1
+ wwn=1                     lwl=0                     wwl=0
+ llc=0                     wlc=0                     lwc=0
+ wwc=0                     lwlc=0                    wwlc=0
+ dlc=1.124e-008            dwc=0                     xpart=1
+ toxref=3e-009             dlcig=2.5e-009            xl=-3.5e-08+dxln_hvt
+ xw=1.5e-8+dxwn_hvt        vth0=0.35647799+dvthn_hvt lvth0=8.4952508e-011+dlvthn_hvt
+ wvth0=1.5224693e-008+dwvthn_hvt                     pvth0=-8.4977994e-016+dpvthn_hvt
+ k1=0.33                   k2=0.034546286+dk2n_hvt   lk2=-2.6984914e-009
+ k3=-2.45                  k3b=1.2                   w0=-5.5e-008
+ dvt0=18.2                 dvt1=1.35                 dvt2=0.12
+ dvt0w=0                   dvt1w=0                   dvt2w=0
+ dsub=0.5                  minv=0                    voffl=0
+ dvtp0=7e-007              dvtp1=0                   lpe0=1.5e-008
+ lpeb=0                    xj=1.5e-007               ngate=4e020
+ ndep=8.3687e017           nsd=1e020                 phin=0
+ cdsc=0                    cdscb=0                   cdscd=0
+ lcdscd=0+dlcdscdn_hvt     cit=-0.00014457143        lcit=4.3450286e-010+dlcitn_hvt
+ voff=-0.12631273          lvoff=2.5345915e-009+dlvoffn_hvt
+ wvoff=-1.2647962e-008     pvoff=-7.0531735e-015+dpvoffn_hvt
+ nfactor=0.6569            eta0=0.13+deta0n_hvt      etab=-0.08
+ u0=0.036405508            lu0=9.0312393e-010        wu0=-1.7527507e-009
+ pu0=-7.9879314e-016       ua=-4.2931429e-010        lua=1.5245714e-018
+ ub=1.4132637e-018         lub=8.5409879e-028        wub=2.051193e-026
+ pub=-2.3793838e-032       uc=1.206e-010             vsat=106809.23
+ lvsat=-4.2476254e-006     wvsat=-9.2367384e-005     pvsat=4.2488997e-011+dpvsatn_hvt
+ a0=1.7448018              la0=-2.0740524e-008       wa0=5.3557158e-007
+ pa0=-3.1866748e-013       ags=0.93751143            lags=-2.0429257e-008
+ a1=0                      a2=1                      b0=0
+ b1=0                      keta=-0.013833429         lketa=-1.0748229e-009
+ dwg=0                     dwb=0                     pclm=1.01
+ pdiblc1=0.1691            pdiblc2=0.00037718571     lpdiblc2=5.4884571e-011
+ pdiblcb=-0.1              drout=0.5                 pvag=1.252
+ delta=0.0075              pscbe1=9.264e008          pscbe2=1e-020
+ fprout=0                  pdits=0                   pditsd=0
+ pditsl=0                  rsh=10.5                  rdsw=150
+ prwg=0                    prwb=0                    wr=1
+ alpha0=0                  alpha1=0.03               beta0=8.7
+ agidl=2.593e-009          bgidl=1.698e009           cgidl=0.25
+ egidl=0.2624              aigbacc=0.01238           bigbacc=0.006109
+ cigbacc=0.2809            nigbacc=4.05              aigbinv=0.35
+ bigbinv=0.03              cigbinv=0.006             eigbinv=1.1
+ nigbinv=1                 aigc=0.009898             bigc=0.001383
+ cigc=1.515e-005           aigsd=0.0086              bigsd=0.0004353
+ cigsd=3.925e-020          nigc=1                    poxedge=1
+ pigcd=1.672               ntox=ntoxn_hvt            xrcrg1=12
+ xrcrg2=1                  cgso=cgon_hvt             cgdo=cgon_hvt
+ cgbo=0                    cgdl=cgln_hvt             cgsl=cgln_hvt
+ clc=1e-007                cle=0.6                   cf=cfn_hvt
+ ckappas=0.6               acde=1.2                  moin=12.6
+ noff=1.686                voffcv=-0.05472           kt1=-0.21968286
+ lkt1=-1.1967886e-008      kt1l=0                    kt2=-0.048550857
+ lkt2=1.7989943e-009       ute=-0.8                  ua1=3.5681606e-009
+ lua1=-7.5222862e-017      wua1=3.6118832e-017       pua1=3.5690757e-023
+ ub1=-2.5127707e-018       lub1=-3.1801713e-027      wub1=-3.4303336e-026
+ pub1=-1.2831677e-031      uc1=1.5153629e-010        luc1=-3.6582091e-017
+ prt=0                     at=90000                  jss=2.00e-07
+ jsws=6.71e-13             jswgs=5.40e-11            njs=1
+ ijthsfwd=0.01             ijthsrev=0.01             bvs=10
+ xjbvs=1                   pbs=0.496                 cjs=cjn_hvt
+ mjs=0.336                 pbsws=0.8                 cjsws=cjswn_hvt
+ mjsws=0.01                pbswgs=1.0004             cjswgs=cjswgn_hvt
+ mjswgs=0.5561             tpb=1.00e-03              tcj=8.34e-04
+ tpbsw=1.00e-03            tcjsw=3.57e-04            tpbswg=1.50e-03
+ tcjswg=7.67e-04           xtis=3                    dmcg=9.25e-008
+ dmci=9.25e-008            dmdg=0                    dmcgt=0
+ dwj=0                     xgw=0                     xgl=0
+ rshg=0.1                  gbmin=1e-012              rbpb=50
+ rbpd=50                   rbps=50                   rbdb=50
+ rbsb=50                   ngcon=1                   saref=0.63e-6
+ sbref=0.63e-6             kvsat=0.1                 wlod=0.8e-6
+ tku0=0.01                 ku0=-7.01e-8              llodku0=1
+ wlodku0=1                 lku0=4.027e-7             wku0=8e-7
+ pku0=-2.0e-13             kvth0=3.5e-9              stk2=1.65e-9
+ steta0=0                  lkvth0=-2.68e-11          wkvth0=1.5e-6
+ pkvth0=0                  llodvth=1                 wlodvth=1
+ lodk2=0.5                 lodeta0=1                 fnoimod=1
+ noia=3.75e+41             noib=6.25e+24             noic=8.75
+ em=1.00e+08               ef=0.9                    wpemod=wpeflag_hvt
+ kvth0we=0.00323           lkvth0we=0                wkvth0we=0
+ pkvth0we=0                ku0we=-0.0015             lku0we=6.00e-10
+ wku0we=0                  pku0we=0                  k2we=0.0015
+ wk2we=0                   web=-210                  wec=-3500
+ scref=1.00e-06            ud=0                      tnoimod=0
+ minr=1e-3

     9: type=n
+ lmin=2.4000e-07-dxln_hvt  lmax=5.0000e-07-dxln_hvt  wmin=1.0000e-06-dxwn_hvt
+ wmax=1.0000e-05-dxwn_hvt  version=4.5               binunit=2
+ paramchk=1                mobmod=0                  capmod=2
+ igcmod=1                  igbmod=1                  geomod=0
+ diomod=1                  rdsmod=0                  rbodymod=0
+ rgatemod=0                permod=1                  acnqsmod=0
+ trnqsmod=0                tnom=25                   toxe=toxn_hvt
+ toxm=toxn_hvt             dtox=3.03e-010            epsrox=3.9
+ wint=6e-009               lint=2.5e-009             ll=0
+ wl=0                      lln=1                     wln=1
+ lw=0                      ww=0                      lwn=1
+ wwn=1                     lwl=0                     wwl=0
+ llc=0                     wlc=0                     lwc=0
+ wwc=0                     lwlc=0                    wwlc=0
+ dlc=1.124e-008            dwc=0                     xpart=1
+ toxref=3e-009             dlcig=2.5e-009            xl=-3.5e-08+dxln_hvt
+ xw=1.5e-8+dxwn_hvt        vth0=0.36281882+dvthn_hvt lvth0=-2.8318308e-009+dlvthn_hvt
+ wvth0=5.6596461e-009+dwvthn_hvt                     pvth0=3.5501416e-015+dpvthn_hvt
+ k1=0.33                   k2=0.031629632+dk2n_hvt   lk2=-1.3568309e-009
+ wk2=2.6583186e-009        pk2=-1.2228266e-015       k3=-2.45
+ k3b=1.2                   w0=-5.5e-008              dvt0=18.2
+ dvt1=1.35                 dvt2=0.12                 dvt0w=0
+ dvt1w=0                   dvt2w=0                   dsub=0.5
+ minv=0                    voffl=0                   dvtp0=7e-007
+ dvtp1=0                   lpe0=1.5e-008             lpeb=0
+ xj=1.5e-007               ngate=4e020               ndep=8.3687e017
+ nsd=1e020                 phin=0                    cdsc=0
+ cdscb=0                   cdscd=0                   lcdscd=0+dlcdscdn_hvt
+ cit=0.00045384615         lcit=1.5923077e-010+dlcitn_hvt
+ voff=-0.11123672          lvoff=-4.4003718e-009+dlvoffn_hvt
+ wvoff=-3.4412363e-008     pvoff=2.9584514e-015+dpvoffn_hvt
+ nfactor=0.6569            eta0=0.13+deta0n_hvt      etab=-0.08
+ u0=0.037952879            lu0=1.9133326e-010        wu0=-4.4839833e-009
+ pu0=4.5757381e-016        ua=-4.2907692e-010        lua=1.4153846e-018
+ ub=1.4164736e-018         lub=-6.224547e-028        wub=1.6807434e-026
+ pub=-2.208977e-032        uc=1.0836785e-010         luc=5.6267908e-018
+ wuc=4.6306195e-018        puc=-2.130085e-024        vsat=106800
+ pvsat=0+dpvsatn_hvt       a0=1.1757867              la0=2.4100638e-007
+ wa0=1.1293567e-007        pa0=-1.2425496e-013       ags=0.92579231
+ lags=-1.5038462e-008      a1=0                      a2=1
+ b0=0                      b1=0                      keta=-0.029185385
+ lketa=5.9870769e-009      dwg=0                     dwb=0
+ pclm=1.01                 pdiblc1=0.1691            pdiblc2=0.00069031762
+ lpdiblc2=-8.9156107e-011  wpdiblc2=-1.762551e-009   ppdiblc2=8.1077346e-016
+ pdiblcb=-0.1              drout=0.5                 pvag=1.252
+ delta=0.0075              pscbe1=9.264e008          pscbe2=1e-020
+ fprout=0                  pdits=0                   pditsd=0
+ pditsl=0                  rsh=10.5                  rdsw=150
+ prwg=0                    prwb=0                    wr=1
+ alpha0=0                  alpha1=0.03               beta0=8.7
+ agidl=2.593e-009          bgidl=1.698e009           cgidl=0.25
+ egidl=0.2624              aigbacc=0.01238           bigbacc=0.006109
+ cigbacc=0.2809            nigbacc=4.05              aigbinv=0.35
+ bigbinv=0.03              cigbinv=0.006             eigbinv=1.1
+ nigbinv=1                 aigc=0.009898             bigc=0.001383
+ cigc=1.515e-005           aigsd=0.0086              bigsd=0.0004353
+ cigsd=3.925e-020          nigc=1                    poxedge=1
+ pigcd=1.672               ntox=ntoxn_hvt            xrcrg1=12
+ xrcrg2=1                  cgso=cgon_hvt             cgdo=cgon_hvt
+ cgbo=0                    cgdl=cgln_hvt             cgsl=cgln_hvt
+ clc=1e-007                cle=0.6                   cf=cfn_hvt
+ ckappas=0.6               acde=1.2                  moin=12.6
+ noff=1.686                voffcv=-0.05472           kt1=-0.22701211
+ lkt1=-8.5964289e-009      wkt1=-1.3806106e-008      pkt1=6.3508089e-015
+ kt1l=0                    kt2=-0.049101538          lkt2=2.0523077e-009
+ ute=-0.8                  ua1=3.3966578e-009        lua1=3.668441e-018
+ wua1=2.0117469e-016       pua1=-4.0234939e-023      ub1=-2.3757153e-018
+ lub1=-6.622565e-026       wub1=-4.3759355e-025      pub1=5.7196727e-032
+ uc1=9.4402308e-011        luc1=-1.0300462e-017      prt=0
+ at=115615.38              lat=-0.011783077          jss=2.00e-07
+ jsws=6.71e-13             jswgs=5.40e-11            njs=1
+ ijthsfwd=0.01             ijthsrev=0.01             bvs=10
+ xjbvs=1                   pbs=0.496                 cjs=cjn_hvt
+ mjs=0.336                 pbsws=0.8                 cjsws=cjswn_hvt
+ mjsws=0.01                pbswgs=1.0004             cjswgs=cjswgn_hvt
+ mjswgs=0.5561             tpb=1.00e-03              tcj=8.34e-04
+ tpbsw=1.00e-03            tcjsw=3.57e-04            tpbswg=1.50e-03
+ tcjswg=7.67e-04           xtis=3                    dmcg=9.25e-008
+ dmci=9.25e-008            dmdg=0                    dmcgt=0
+ dwj=0                     xgw=0                     xgl=0
+ rshg=0.1                  gbmin=1e-012              rbpb=50
+ rbpd=50                   rbps=50                   rbdb=50
+ rbsb=50                   ngcon=1                   saref=0.63e-6
+ sbref=0.63e-6             kvsat=0.1                 wlod=0.8e-6
+ tku0=0.01                 ku0=-7.01e-8              llodku0=1
+ wlodku0=1                 lku0=4.027e-7             wku0=8e-7
+ pku0=-2.0e-13             kvth0=3.5e-9              stk2=1.65e-9
+ steta0=0                  lkvth0=-2.68e-11          wkvth0=1.5e-6
+ pkvth0=0                  llodvth=1                 wlodvth=1
+ lodk2=0.5                 lodeta0=1                 fnoimod=1
+ noia=3.75e+41             noib=6.25e+24             noic=8.75
+ em=1.00e+08               ef=0.9                    wpemod=wpeflag_hvt
+ kvth0we=0.00323           lkvth0we=0                wkvth0we=0
+ pkvth0we=0                ku0we=-0.0015             lku0we=6.00e-10
+ wku0we=0                  pku0we=0                  k2we=0.0015
+ wk2we=0                   web=-210                  wec=-3500
+ scref=1.00e-06            ud=0                      tnoimod=0
+ minr=1e-3

     10: type=n
+ lmin=1.0e-07              lmax=2.4000e-07-dxln_hvt  wmin=1.0000e-06-dxwn_hvt
+ wmax=1.0000e-05-dxwn_hvt  version=4.5               binunit=2
+ paramchk=1                mobmod=0                  capmod=2
+ igcmod=1                  igbmod=1                  geomod=0
+ diomod=1                  rdsmod=0                  rbodymod=0
+ rgatemod=0                permod=1                  acnqsmod=0
+ trnqsmod=0                tnom=25                   toxe=toxn_hvt
+ toxm=toxn_hvt             dtox=3.03e-010            epsrox=3.9
+ wint=6e-009               lint=2.5e-009             ll=0
+ wl=0                      lln=1                     wln=1
+ lw=0                      ww=0                      lwn=1
+ wwn=1                     lwl=0                     wwl=0
+ llc=0                     wlc=0                     lwc=0
+ wwc=0                     lwlc=0                    wwlc=0
+ dlc=1.124e-008            dwc=0                     xpart=1
+ toxref=3e-009             dlcig=2.5e-009            xl=-3.5e-08+dxln_hvt
+ xw=1.5e-8+dxwn_hvt        vth0=0.34889848+dvthn_hvt lvth0=-4.7761905e-011+dlvthn_hvt
+ wvth0=2.1021543e-008+dwvthn_hvt                     pvth0=4.7776233e-016+dpvthn_hvt
+ k1=0.33                   k2=0.032710856+dk2n_hvt   lk2=-1.5730757e-009
+ wk2=-7.1106961e-009       pk2=7.3097637e-016        k3=-2.45
+ k3b=1.2                   w0=-5.5e-008              dvt0=18.2
+ dvt1=1.35                 dvt2=0.12                 dvt0w=0
+ dvt1w=0                   dvt2w=0                   dsub=0.5
+ minv=0                    voffl=0                   dvtp0=7e-007
+ dvtp1=0                   lpe0=1.5e-008             lpeb=0
+ xj=1.5e-007               ngate=4e020               ndep=8.3687e017
+ nsd=1e020                 phin=0                    cdsc=0
+ cdscb=0                   cdscd=0                   lcdscd=0+dlcdscdn_hvt
+ cit=-0.00015271429        lcit=2.8054286e-010+dlcitn_hvt
+ voff=-0.12070868          lvoff=-2.50598e-009+dlvoffn_hvt
+ wvoff=-2.4063296e-008     pvoff=8.8863794e-016+dpvoffn_hvt
+ nfactor=0.6569            eta0=0.12313099+deta0n_hvt
+ leta0=1.3738019e-009      weta0=7.8353023e-009      peta0=-1.5670605e-015
+ etab=-0.08                u0=0.040466781            lu0=-3.1144705e-010
+ wu0=-4.0976083e-009       pu0=3.8029882e-016        ua=-4.2457143e-010
+ lua=5.1428571e-019        ub=1.4139448e-018         lub=-1.1668571e-028
+ wub=-1.3377345e-025       pub=8.0264072e-033        uc=1.4982695e-010
+ luc=-2.665031e-018        wuc=-2.5560285e-018       puc=-6.9275538e-025
+ vsat=106390.79            lvsat=8.1841905e-005      wvsat=-0.0010510771
+ pvsat=2.1021543e-010+dpvsatn_hvt                    a0=2.9781072
+ la0=-1.1945771e-007       wa0=-9.956567e-007        pa0=9.7463516e-014
+ ags=0.8506                a1=0                      a2=1
+ b0=0                      b1=0                      keta=-0.015887426
+ lketa=3.3274852e-009      wketa=-1.0200226e-008     pketa=2.0400452e-015
+ dwg=0                     dwb=0                     pclm=1.01
+ pdiblc1=0.1691            pdiblc2=0.00039284685     lpdiblc2=-2.9661952e-011
+ wpdiblc2=1.8923848e-009   ppdiblc2=7.978631e-017    pdiblcb=-0.1
+ drout=0.5                 pvag=1.252                delta=0.0075
+ pscbe1=9.264e008          pscbe2=1e-020             fprout=0
+ pdits=0                   pditsd=0                  pditsl=0
+ rsh=10.5                  rdsw=150                  prwg=0
+ prwb=0                    wr=1                      alpha0=0
+ alpha1=0.03               beta0=8.7                 agidl=2.593e-009
+ bgidl=1.698e009           cgidl=0.25                egidl=0.2624
+ aigbacc=0.01238           bigbacc=0.006109          cigbacc=0.2809
+ nigbacc=4.05              aigbinv=0.35              bigbinv=0.03
+ cigbinv=0.006             eigbinv=1.1               nigbinv=1
+ aigc=0.009898             bigc=0.001383             cigc=1.515e-005
+ aigsd=0.0086              bigsd=0.0004353           cigsd=3.925e-020
+ nigc=1                    poxedge=1                 pigcd=1.672
+ ntox=ntoxn_hvt            xrcrg1=12                 xrcrg2=1
+ cgso=cgon_hvt             cgdo=cgon_hvt             cgbo=0
+ cgdl=cgln_hvt             cgsl=cgln_hvt             clc=1e-007
+ cle=0.6                   cf=cfn_hvt                ckappas=0.6
+ acde=1.2                  moin=12.6                 noff=1.686
+ voffcv=-0.05472           kt1=-0.25630657           lkt1=-2.7375371e-009
+ wkt1=1.1354818e-008       pkt1=1.318624e-015        kt1l=0
+ kt2=-0.041917143          lkt2=6.1542857e-010       ute=-0.8
+ ua1=4.087257e-009         lua1=-1.344514e-016       wua1=9.6030229e-017
+ pua1=-1.9206046e-023      ub1=-3.6492293e-018       lub1=1.8847714e-025
+ wub1=-1.5160991e-025      pub1=3.6805471e-047       uc1=-3.312789e-011
+ luc1=1.5205578e-017       wuc1=2.9573488e-017       puc1=-5.9146977e-024
+ prt=0                     at=57085.714              lat=-7.7142857e-005
+ jss=2.00e-07              jsws=6.71e-13             jswgs=5.40e-11
+ njs=1                     ijthsfwd=0.01             ijthsrev=0.01
+ bvs=10                    xjbvs=1                   pbs=0.496
+ cjs=cjn_hvt               mjs=0.336                 pbsws=0.8
+ cjsws=cjswn_hvt           mjsws=0.01                pbswgs=1.0004
+ cjswgs=cjswgn_hvt         mjswgs=0.5561             tpb=1.00e-03
+ tcj=8.34e-04              tpbsw=1.00e-03            tcjsw=3.57e-04
+ tpbswg=1.50e-03           tcjswg=7.67e-04           xtis=3
+ dmcg=9.25e-008            dmci=9.25e-008            dmdg=0
+ dmcgt=0                   dwj=0                     xgw=0
+ xgl=0                     rshg=0.1                  gbmin=1e-012
+ rbpb=50                   rbpd=50                   rbps=50
+ rbdb=50                   rbsb=50                   ngcon=1
+ saref=0.63e-6             sbref=0.63e-6             kvsat=0.1
+ wlod=0.8e-6               tku0=0.01                 ku0=-7.01e-8
+ llodku0=1                 wlodku0=1                 lku0=4.027e-7
+ wku0=8e-7                 pku0=-2.0e-13             kvth0=3.5e-9
+ stk2=1.65e-9              steta0=0                  lkvth0=-2.68e-11
+ wkvth0=1.5e-6             pkvth0=0                  llodvth=1
+ wlodvth=1                 lodk2=0.5                 lodeta0=1
+ fnoimod=1                 noia=3.75e+41             noib=6.25e+24
+ noic=8.75                 em=1.00e+08               ef=0.9
+ wpemod=wpeflag_hvt        kvth0we=0.00323           lkvth0we=0
+ wkvth0we=0                pkvth0we=0                ku0we=-0.0015
+ lku0we=6.00e-10           wku0we=0                  pku0we=0
+ k2we=0.0015               wk2we=0                   web=-210
+ wec=-3500                 scref=1.00e-06            ud=0
+ tnoimod=0                 minr=1e-3

     11: type=n
+ lmin=1.0000e-05-dxln_hvt  lmax=2.001e-05            wmin=5.0000e-07-dxwn_hvt
+ wmax=1.0000e-06-dxwn_hvt  version=4.5               binunit=2
+ paramchk=1                mobmod=0                  capmod=2
+ igcmod=1                  igbmod=1                  geomod=0
+ diomod=1                  rdsmod=0                  rbodymod=0
+ rgatemod=0                permod=1                  acnqsmod=0
+ trnqsmod=0                tnom=25                   toxe=toxn_hvt
+ toxm=toxn_hvt             dtox=3.03e-010            epsrox=3.9
+ wint=6e-009               lint=2.5e-009             ll=0
+ wl=0                      lln=1                     wln=1
+ lw=0                      ww=0                      lwn=1
+ wwn=1                     lwl=0                     wwl=0
+ llc=0                     wlc=0                     lwc=0
+ wwc=0                     lwlc=0                    wwlc=0
+ dlc=1.124e-008            dwc=0                     xpart=1
+ toxref=3e-009             dlcig=2.5e-009            xl=-3.5e-08+dxln_hvt
+ xw=1.5e-8+dxwn_hvt        vth0=0.369018+dvthn_hvt   wvth0=-3.027054e-009+dwvthn_hvt
+ lvth0=0+dlvthn_hvt        pvth0=0+dpvthn_hvt        k1=0.33
+ k2=0.03406558+dk2n_hvt    wk2=-9.3838674e-010       k3=-2.45
+ k3b=1.2                   w0=-5.5e-008              dvt0=18.2
+ dvt1=1.35                 dvt2=0.12                 dvt0w=0
+ dvt1w=0                   dvt2w=0                   dsub=0.5
+ minv=0                    voffl=0                   dvtp0=7e-007
+ dvtp1=0                   lpe0=1.5e-008             lpeb=0
+ xj=1.5e-007               ngate=4e020               ndep=8.3687e017
+ nsd=1e020                 phin=0                    cdsc=0
+ cdscb=0                   cdscd=0                   lcdscd=0+dlcdscdn_hvt
+ cit=0                     voff=-0.1395258           wvoff=4.3387774e-009
+ lvoff=0+dlvoffn_hvt       lcit=0+dlcitn_hvt         pvoff=0+dpvoffn_hvt
+ nfactor=0.6569            eta0=0.13+deta0n_hvt      etab=-0.08
+ u0=0.03500942             wu0=-1.5841583e-009       ua=-4.28e-010
+ ub=1.414e-018             uc=1.435e-010             vsat=106699.7
+ pvsat=0+dpvsatn_hvt       wvsat=5.04509e-005        a0=2.33
+ ags=0.8506                a1=0                      a2=1
+ b0=0                      b1=0                      keta=-0.038203038
+ wketa=2.1868447e-008      dwg=0                     dwb=0
+ pclm=1.01                 pdiblc1=0.1691            pdiblc2=0.0001103
+ pdiblcb=-0.1              drout=0.5                 pvag=1.252
+ delta=0.0075              pscbe1=9.264e008          pscbe2=1e-020
+ fprout=0                  pdits=0                   pditsd=0
+ pditsl=0                  rsh=10.5                  rdsw=150
+ prwg=0                    prwb=0                    wr=1
+ alpha0=0                  alpha1=0.03               beta0=8.7
+ agidl=2.593e-009          bgidl=1.698e009           cgidl=0.25
+ egidl=0.2624              aigbacc=0.01238           bigbacc=0.006109
+ cigbacc=0.2809            nigbacc=4.05              aigbinv=0.35
+ bigbinv=0.03              cigbinv=0.006             eigbinv=1.1
+ nigbinv=1                 aigc=0.009898             bigc=0.001383
+ cigc=1.515e-005           aigsd=0.0086              bigsd=0.0004353
+ cigsd=3.925e-020          nigc=1                    poxedge=1
+ pigcd=1.672               ntox=ntoxn_hvt            xrcrg1=12
+ xrcrg2=1                  cgso=cgon_hvt             cgdo=cgon_hvt
+ cgbo=0                    cgdl=cgln_hvt             cgsl=cgln_hvt
+ clc=1e-007                cle=0.6                   cf=cfn_hvt
+ ckappas=0.6               acde=1.2                  moin=12.6
+ noff=1.686                voffcv=-0.05472           kt1=-0.1987
+ kt1l=0                    kt2=-0.0522               ute=-0.75
+ ua1=3.72e-009             ub1=-2.164056e-018        wub1=-3.2692183e-025
+ uc1=2.4e-010              prt=0                     at=90000
+ jss=2.00e-07              jsws=6.71e-13             jswgs=5.40e-11
+ njs=1                     ijthsfwd=0.01             ijthsrev=0.01
+ bvs=10                    xjbvs=1                   pbs=0.496
+ cjs=cjn_hvt               mjs=0.336                 pbsws=0.8
+ cjsws=cjswn_hvt           mjsws=0.01                pbswgs=1.0004
+ cjswgs=cjswgn_hvt         mjswgs=0.5561             tpb=1.00e-03
+ tcj=8.34e-04              tpbsw=1.00e-03            tcjsw=3.57e-04
+ tpbswg=1.50e-03           tcjswg=7.67e-04           xtis=3
+ dmcg=9.25e-008            dmci=9.25e-008            dmdg=0
+ dmcgt=0                   dwj=0                     xgw=0
+ xgl=0                     rshg=0.1                  gbmin=1e-012
+ rbpb=50                   rbpd=50                   rbps=50
+ rbdb=50                   rbsb=50                   ngcon=1
+ saref=0.63e-6             sbref=0.63e-6             kvsat=0.1
+ wlod=0.8e-6               tku0=0.01                 ku0=-7.01e-8
+ llodku0=1                 wlodku0=1                 lku0=4.027e-7
+ wku0=8e-7                 pku0=-2.0e-13             kvth0=3.5e-9
+ stk2=1.65e-9              steta0=0                  lkvth0=-2.68e-11
+ wkvth0=1.5e-6             pkvth0=0                  llodvth=1
+ wlodvth=1                 lodk2=0.5                 lodeta0=1
+ fnoimod=1                 noia=3.75e+41             noib=6.25e+24
+ noic=8.75                 em=1.00e+08               ef=0.9
+ wpemod=wpeflag_hvt        kvth0we=0.00323           lkvth0we=0
+ wkvth0we=0                pkvth0we=0                ku0we=-0.0015
+ lku0we=6.00e-10           wku0we=0                  pku0we=0
+ k2we=0.0015               wk2we=0                   web=-210
+ wec=-3500                 scref=1.00e-06            ud=0
+ tnoimod=0                 minr=1e-3

     12: type=n
+ lmin=1.2000e-06-dxln_hvt  lmax=1.0000e-05-dxln_hvt  wmin=5.0000e-07-dxwn_hvt
+ wmax=1.0000e-06-dxwn_hvt  version=4.5               binunit=2
+ paramchk=1                mobmod=0                  capmod=2
+ igcmod=1                  igbmod=1                  geomod=0
+ diomod=1                  rdsmod=0                  rbodymod=0
+ rgatemod=0                permod=1                  acnqsmod=0
+ trnqsmod=0                tnom=25                   toxe=toxn_hvt
+ toxm=toxn_hvt             dtox=3.03e-010            epsrox=3.9
+ wint=6e-009               lint=2.5e-009             ll=0
+ wl=0                      lln=1                     wln=1
+ lw=0                      ww=0                      lwn=1
+ wwn=1                     lwl=0                     wwl=0
+ llc=0                     wlc=0                     lwc=0
+ wwc=0                     lwlc=0                    wwlc=0
+ dlc=1.124e-008            dwc=0                     xpart=1
+ toxref=3e-009             dlcig=2.5e-009            xl=-3.5e-08+dxln_hvt
+ xw=1.5e-8+dxwn_hvt        vth0=0.36849152+dvthn_hvt lvth0=5.2437589e-009+dlvthn_hvt
+ wvth0=-3.1600609e-009+dwvthn_hvt                    pvth0=1.3247489e-015+dpvthn_hvt
+ k1=0.33                   k2=0.034308861+dk2n_hvt   lk2=-2.4230788e-009
+ wk2=-1.0620832e-009       pk2=1.2320165e-015        k3=-2.45
+ k3b=1.2                   w0=-5.5e-008              dvt0=18.2
+ dvt1=1.35                 dvt2=0.12                 dvt0w=0
+ dvt1w=0                   dvt2w=0                   dsub=0.5
+ minv=0                    voffl=0                   dvtp0=7e-007
+ dvtp1=0                   lpe0=1.5e-008             lpeb=0
+ xj=1.5e-007               ngate=4e020               ndep=8.3687e017
+ nsd=1e020                 phin=0                    cdsc=0
+ cdscb=0                   cdscd=0                   lcdscd=0+dlcdscdn_hvt
+ cit=-3.0318182e-005       lcit=3.0196909e-010+dlcitn_hvt
+ voff=-0.13991638          lvoff=3.8901496e-009+dlvoffn_hvt
+ wvoff=5.73535e-009        pvoff=-1.3909864e-014+dpvoffn_hvt
+ nfactor=0.6569            eta0=0.13+deta0n_hvt      etab=-0.08
+ u0=0.03484205             lu0=1.6670007e-009        wu0=-1.5908086e-009
+ pu0=6.6237445e-017        ua=-4.28e-010             ub=1.414e-018
+ uc=1.4651864e-010         luc=-3.0065618e-017       vsat=106693.07
+ lvsat=6.6039327e-005      wvsat=5.7101246e-005      pvsat=-6.6237445e-011+dpvsatn_hvt
+ a0=2.3752136              la0=-4.5032782e-007       ags=0.841465
+ lags=9.09846e-008         a1=0                      a2=1
+ b0=0                      b1=0                      keta=-0.041293257
+ lketa=3.0778578e-008      wketa=2.4751106e-008      pketa=-2.8711283e-014
+ dwg=0                     dwb=0                     pclm=1.01
+ pdiblc1=0.1691            pdiblc2=0.00017437326     lpdiblc2=-6.3816966e-010
+ wpdiblc2=-1.05807e-010    ppdiblc2=1.0538378e-015   pdiblcb=-0.1
+ drout=0.5                 pvag=1.252                delta=0.0075
+ pscbe1=9.264e008          pscbe2=1e-020             fprout=0
+ pdits=0                   pditsd=0                  pditsl=0
+ rsh=10.5                  rdsw=150                  prwg=0
+ prwb=0                    wr=1                      alpha0=0
+ alpha1=0.03               beta0=8.7                 agidl=2.593e-009
+ bgidl=1.698e009           cgidl=0.25                egidl=0.2624
+ aigbacc=0.01238           bigbacc=0.006109          cigbacc=0.2809
+ nigbacc=4.05              aigbinv=0.35              bigbinv=0.03
+ cigbinv=0.006             eigbinv=1.1               nigbinv=1
+ aigc=0.009898             bigc=0.001383             cigc=1.515e-005
+ aigsd=0.0086              bigsd=0.0004353           cigsd=3.925e-020
+ nigc=1                    poxedge=1                 pigcd=1.672
+ ntox=ntoxn_hvt            xrcrg1=12                 xrcrg2=1
+ cgso=cgon_hvt             cgdo=cgon_hvt             cgbo=0
+ cgdl=cgln_hvt             cgsl=cgln_hvt             clc=1e-007
+ cle=0.6                   cf=cfn_hvt                ckappas=0.6
+ acde=1.2                  moin=12.6                 noff=1.686
+ voffcv=-0.05472           kt1=-0.19471996           lkt1=-3.9641189e-008
+ wkt1=1.4630761e-010       pkt1=-1.4572238e-015      kt1l=0
+ kt2=-0.052768759          lkt2=5.6648351e-009       wkt2=-1.1704609e-010
+ pkt2=1.165779e-015        ute=-0.74340909           lute=-6.5645455e-008
+ ua1=3.7231966e-009        lua1=-3.1838045e-017      wua1=1.6625865e-017
+ pua1=-1.6559361e-022      ub1=-2.1205621e-018       lub1=-4.3319961e-025
+ wub1=-3.4806993e-025      pub1=2.1063508e-031       uc1=2.4998471e-010
+ luc1=-9.9447691e-017      wuc1=5.8509743e-018       puc1=-5.8275704e-023
+ prt=0                     at=90000                  jss=2.00e-07
+ jsws=6.71e-13             jswgs=5.40e-11            njs=1
+ ijthsfwd=0.01             ijthsrev=0.01             bvs=10
+ xjbvs=1                   pbs=0.496                 cjs=cjn_hvt
+ mjs=0.336                 pbsws=0.8                 cjsws=cjswn_hvt
+ mjsws=0.01                pbswgs=1.0004             cjswgs=cjswgn_hvt
+ mjswgs=0.5561             tpb=1.00e-03              tcj=8.34e-04
+ tpbsw=1.00e-03            tcjsw=3.57e-04            tpbswg=1.50e-03
+ tcjswg=7.67e-04           xtis=3                    dmcg=9.25e-008
+ dmci=9.25e-008            dmdg=0                    dmcgt=0
+ dwj=0                     xgw=0                     xgl=0
+ rshg=0.1                  gbmin=1e-012              rbpb=50
+ rbpd=50                   rbps=50                   rbdb=50
+ rbsb=50                   ngcon=1                   saref=0.63e-6
+ sbref=0.63e-6             kvsat=0.1                 wlod=0.8e-6
+ tku0=0.01                 ku0=-7.01e-8              llodku0=1
+ wlodku0=1                 lku0=4.027e-7             wku0=8e-7
+ pku0=-2.0e-13             kvth0=3.5e-9              stk2=1.65e-9
+ steta0=0                  lkvth0=-2.68e-11          wkvth0=1.5e-6
+ pkvth0=0                  llodvth=1                 wlodvth=1
+ lodk2=0.5                 lodeta0=1                 fnoimod=1
+ noia=3.75e+41             noib=6.25e+24             noic=8.75
+ em=1.00e+08               ef=0.9                    wpemod=wpeflag_hvt
+ kvth0we=0.00323           lkvth0we=0                wkvth0we=0
+ pkvth0we=0                ku0we=-0.0015             lku0we=6.00e-10
+ wku0we=0                  pku0we=0                  k2we=0.0015
+ wk2we=0                   web=-210                  wec=-3500
+ scref=1.00e-06            ud=0                      tnoimod=0
+ minr=1e-3

     13: type=n
+ lmin=5.0000e-07-dxln_hvt  lmax=1.2000e-06-dxln_hvt  wmin=5.0000e-07-dxwn_hvt
+ wmax=1.0000e-06-dxwn_hvt  version=4.5               binunit=2
+ paramchk=1                mobmod=0                  capmod=2
+ igcmod=1                  igbmod=1                  geomod=0
+ diomod=1                  rdsmod=0                  rbodymod=0
+ rgatemod=0                permod=1                  acnqsmod=0
+ trnqsmod=0                tnom=25                   toxe=toxn_hvt
+ toxm=toxn_hvt             dtox=3.03e-010            epsrox=3.9
+ wint=6e-009               lint=2.5e-009             ll=0
+ wl=0                      lln=1                     wln=1
+ lw=0                      ww=0                      lwn=1
+ wwn=1                     lwl=0                     wwl=0
+ llc=0                     wlc=0                     lwc=0
+ wwc=0                     lwlc=0                    wwlc=0
+ dlc=1.124e-008            dwc=0                     xpart=1
+ toxref=3e-009             dlcig=2.5e-009            xl=-3.5e-08+dxln_hvt
+ xw=1.5e-8+dxwn_hvt        vth0=0.37631349+dvthn_hvt lvth0=-3.8297234e-009+dlvthn_hvt
+ wvth0=-4.6703119e-009+dwvthn_hvt                    pvth0=3.07664e-015+dpvthn_hvt
+ k1=0.33                   k2=0.034546286+dk2n_hvt   lk2=-2.6984914e-009
+ k3=-2.45                  k3b=1.2                   w0=-5.5e-008
+ dvt0=18.2                 dvt1=1.35                 dvt2=0.12
+ dvt0w=0                   dvt1w=0                   dvt2w=0
+ dsub=0.5                  minv=0                    voffl=0
+ dvtp0=7e-007              dvtp1=0                   lpe0=1.5e-008
+ lpeb=0                    xj=1.5e-007               ngate=4e020
+ ndep=8.3687e017           nsd=1e020                 phin=0
+ cdsc=0                    cdscb=0                   cdscd=0
+ lcdscd=0+dlcdscdn_hvt     cit=-0.00014457143        lcit=4.3450286e-010+dlcitn_hvt
+ voff=-0.13182625          lvoff=-5.494403e-009+dlvoffn_hvt
+ wvoff=-7.1179013e-009     pvoff=9.9990801e-016+dpvoffn_hvt
+ nfactor=0.6569            eta0=0.13+deta0n_hvt      etab=-0.08
+ u0=0.037396907            lu0=-1.2966328e-009       wu0=-2.7471236e-009
+ pu0=1.4075628e-015        ua=-4.2931429e-010        lua=1.5245714e-018
+ ub=1.4522247e-018         lub=-4.4340635e-026       wub=-1.8565931e-026
+ pub=2.153648e-032         uc=1.206e-010             vsat=106717.14
+ lvsat=3.8114286e-005      a0=2.4486705              pvsat=0+dpvsatn_hvt
+ la0=-5.3553773e-007       wa0=-1.7040873e-007       pa0=1.9767412e-013
+ ags=0.93751143            lags=-2.0429257e-008      a1=0
+ a2=1                      b0=0                      b1=0
+ keta=-0.013833429         lketa=-1.0748229e-009     dwg=0
+ dwb=0                     pclm=1.01                 pdiblc1=0.1691
+ pdiblc2=-5.5523629e-005   lpdiblc2=-3.7148927e-010  wpdiblc2=4.3400747e-010
+ ppdiblc2=4.2765296e-016   pdiblcb=-0.1              drout=0.5
+ pvag=1.252                delta=0.0075              pscbe1=9.264e008
+ pscbe2=1e-020             fprout=0                  pdits=0
+ pditsd=0                  pditsl=0                  rsh=10.5
+ rdsw=150                  prwg=0                    prwb=0
+ wr=1                      alpha0=0                  alpha1=0.03
+ beta0=8.7                 agidl=2.593e-009          bgidl=1.698e009
+ cgidl=0.25                egidl=0.2624              aigbacc=0.01238
+ bigbacc=0.006109          cigbacc=0.2809            nigbacc=4.05
+ aigbinv=0.35              bigbinv=0.03              cigbinv=0.006
+ eigbinv=1.1               nigbinv=1                 aigc=0.009898
+ bigc=0.001383             cigc=1.515e-005           aigsd=0.0086
+ bigsd=0.0004353           cigsd=3.925e-020          nigc=1
+ poxedge=1                 pigcd=1.672               ntox=ntoxn_hvt
+ xrcrg1=12                 xrcrg2=1                  cgso=cgon_hvt
+ cgdo=cgon_hvt             cgbo=0                    cgdl=cgln_hvt
+ cgsl=cgln_hvt             clc=1e-007                cle=0.6
+ cf=cfn_hvt                ckappas=0.6               acde=1.2
+ moin=12.6                 noff=1.686                voffcv=-0.05472
+ kt1=-0.21784906           lkt1=-1.2811431e-008      wkt1=-1.8392957e-009
+ pkt1=8.4607601e-016       kt1l=0                    kt2=-0.050017893
+ lkt2=2.4738306e-009       wkt2=1.4714365e-009       pkt2=-6.7686081e-016
+ ute=-0.8                  ua1=3.6962061e-009        lua1=-5.2902629e-019
+ wua1=-9.2310732e-017      pua1=-3.922716e-023       ub1=-2.2719023e-018
+ lub1=-2.5764495e-025      wub1=-2.7589435e-025      pub1=1.269114e-031
+ uc1=1.5346091e-010        luc1=1.2519918e-017       wuc1=-1.9303956e-018
+ puc1=-4.9249315e-023      prt=0                     at=90000
+ jss=2.00e-07              jsws=6.71e-13             jswgs=5.40e-11
+ njs=1                     ijthsfwd=0.01             ijthsrev=0.01
+ bvs=10                    xjbvs=1                   pbs=0.496
+ cjs=cjn_hvt               mjs=0.336                 pbsws=0.8
+ cjsws=cjswn_hvt           mjsws=0.01                pbswgs=1.0004
+ cjswgs=cjswgn_hvt         mjswgs=0.5561             tpb=1.00e-03
+ tcj=8.34e-04              tpbsw=1.00e-03            tcjsw=3.57e-04
+ tpbswg=1.50e-03           tcjswg=7.67e-04           xtis=3
+ dmcg=9.25e-008            dmci=9.25e-008            dmdg=0
+ dmcgt=0                   dwj=0                     xgw=0
+ xgl=0                     rshg=0.1                  gbmin=1e-012
+ rbpb=50                   rbpd=50                   rbps=50
+ rbdb=50                   rbsb=50                   ngcon=1
+ saref=0.63e-6             sbref=0.63e-6             kvsat=0.1
+ wlod=0.8e-6               tku0=0.01                 ku0=-7.01e-8
+ llodku0=1                 wlodku0=1                 lku0=4.027e-7
+ wku0=8e-7                 pku0=-2.0e-13             kvth0=3.5e-9
+ stk2=1.65e-9              steta0=0                  lkvth0=-2.68e-11
+ wkvth0=1.5e-6             pkvth0=0                  llodvth=1
+ wlodvth=1                 lodk2=0.5                 lodeta0=1
+ fnoimod=1                 noia=3.75e+41             noib=6.25e+24
+ noic=8.75                 em=1.00e+08               ef=0.9
+ wpemod=wpeflag_hvt        kvth0we=0.00323           lkvth0we=0
+ wkvth0we=0                pkvth0we=0                ku0we=-0.0015
+ lku0we=6.00e-10           wku0we=0                  pku0we=0
+ k2we=0.0015               wk2we=0                   web=-210
+ wec=-3500                 scref=1.00e-06            ud=0
+ tnoimod=0                 minr=1e-3

     14: type=n
+ lmin=2.4000e-07-dxln_hvt  lmax=5.0000e-07-dxln_hvt  wmin=5.0000e-07-dxwn_hvt
+ wmax=1.0000e-06-dxwn_hvt  version=4.5               binunit=2
+ paramchk=1                mobmod=0                  capmod=2
+ igcmod=1                  igbmod=1                  geomod=0
+ diomod=1                  rdsmod=0                  rbodymod=0
+ rgatemod=0                permod=1                  acnqsmod=0
+ trnqsmod=0                tnom=25                   toxe=toxn_hvt
+ toxm=toxn_hvt             dtox=3.03e-010            epsrox=3.9
+ wint=6e-009               lint=2.5e-009             ll=0
+ wl=0                      lln=1                     wln=1
+ lw=0                      ww=0                      lwn=1
+ wwn=1                     lwl=0                     wwl=0
+ llc=0                     wlc=0                     lwc=0
+ wwc=0                     lwlc=0                    wwlc=0
+ dlc=1.124e-008            dwc=0                     xpart=1
+ toxref=3e-009             dlcig=2.5e-009            xl=-3.5e-08+dxln_hvt
+ xw=1.5e-8+dxwn_hvt        vth0=0.364128+dvthn_hvt   lvth0=1.7756e-009+dlvthn_hvt
+ wvth0=4.3465391e-009+dwvthn_hvt                     pvth0=-1.0711114e-015+dpvthn_hvt
+ k1=0.33                   k2=0.03428+dk2n_hvt       lk2=-2.576e-009
+ k3=-2.45                  k3b=1.2                   w0=-5.5e-008
+ dvt0=18.2                 dvt1=1.35                 dvt2=0.12
+ dvt0w=0                   dvt1w=0                   dvt2w=0
+ dsub=0.5                  minv=0                    voffl=0
+ dvtp0=7e-007              dvtp1=0                   lpe0=1.5e-008
+ lpeb=0                    xj=1.5e-007               ngate=4e020
+ ndep=8.3687e017           nsd=1e020                 phin=0
+ cdsc=0                    cdscb=0                   cdscd=0
+ lcdscd=0+dlcdscdn_hvt     cit=0.00045384615         lcit=1.5923077e-010+dlcitn_hvt
+ voff=-0.14270614          lvoff=-4.8965231e-010+dlvoffn_hvt
+ wvoff=-2.8485354e-009     pvoff=-9.6400027e-016+dpvoffn_hvt
+ nfactor=0.6569            eta0=0.13+deta0n_hvt      etab=-0.08
+ u0=0.031545371            lu0=1.3950738e-009        wu0=1.9427477e-009
+ pu0=-7.4977799e-016       ua=-4.2907692e-010        lua=1.4153846e-018
+ ub=1.3833951e-018         lub=-1.2679015e-026       wub=4.9985199e-026
+ pub=-9.9970399e-033       uc=1.1298462e-010         luc=3.5030769e-018
+ vsat=106800               a0=0.82013031             pvsat=0+dpvsatn_hvt
+ la0=2.1359074e-007        wa0=4.6965907e-007        pa0=-9.6757065e-014
+ ags=0.92579231            lags=-1.5038462e-008      a1=0
+ a2=1                      b0=0                      b1=0
+ keta=-0.029185385         lketa=5.9870769e-009      dwg=0
+ dwb=0                     pclm=1.01                 pdiblc1=0.1691
+ pdiblc2=-0.0034724236     lpdiblc2=1.2002847e-009   wpdiblc2=2.4126785e-009
+ ppdiblc2=-4.8253569e-016  pdiblcb=-0.1              drout=0.5
+ pvag=1.252                delta=0.0075              pscbe1=9.264e008
+ pscbe2=1e-020             fprout=0                  pdits=0
+ pditsd=0                  pditsl=0                  rsh=10.5
+ rdsw=150                  prwg=0                    prwb=0
+ wr=1                      alpha0=0                  alpha1=0.03
+ beta0=8.7                 agidl=2.593e-009          bgidl=1.698e009
+ cgidl=0.25                egidl=0.2624              aigbacc=0.01238
+ bigbacc=0.006109          cigbacc=0.2809            nigbacc=4.05
+ aigbinv=0.35              bigbinv=0.03              cigbinv=0.006
+ eigbinv=1.1               nigbinv=1                 aigc=0.009898
+ bigc=0.001383             cigc=1.515e-005           aigsd=0.0086
+ bigsd=0.0004353           cigsd=3.925e-020          nigc=1
+ poxedge=1                 pigcd=1.672               ntox=ntoxn_hvt
+ xrcrg1=12                 xrcrg2=1                  cgso=cgon_hvt
+ cgdo=cgon_hvt             cgbo=0                    cgdl=cgln_hvt
+ cgsl=cgln_hvt             clc=1e-007                cle=0.6
+ cf=cfn_hvt                ckappas=0.6               acde=1.2
+ moin=12.6                 noff=1.686                voffcv=-0.05472
+ kt1=-0.24077692           lkt1=-2.2646154e-009      kt1l=0
+ kt2=-0.049101538          lkt2=2.0523077e-009       ute=-0.8
+ ua1=3.778156e-009         lua1=-3.8226e-017         wua1=-1.8146801e-016
+ pua1=1.7851857e-024       ub1=-2.70134e-018         lub1=-6.01036e-026
+ wub1=-1.1099198e-025      pub1=5.1056311e-032       uc1=2.8666129e-010
+ luc1=-4.8752258e-017      wuc1=-1.9283576e-016      puc1=3.8567152e-023
+ prt=0                     at=110430.62              lat=-0.0093980831
+ wat=0.0052003235          pat=-2.3921488e-009       jss=2.00e-07
+ jsws=6.71e-13             jswgs=5.40e-11            njs=1
+ ijthsfwd=0.01             ijthsrev=0.01             bvs=10
+ xjbvs=1                   pbs=0.496                 cjs=cjn_hvt
+ mjs=0.336                 pbsws=0.8                 cjsws=cjswn_hvt
+ mjsws=0.01                pbswgs=1.0004             cjswgs=cjswgn_hvt
+ mjswgs=0.5561             tpb=1.00e-03              tcj=8.34e-04
+ tpbsw=1.00e-03            tcjsw=3.57e-04            tpbswg=1.50e-03
+ tcjswg=7.67e-04           xtis=3                    dmcg=9.25e-008
+ dmci=9.25e-008            dmdg=0                    dmcgt=0
+ dwj=0                     xgw=0                     xgl=0
+ rshg=0.1                  gbmin=1e-012              rbpb=50
+ rbpd=50                   rbps=50                   rbdb=50
+ rbsb=50                   ngcon=1                   saref=0.63e-6
+ sbref=0.63e-6             kvsat=0.1                 wlod=0.8e-6
+ tku0=0.01                 ku0=-7.01e-8              llodku0=1
+ wlodku0=1                 lku0=4.027e-7             wku0=8e-7
+ pku0=-2.0e-13             kvth0=3.5e-9              stk2=1.65e-9
+ steta0=0                  lkvth0=-2.68e-11          wkvth0=1.5e-6
+ pkvth0=0                  llodvth=1                 wlodvth=1
+ lodk2=0.5                 lodeta0=1                 fnoimod=1
+ noia=3.75e+41             noib=6.25e+24             noic=8.75
+ em=1.00e+08               ef=0.9                    wpemod=wpeflag_hvt
+ kvth0we=0.00323           lkvth0we=0                wkvth0we=0
+ pkvth0we=0                ku0we=-0.0015             lku0we=6.00e-10
+ wku0we=0                  pku0we=0                  k2we=0.0015
+ wk2we=0                   web=-210                  wec=-3500
+ scref=1.00e-06            ud=0                      tnoimod=0
+ minr=1e-3

     15: type=n
+ lmin=1.0e-07              lmax=2.4000e-07-dxln_hvt  wmin=5.0000e-07-dxwn_hvt
+ wmax=1.0000e-06-dxwn_hvt  version=4.5               binunit=2
+ paramchk=1                mobmod=0                  capmod=2
+ igcmod=1                  igbmod=1                  geomod=0
+ diomod=1                  rdsmod=0                  rbodymod=0
+ rgatemod=0                permod=1                  acnqsmod=0
+ trnqsmod=0                tnom=25                   toxe=toxn_hvt
+ toxm=toxn_hvt             dtox=3.03e-010            epsrox=3.9
+ wint=6e-009               lint=2.5e-009             ll=0
+ wl=0                      lln=1                     wln=1
+ lw=0                      ww=0                      lwn=1
+ wwn=1                     lwl=0                     wwl=0
+ llc=0                     wlc=0                     lwc=0
+ wwc=0                     lwlc=0                    wwlc=0
+ dlc=1.124e-008            dwc=0                     xpart=1
+ toxref=3e-009             dlcig=2.5e-009            xl=-3.5e-08+dxln_hvt
+ xw=1.5e-8+dxwn_hvt        vth0=0.36913857+dvthn_hvt lvth0=7.7348571e-010+dlvthn_hvt
+ wvth0=7.2072714e-010+dwvthn_hvt                     pvth0=-3.4594903e-016+dpvthn_hvt
+ k1=0.33                   k2=0.026462157+dk2n_hvt   lk2=-1.0124314e-009
+ wk2=-8.4325076e-010       pk2=1.6865015e-016        k3=-2.45
+ k3b=1.2                   w0=-5.5e-008              dvt0=18.2
+ dvt1=1.35                 dvt2=0.12                 dvt0w=0
+ dvt1w=0                   dvt2w=0                   dsub=0.5
+ minv=0                    voffl=0                   dvtp0=7e-007
+ dvtp1=0                   lpe0=1.5e-008             lpeb=0
+ xj=1.5e-007               ngate=4e020               ndep=8.3687e017
+ nsd=1e020                 phin=0                    cdsc=0
+ cdscb=0                   cdscd=0                   lcdscd=0+dlcdscdn_hvt
+ cit=-0.000206176          lcit=2.912352e-010+dlcitn_hvt
+ wcit=5.3622099e-011       pcit=-1.072442e-017       voff=-0.13407951
+ lvoff=-2.2149771e-009+dlvoffn_hvt                   wvoff=-1.0652347e-008
+ pvoff=5.9676207e-016+dpvoffn_hvt                    nfactor=0.6569
+ eta0=0.11412829+deta0n_hvt                          leta0=3.1743429e-009
+ weta0=1.6865015e-008      peta0=-3.373003e-015      etab=-0.08
+ u0=0.03749234             lu0=2.0568e-010           wu0=-1.1142442e-009
+ pu0=-1.3837961e-016       ua=-4.2457143e-010        lua=5.1428571e-019
+ ub=1.2564274e-018         lub=1.2714514e-026        wub=2.4216432e-026
+ pub=-4.8432864e-033       uc=1.3624994e-010         luc=-1.1499874e-018
+ wuc=1.106172e-017         puc=-2.212344e-024        vsat=105256.63
+ lvsat=0.00030867429       wvsat=8.6487257e-005      pvsat=-1.7297451e-011+dpvsatn_hvt
+ a0=1.7559169              la0=2.6433429e-008        wa0=2.3020025e-007
+ pa0=-4.88653e-014         ags=0.8506                a1=0
+ a2=1                      b0=0                      b1=0
+ keta=-0.013260823         lketa=2.8021646e-009      wketa=-1.2834709e-008
+ pketa=2.5669418e-015      dwg=0                     dwb=0
+ pclm=1.01                 pdiblc1=0.1691            pdiblc2=0.0022795714
+ lpdiblc2=4.9885714e-011   pdiblcb=-0.1              drout=0.5
+ pvag=1.252                delta=0.0075              pscbe1=9.264e008
+ pscbe2=1e-020             fprout=0                  pdits=0
+ pditsd=0                  pditsl=0                  rsh=10.5
+ rdsw=150                  prwg=0                    prwb=0
+ wr=1                      alpha0=0                  alpha1=0.03
+ beta0=8.7                 agidl=2.593e-009          bgidl=1.698e009
+ cgidl=0.25                egidl=0.2624              aigbacc=0.01238
+ bigbacc=0.006109          cigbacc=0.2809            nigbacc=4.05
+ aigbinv=0.35              bigbinv=0.03              cigbinv=0.006
+ eigbinv=1.1               nigbinv=1                 aigc=0.009898
+ bigc=0.001383             cigc=1.515e-005           aigsd=0.0086
+ bigsd=0.0004353           cigsd=3.925e-020          nigc=1
+ poxedge=1                 pigcd=1.672               ntox=ntoxn_hvt
+ xrcrg1=12                 xrcrg2=1                  cgso=cgon_hvt
+ cgdo=cgon_hvt             cgbo=0                    cgdl=cgln_hvt
+ cgsl=cgln_hvt             clc=1e-007                cle=0.6
+ cf=cfn_hvt                ckappas=0.6               acde=1.2
+ moin=12.6                 noff=1.686                voffcv=-0.05472
+ kt1=-0.2530912            lkt1=1.9824e-010          wkt1=8.1298022e-009
+ pkt1=-1.6259604e-015      kt1l=0                    kt2=-0.041917143
+ lkt2=6.1542857e-010       ute=-0.8                  ua1=4.4287514e-009
+ lua1=-1.6834509e-016      wua1=-2.4648868e-016      pua1=1.4789321e-023
+ ub1=-4.0058971e-018       lub1=2.0080783e-025       wub1=2.0612796e-025
+ pub1=-1.2367678e-032      uc1=-3.6428571e-012       luc1=9.3085714e-018
+ prt=0                     at=64213.943              lat=-0.00015474857
+ wat=-0.0071496133         pat=7.7838531e-011        jss=2.00e-07
+ jsws=6.71e-13             jswgs=5.40e-11            njs=1
+ ijthsfwd=0.01             ijthsrev=0.01             bvs=10
+ xjbvs=1                   pbs=0.496                 cjs=cjn_hvt
+ mjs=0.336                 pbsws=0.8                 cjsws=cjswn_hvt
+ mjsws=0.01                pbswgs=1.0004             cjswgs=cjswgn_hvt
+ mjswgs=0.5561             tpb=1.00e-03              tcj=8.34e-04
+ tpbsw=1.00e-03            tcjsw=3.57e-04            tpbswg=1.50e-03
+ tcjswg=7.67e-04           xtis=3                    dmcg=9.25e-008
+ dmci=9.25e-008            dmdg=0                    dmcgt=0
+ dwj=0                     xgw=0                     xgl=0
+ rshg=0.1                  gbmin=1e-012              rbpb=50
+ rbpd=50                   rbps=50                   rbdb=50
+ rbsb=50                   ngcon=1                   saref=0.63e-6
+ sbref=0.63e-6             kvsat=0.1                 wlod=0.8e-6
+ tku0=0.01                 ku0=-7.01e-8              llodku0=1
+ wlodku0=1                 lku0=4.027e-7             wku0=8e-7
+ pku0=-2.0e-13             kvth0=3.5e-9              stk2=1.65e-9
+ steta0=0                  lkvth0=-2.68e-11          wkvth0=1.5e-6
+ pkvth0=0                  llodvth=1                 wlodvth=1
+ lodk2=0.5                 lodeta0=1                 fnoimod=1
+ noia=3.75e+41             noib=6.25e+24             noic=8.75
+ em=1.00e+08               ef=0.9                    wpemod=wpeflag_hvt
+ kvth0we=0.00323           lkvth0we=0                wkvth0we=0
+ pkvth0we=0                ku0we=-0.0015             lku0we=6.00e-10
+ wku0we=0                  pku0we=0                  k2we=0.0015
+ wk2we=0                   web=-210                  wec=-3500
+ scref=1.00e-06            ud=0                      tnoimod=0
+ minr=1e-3

     16: type=n
+ lmin=1.0000e-05-dxln_hvt  lmax=2.001e-05            wmin=2.4000e-07-dxwn_hvt
+ wmax=5.0000e-07-dxwn_hvt  version=4.5               binunit=2
+ paramchk=1                mobmod=0                  capmod=2
+ igcmod=1                  igbmod=1                  geomod=0
+ diomod=1                  rdsmod=0                  rbodymod=0
+ rgatemod=0                permod=1                  acnqsmod=0
+ trnqsmod=0                tnom=25                   toxe=toxn_hvt
+ toxm=toxn_hvt             dtox=3.03e-010            epsrox=3.9
+ wint=6e-009               lint=2.5e-009             ll=0
+ wl=0                      lln=1                     wln=1
+ lw=0                      ww=0                      lwn=1
+ wwn=1                     lwl=0                     wwl=0
+ llc=0                     wlc=0                     lwc=0
+ wwc=0                     lwlc=0                    wwlc=0
+ dlc=1.124e-008            dwc=0                     xpart=1
+ toxref=3e-009             dlcig=2.5e-009            xl=-3.5e-08+dxln_hvt
+ xw=1.5e-8+dxwn_hvt        vth0=0.36673846+dvthn_hvt wvth0=-1.8804462e-009+dwvthn_hvt
+ lvth0=0+dlvthn_hvt        pvth0=0+dpvthn_hvt        k1=0.33
+ k2=0.0313495+dk2n_hvt     wk2=4.278015e-010         k3=-2.45
+ k3b=1.2                   w0=-5.5e-008              dvt0=18.2
+ dvt1=1.35                 dvt2=0.12                 dvt0w=0
+ dvt1w=0                   dvt2w=0                   dsub=0.5
+ minv=0                    voffl=0                   dvtp0=7e-007
+ dvtp1=0                   lpe0=1.5e-008             lpeb=0
+ xj=1.5e-007               ngate=4e020               ndep=8.3687e017
+ nsd=1e020                 phin=0                    cdsc=0
+ cdscb=0                   cdscd=0                   lcdscd=0+dlcdscdn_hvt
+ cit=0                     voff=-0.136975            wvoff=3.055725e-009
+ lvoff=0+dlvoffn_hvt       lcit=0+dlcitn_hvt         pvoff=0+dpvoffn_hvt
+ nfactor=0.6569            eta0=0.13+deta0n_hvt      etab=-0.08
+ u0=0.033495577            wu0=-8.2269519e-010       ua=-4.28e-010
+ ub=1.414e-018             uc=1.4181769e-010         wuc=8.4620077e-019
+ vsat=106800               a0=2.33                   ags=0.8506
+ pvsat=0+dpvsatn_hvt       a1=0                      a2=1
+ b0=0                      b1=0                      keta=0.0039916423
+ wketa=6.4452292e-010      dwg=0                     dwb=0
+ pclm=1.01                 pdiblc1=0.1691            pdiblc2=0.0001103
+ pdiblcb=-0.1              drout=0.5                 pvag=1.252
+ delta=0.0075              pscbe1=9.264e008          pscbe2=1e-020
+ fprout=0                  pdits=0                   pditsd=0
+ pditsl=0                  rsh=10.5                  rdsw=150
+ prwg=0                    prwb=0                    wr=1
+ alpha0=0                  alpha1=0.03               beta0=8.7
+ agidl=2.593e-009          bgidl=1.698e009           cgidl=0.25
+ egidl=0.2624              aigbacc=0.01238           bigbacc=0.006109
+ cigbacc=0.2809            nigbacc=4.05              aigbinv=0.35
+ bigbinv=0.03              cigbinv=0.006             eigbinv=1.1
+ nigbinv=1                 aigc=0.009898             bigc=0.001383
+ cigc=1.515e-005           aigsd=0.0086              bigsd=0.0004353
+ cigsd=3.925e-020          nigc=1                    poxedge=1
+ pigcd=1.672               ntox=ntoxn_hvt            xrcrg1=12
+ xrcrg2=1                  cgso=cgon_hvt             cgdo=cgon_hvt
+ cgbo=0                    cgdl=cgln_hvt             cgsl=cgln_hvt
+ clc=1e-007                cle=0.6                   cf=cfn_hvt
+ ckappas=0.6               acde=1.2                  moin=12.6
+ noff=1.686                voffcv=-0.05472           kt1=-0.19496154
+ wkt1=-1.8804462e-009      kt1l=0                    kt2=-0.0522
+ ute=-0.75                 ua1=3.72e-009             ub1=-2.6298808e-018
+ wub1=-9.2611973e-026      uc1=2.4e-010              prt=0
+ at=90000                  jss=2.00e-07              jsws=6.71e-13
+ jswgs=5.40e-11            njs=1                     ijthsfwd=0.01
+ ijthsrev=0.01             bvs=10                    xjbvs=1
+ pbs=0.496                 cjs=cjn_hvt               mjs=0.336
+ pbsws=0.8                 cjsws=cjswn_hvt           mjsws=0.01
+ pbswgs=1.0004             cjswgs=cjswgn_hvt         mjswgs=0.5561
+ tpb=1.00e-03              tcj=8.34e-04              tpbsw=1.00e-03
+ tcjsw=3.57e-04            tpbswg=1.50e-03           tcjswg=7.67e-04
+ xtis=3                    dmcg=9.25e-008            dmci=9.25e-008
+ dmdg=0                    dmcgt=0                   dwj=0
+ xgw=0                     xgl=0                     rshg=0.1
+ gbmin=1e-012              rbpb=50                   rbpd=50
+ rbps=50                   rbdb=50                   rbsb=50
+ ngcon=1                   saref=0.63e-6             sbref=0.63e-6
+ kvsat=0.1                 wlod=0.8e-6               tku0=0.01
+ ku0=-7.01e-8              llodku0=1                 wlodku0=1
+ lku0=4.027e-7             wku0=8e-7                 pku0=-2.0e-13
+ kvth0=3.5e-9              stk2=1.65e-9              steta0=0
+ lkvth0=-2.68e-11          wkvth0=1.5e-6             pkvth0=0
+ llodvth=1                 wlodvth=1                 lodk2=0.5
+ lodeta0=1                 fnoimod=1                 noia=3.75e+41
+ noib=6.25e+24             noic=8.75                 em=1.00e+08
+ ef=0.9                    wpemod=wpeflag_hvt        kvth0we=0.00323
+ lkvth0we=0                wkvth0we=0                pkvth0we=0
+ ku0we=-0.0015             lku0we=6.00e-10           wku0we=0
+ pku0we=0                  k2we=0.0015               wk2we=0
+ web=-210                  wec=-3500                 scref=1.00e-06
+ ud=0                      tnoimod=0                 minr=1e-3

     17: type=n
+ lmin=1.2000e-06-dxln_hvt  lmax=1.0000e-05-dxln_hvt  wmin=2.4000e-07-dxwn_hvt
+ wmax=5.0000e-07-dxwn_hvt  version=4.5               binunit=2
+ paramchk=1                mobmod=0                  capmod=2
+ igcmod=1                  igbmod=1                  geomod=0
+ diomod=1                  rdsmod=0                  rbodymod=0
+ rgatemod=0                permod=1                  acnqsmod=0
+ trnqsmod=0                tnom=25                   toxe=toxn_hvt
+ toxm=toxn_hvt             dtox=3.03e-010            epsrox=3.9
+ wint=6e-009               lint=2.5e-009             ll=0
+ wl=0                      lln=1                     wln=1
+ lw=0                      ww=0                      lwn=1
+ wwn=1                     lwl=0                     wwl=0
+ llc=0                     wlc=0                     lwc=0
+ wwc=0                     lwlc=0                    wwlc=0
+ dlc=1.124e-008            dwc=0                     xpart=1
+ toxref=3e-009             dlcig=2.5e-009            xl=-3.5e-08+dxln_hvt
+ xw=1.5e-8+dxwn_hvt        vth0=0.36533156+dvthn_hvt lvth0=1.401278e-008+dlvthn_hvt
+ wvth0=-1.5705999e-009+dwvthn_hvt                    pvth0=-3.0860686e-015+dpvthn_hvt
+ k1=0.33                   k2=0.030838051+dk2n_hvt   lk2=5.0940368e-009
+ wk2=6.837345e-010         pk2=-2.5490926e-015       k3=-2.45
+ k3b=1.2                   w0=-5.5e-008              dvt0=18.2
+ dvt1=1.35                 dvt2=0.12                 dvt0w=0
+ dvt1w=0                   dvt2w=0                   dsub=0.5
+ minv=0                    voffl=0                   dvtp0=7e-007
+ dvtp1=0                   lpe0=1.5e-008             lpeb=0
+ xj=1.5e-007               ngate=4e020               ndep=8.3687e017
+ nsd=1e020                 phin=0                    cdsc=0
+ cdscb=0                   cdscd=0                   lcdscd=0+dlcdscdn_hvt
+ cit=-3.0318182e-005       lcit=3.0196909e-010+dlcitn_hvt
+ voff=-0.13465069          lvoff=-2.3150122e-008+dlvoffn_hvt
+ wvoff=3.0867096e-009      pvoff=-3.0860686e-016+dpvoffn_hvt
+ nfactor=0.6569            eta0=0.13+deta0n_hvt      etab=-0.08
+ u0=0.03324969             lu0=2.4490299e-009        wu0=-7.8985149e-010
+ pu0=-3.2712327e-016       ua=-4.28e-010             ub=1.414e-018
+ uc=1.4461457e-010         luc=-2.7856901e-017       wuc=9.5774542e-019
+ puc=-1.1109847e-024       vsat=106806.59            lvsat=-6.5645455e-005
+ pvsat=0+dpvsatn_hvt       a0=2.3752136              la0=-4.5032782e-007
+ ags=0.841465              lags=9.09846e-008         a1=0
+ a2=1                      b0=0                      b1=0
+ keta=0.0064634497         lketa=-2.4619202e-008     wketa=7.2948276e-010
+ pketa=-8.462e-016         dwg=0                     dwb=0
+ pclm=1.01                 pdiblc1=0.1691            pdiblc2=0.00011420131
+ lpdiblc2=-3.8857059e-011  wpdiblc2=-7.5540514e-011  ppdiblc2=7.5238352e-016
+ pdiblcb=-0.1              drout=0.5                 pvag=1.252
+ delta=0.0075              pscbe1=9.264e008          pscbe2=1e-020
+ fprout=0                  pdits=0                   pditsd=0
+ pditsl=0                  rsh=10.5                  rdsw=150
+ prwg=0                    prwb=0                    wr=1
+ alpha0=0                  alpha1=0.03               beta0=8.7
+ agidl=2.593e-009          bgidl=1.698e009           cgidl=0.25
+ egidl=0.2624              aigbacc=0.01238           bigbacc=0.006109
+ cigbacc=0.2809            nigbacc=4.05              aigbinv=0.35
+ bigbinv=0.03              cigbinv=0.006             eigbinv=1.1
+ nigbinv=1                 aigc=0.009898             bigc=0.001383
+ cigc=1.515e-005           aigsd=0.0086              bigsd=0.0004353
+ cigsd=3.925e-020          nigc=1                    poxedge=1
+ pigcd=1.672               ntox=ntoxn_hvt            xrcrg1=12
+ xrcrg2=1                  cgso=cgon_hvt             cgdo=cgon_hvt
+ cgbo=0                    cgdl=cgln_hvt             cgsl=cgln_hvt
+ clc=1e-007                cle=0.6                   cf=cfn_hvt
+ ckappas=0.6               acde=1.2                  moin=12.6
+ noff=1.686                voffcv=-0.05472           kt1=-0.19056743
+ lkt1=-4.376532e-008       wkt1=-1.9424154e-009      pkt1=6.1721371e-016
+ kt1l=0                    kt2=-0.053001455          lkt2=7.9824873e-009
+ ute=-0.74340909           lute=-6.5645455e-008      ua1=3.752554e-009
+ lua1=-3.2423805e-016      wua1=1.8590774e-018       pua1=-1.8516411e-023
+ ub1=-2.6115525e-018       lub1=-1.8254991e-025      wub1=-1.0110176e-025
+ pub1=8.4558279e-032       uc1=2.6161686e-010        luc1=-2.1530396e-016
+ prt=0                     at=90000                  jss=2.00e-07
+ jsws=6.71e-13             jswgs=5.40e-11            njs=1
+ ijthsfwd=0.01             ijthsrev=0.01             bvs=10
+ xjbvs=1                   pbs=0.496                 cjs=cjn_hvt
+ mjs=0.336                 pbsws=0.8                 cjsws=cjswn_hvt
+ mjsws=0.01                pbswgs=1.0004             cjswgs=cjswgn_hvt
+ mjswgs=0.5561             tpb=1.00e-03              tcj=8.34e-04
+ tpbsw=1.00e-03            tcjsw=3.57e-04            tpbswg=1.50e-03
+ tcjswg=7.67e-04           xtis=3                    dmcg=9.25e-008
+ dmci=9.25e-008            dmdg=0                    dmcgt=0
+ dwj=0                     xgw=0                     xgl=0
+ rshg=0.1                  gbmin=1e-012              rbpb=50
+ rbpd=50                   rbps=50                   rbdb=50
+ rbsb=50                   ngcon=1                   saref=0.63e-6
+ sbref=0.63e-6             kvsat=0.1                 wlod=0.8e-6
+ tku0=0.01                 ku0=-7.01e-8              llodku0=1
+ wlodku0=1                 lku0=4.027e-7             wku0=8e-7
+ pku0=-2.0e-13             kvth0=3.5e-9              stk2=1.65e-9
+ steta0=0                  lkvth0=-2.68e-11          wkvth0=1.5e-6
+ pkvth0=0                  llodvth=1                 wlodvth=1
+ lodk2=0.5                 lodeta0=1                 fnoimod=1
+ noia=3.75e+41             noib=6.25e+24             noic=8.75
+ em=1.00e+08               ef=0.9                    wpemod=wpeflag_hvt
+ kvth0we=0.00323           lkvth0we=0                wkvth0we=0
+ pkvth0we=0                ku0we=-0.0015             lku0we=6.00e-10
+ wku0we=0                  pku0we=0                  k2we=0.0015
+ wk2we=0                   web=-210                  wec=-3500
+ scref=1.00e-06            ud=0                      tnoimod=0
+ minr=1e-3

     18: type=n
+ lmin=5.0000e-07-dxln_hvt  lmax=1.2000e-06-dxln_hvt  wmin=2.4000e-07-dxwn_hvt
+ wmax=5.0000e-07-dxwn_hvt  version=4.5               binunit=2
+ paramchk=1                mobmod=0                  capmod=2
+ igcmod=1                  igbmod=1                  geomod=0
+ diomod=1                  rdsmod=0                  rbodymod=0
+ rgatemod=0                permod=1                  acnqsmod=0
+ trnqsmod=0                tnom=25                   toxe=toxn_hvt
+ toxm=toxn_hvt             dtox=3.03e-010            epsrox=3.9
+ wint=6e-009               lint=2.5e-009             ll=0
+ wl=0                      lln=1                     wln=1
+ lw=0                      ww=0                      lwn=1
+ wwn=1                     lwl=0                     wwl=0
+ llc=0                     wlc=0                     lwc=0
+ wwc=0                     lwlc=0                    wwlc=0
+ dlc=1.124e-008            dwc=0                     xpart=1
+ toxref=3e-009             dlcig=2.5e-009            xl=-3.5e-08+dxln_hvt
+ xw=1.5e-8+dxwn_hvt        vth0=0.37114088+dvthn_hvt lvth0=7.2739648e-009+dlvthn_hvt
+ wvth0=-2.0684908e-009+dwvthn_hvt                    pvth0=-2.5085152e-015+dpvthn_hvt
+ k1=0.33                   k2=0.040344105+dk2n_hvt   lk2=-5.932987e-009
+ wk2=-2.9163033e-009       pk2=1.6269513e-015        k3=-2.45
+ k3b=1.2                   w0=-5.5e-008              dvt0=18.2
+ dvt1=1.35                 dvt2=0.12                 dvt0w=0
+ dvt1w=0                   dvt2w=0                   dsub=0.5
+ minv=0                    voffl=0                   dvtp0=7e-007
+ dvtp1=0                   lpe0=1.5e-008             lpeb=0
+ xj=1.5e-007               ngate=4e020               ndep=8.3687e017
+ nsd=1e020                 phin=0                    cdsc=0
+ cdscb=0                   cdscd=0                   lcdscd=0+dlcdscdn_hvt
+ cit=-0.00014457143        lcit=4.3450286e-010+dlcitn_hvt
+ voff=-0.14310921          lvoff=-1.3338241e-008+dlvoffn_hvt
+ wvoff=-1.4425708e-009     pvoff=4.9453585e-015+dpvoffn_hvt
+ nfactor=0.6569            eta0=0.13+deta0n_hvt      etab=-0.08
+ u0=0.032776582            lu0=2.9978352e-009        wu0=-4.2310038e-010
+ pu0=-7.5255455e-016       ua=-4.2931429e-010        lua=1.5245714e-018
+ ub=1.3631093e-018         lub=5.9033165e-026        wub=2.6259087e-026
+ pub=-3.0460541e-032       uc=1.206e-010             vsat=106717.14
+ pvsat=0+dpvsatn_hvt       lvsat=3.8114286e-005      a0=1.8961525
+ la0=1.0538307e-007        wa0=1.0750779e-007        pa0=-1.2470904e-013
+ ags=0.93751143            lags=-2.0429257e-008      a1=0
+ a2=1                      b0=0                      b1=0
+ keta=-0.013833429         lketa=-1.0748229e-009     dwg=0
+ dwb=0                     pclm=1.01                 pdiblc1=0.1691
+ pdiblc2=-0.001839415      lpdiblc2=2.2273379e-009   wpdiblc2=1.3313048e-009
+ ppdiblc2=-8.7955709e-016  pdiblcb=-0.1              drout=0.5
+ pvag=1.252                delta=0.0075              pscbe1=9.264e008
+ pscbe2=1e-020             fprout=0                  pdits=0
+ pditsd=0                  pditsl=0                  rsh=10.5
+ rdsw=150                  prwg=0                    prwb=0
+ wr=1                      alpha0=0                  alpha1=0.03
+ beta0=8.7                 agidl=2.593e-009          bgidl=1.698e009
+ cgidl=0.25                egidl=0.2624              aigbacc=0.01238
+ bigbacc=0.006109          cigbacc=0.2809            nigbacc=4.05
+ aigbinv=0.35              bigbinv=0.03              cigbinv=0.006
+ eigbinv=1.1               nigbinv=1                 aigc=0.009898
+ bigc=0.001383             cigc=1.515e-005           aigsd=0.0086
+ bigsd=0.0004353           cigsd=3.925e-020          nigc=1
+ poxedge=1                 pigcd=1.672               ntox=ntoxn_hvt
+ xrcrg1=12                 xrcrg2=1                  cgso=cgon_hvt
+ cgdo=cgon_hvt             cgbo=0                    cgdl=cgln_hvt
+ cgsl=cgln_hvt             clc=1e-007                cle=0.6
+ cf=cfn_hvt                ckappas=0.6               acde=1.2
+ moin=12.6                 noff=1.686                voffcv=-0.05472
+ kt1=-0.2198688            lkt1=-9.7757279e-009      wkt1=-8.2336678e-010
+ pkt1=-6.8088269e-016      kt1l=0                    kt2=-0.047092571
+ lkt2=1.1281829e-009       ute=-0.8                  ua1=3.5179997e-009
+ lua1=-5.2155002e-017      wua1=-2.6729199e-018      pua1=-1.3259294e-023
+ ub1=-2.7274725e-018       lub1=-4.8082637e-026      wub1=-4.6742519e-026
+ pub1=2.1501559e-032       uc1=1.4962314e-010        luc1=-8.5391246e-017
+ prt=0                     at=90000                  jss=2.00e-07
+ jsws=6.71e-13             jswgs=5.40e-11            njs=1
+ ijthsfwd=0.01             ijthsrev=0.01             bvs=10
+ xjbvs=1                   pbs=0.496                 cjs=cjn_hvt
+ mjs=0.336                 pbsws=0.8                 cjsws=cjswn_hvt
+ mjsws=0.01                pbswgs=1.0004             cjswgs=cjswgn_hvt
+ mjswgs=0.5561             tpb=1.00e-03              tcj=8.34e-04
+ tpbsw=1.00e-03            tcjsw=3.57e-04            tpbswg=1.50e-03
+ tcjswg=7.67e-04           xtis=3                    dmcg=9.25e-008
+ dmci=9.25e-008            dmdg=0                    dmcgt=0
+ dwj=0                     xgw=0                     xgl=0
+ rshg=0.1                  gbmin=1e-012              rbpb=50
+ rbpd=50                   rbps=50                   rbdb=50
+ rbsb=50                   ngcon=1                   saref=0.63e-6
+ sbref=0.63e-6             kvsat=0.1                 wlod=0.8e-6
+ tku0=0.01                 ku0=-7.01e-8              llodku0=1
+ wlodku0=1                 lku0=4.027e-7             wku0=8e-7
+ pku0=-2.0e-13             kvth0=3.5e-9              stk2=1.65e-9
+ steta0=0                  lkvth0=-2.68e-11          wkvth0=1.5e-6
+ pkvth0=0                  llodvth=1                 wlodvth=1
+ lodk2=0.5                 lodeta0=1                 fnoimod=1
+ noia=3.75e+41             noib=6.25e+24             noic=8.75
+ em=1.00e+08               ef=0.9                    wpemod=wpeflag_hvt
+ kvth0we=0.00323           lkvth0we=0                wkvth0we=0
+ pkvth0we=0                ku0we=-0.0015             lku0we=6.00e-10
+ wku0we=0                  pku0we=0                  k2we=0.0015
+ wk2we=0                   web=-210                  wec=-3500
+ scref=1.00e-06            ud=0                      tnoimod=0
+ minr=1e-3

     19: type=n
+ lmin=2.4000e-07-dxln_hvt  lmax=5.0000e-07-dxln_hvt  wmin=2.4000e-07-dxwn_hvt
+ wmax=5.0000e-07-dxwn_hvt  version=4.5               binunit=2
+ paramchk=1                mobmod=0                  capmod=2
+ igcmod=1                  igbmod=1                  geomod=0
+ diomod=1                  rdsmod=0                  rbodymod=0
+ rgatemod=0                permod=1                  acnqsmod=0
+ trnqsmod=0                tnom=25                   toxe=toxn_hvt
+ toxm=toxn_hvt             dtox=3.03e-010            epsrox=3.9
+ wint=6e-009               lint=2.5e-009             ll=0
+ wl=0                      lln=1                     wln=1
+ lw=0                      ww=0                      lwn=1
+ wwn=1                     lwl=0                     wwl=0
+ llc=0                     wlc=0                     lwc=0
+ wwc=0                     lwlc=0                    wwlc=0
+ dlc=1.124e-008            dwc=0                     xpart=1
+ toxref=3e-009             dlcig=2.5e-009            xl=-3.5e-08+dxln_hvt
+ xw=1.5e-8+dxwn_hvt        vth0=0.3841284+dvthn_hvt  lvth0=1.2997041e-009+dlvthn_hvt
+ wvth0=-5.7136633e-009+dwvthn_hvt                    pvth0=-8.317358e-016+dpvthn_hvt
+ k1=0.33                   k2=0.033966544+dk2n_hvt   lk2=-2.9993089e-009
+ wk2=1.5766818e-010        pk2=2.1292436e-016        k3=-2.45
+ k3b=1.2                   w0=-5.5e-008              dvt0=18.2
+ dvt1=1.35                 dvt2=0.12                 dvt0w=0
+ dvt1w=0                   dvt2w=0                   dsub=0.5
+ minv=0                    voffl=0                   dvtp0=7e-007
+ dvtp1=0                   lpe0=1.5e-008             lpeb=0
+ xj=1.5e-007               ngate=4e020               ndep=8.3687e017
+ nsd=1e020                 phin=0                    cdsc=0
+ cdscb=0                   cdscd=0                   lcdscd=0+dlcdscdn_hvt
+ cit=0.00045384615         lcit=1.5923077e-010+dlcitn_hvt
+ voff=-0.16457402          lvoff=-3.464426e-009+dlvoffn_hvt
+ wvoff=8.1510108e-009      pvoff=5.3231091e-016+dpvoffn_hvt
+ nfactor=0.6569            eta0=0.13+deta0n_hvt      etab=-0.08
+ u0=0.039321574            lu0=-1.2860947e-011       wu0=-1.9686825e-009
+ pu0=-4.158679e-017        ua=-4.2907692e-010        lua=1.4153846e-018
+ ub=1.6434512e-018         lub=-6.9924083e-026       wub=-8.0823022e-026
+ pub=1.8797229e-032        uc=8.9396361e-011         luc=1.4353674e-017
+ wuc=1.1864892e-017        puc=-5.4578503e-024       vsat=106800
+ pvsat=0+dpvsatn_hvt       a0=2.0244533              la0=4.6364734e-008
+ wa0=-1.3611537e-007       pa0=-1.2642384e-014       ags=0.92579231
+ lags=-1.5038462e-008      a1=0                      a2=1
+ b0=0                      b1=0                      keta=-0.029185385
+ lketa=5.9870769e-009      dwg=0                     dwb=0
+ pclm=1.01                 pdiblc1=0.1691            pdiblc2=0.003476228
+ lpdiblc2=-2.1785791e-010  wpdiblc2=-1.0824933e-009  ppdiblc2=2.3079005e-016
+ pdiblcb=-0.1              drout=0.5                 pvag=1.252
+ delta=0.0075              pscbe1=9.264e008          pscbe2=1e-020
+ fprout=0                  pdits=0                   pditsd=0
+ pditsl=0                  rsh=10.5                  rdsw=150
+ prwg=0                    prwb=0                    wr=1
+ alpha0=0                  alpha1=0.03               beta0=8.7
+ agidl=2.593e-009          bgidl=1.698e009           cgidl=0.25
+ egidl=0.2624              aigbacc=0.01238           bigbacc=0.006109
+ cigbacc=0.2809            nigbacc=4.05              aigbinv=0.35
+ bigbinv=0.03              cigbinv=0.006             eigbinv=1.1
+ nigbinv=1                 aigc=0.009898             bigc=0.001383
+ cigc=1.515e-005           aigsd=0.0086              bigsd=0.0004353
+ cigsd=3.925e-020          nigc=1                    poxedge=1
+ pigcd=1.672               ntox=ntoxn_hvt            xrcrg1=12
+ xrcrg2=1                  cgso=cgon_hvt             cgdo=cgon_hvt
+ cgbo=0                    cgdl=cgln_hvt             cgsl=cgln_hvt
+ clc=1e-007                cle=0.6                   cf=cfn_hvt
+ ckappas=0.6               acde=1.2                  moin=12.6
+ noff=1.686                voffcv=-0.05472           kt1=-0.24899435
+ lkt1=3.6220237e-009       wkt1=4.1333653e-009       pkt1=-2.9609794e-015
+ kt1l=0                    kt2=-0.049101538          lkt2=2.0523077e-009
+ ute=-0.8                  ua1=3.4814417e-009        lua1=-3.5338343e-017
+ wua1=-3.2220722e-017      pua1=3.3269432e-025       ub1=-2.922e-018
+ lub1=4.14e-026            uc1=-9.671e-011           luc1=2.7922e-017
+ prt=0                     at=120769.23              lat=-0.014153846
+ jss=2.00e-07              jsws=6.71e-13             jswgs=5.40e-11
+ njs=1                     ijthsfwd=0.01             ijthsrev=0.01
+ bvs=10                    xjbvs=1                   pbs=0.496
+ cjs=cjn_hvt               mjs=0.336                 pbsws=0.8
+ cjsws=cjswn_hvt           mjsws=0.01                pbswgs=1.0004
+ cjswgs=cjswgn_hvt         mjswgs=0.5561             tpb=1.00e-03
+ tcj=8.34e-04              tpbsw=1.00e-03            tcjsw=3.57e-04
+ tpbswg=1.50e-03           tcjswg=7.67e-04           xtis=3
+ dmcg=9.25e-008            dmci=9.25e-008            dmdg=0
+ dmcgt=0                   dwj=0                     xgw=0
+ xgl=0                     rshg=0.1                  gbmin=1e-012
+ rbpb=50                   rbpd=50                   rbps=50
+ rbdb=50                   rbsb=50                   ngcon=1
+ saref=0.63e-6             sbref=0.63e-6             kvsat=0.1
+ wlod=0.8e-6               tku0=0.01                 ku0=-7.01e-8
+ llodku0=1                 wlodku0=1                 lku0=4.027e-7
+ wku0=8e-7                 pku0=-2.0e-13             kvth0=3.5e-9
+ stk2=1.65e-9              steta0=0                  lkvth0=-2.68e-11
+ wkvth0=1.5e-6             pkvth0=0                  llodvth=1
+ wlodvth=1                 lodk2=0.5                 lodeta0=1
+ fnoimod=1                 noia=3.75e+41             noib=6.25e+24
+ noic=8.75                 em=1.00e+08               ef=0.9
+ wpemod=wpeflag_hvt        kvth0we=0.00323           lkvth0we=0
+ wkvth0we=0                pkvth0we=0                ku0we=-0.0015
+ lku0we=6.00e-10           wku0we=0                  pku0we=0
+ k2we=0.0015               wk2we=0                   web=-210
+ wec=-3500                 scref=1.00e-06            ud=0
+ tnoimod=0                 minr=1e-3

     20: type=n
+ lmin=1.0e-07              lmax=2.4000e-07-dxln_hvt  wmin=2.4000e-07-dxwn_hvt
+ wmax=5.0000e-07-dxwn_hvt  version=4.5               binunit=2
+ paramchk=1                mobmod=0                  capmod=2
+ igcmod=1                  igbmod=1                  geomod=0
+ diomod=1                  rdsmod=0                  rbodymod=0
+ rgatemod=0                permod=1                  acnqsmod=0
+ trnqsmod=0                tnom=25                   toxe=toxn_hvt
+ toxm=toxn_hvt             dtox=3.03e-010            epsrox=3.9
+ wint=6e-009               lint=2.5e-009             ll=0
+ wl=0                      lln=1                     wln=1
+ lw=0                      ww=0                      lwn=1
+ wwn=1                     lwl=0                     wwl=0
+ llc=0                     wlc=0                     lwc=0
+ wwc=0                     lwlc=0                    wwlc=0
+ dlc=1.124e-008            dwc=0                     xpart=1
+ toxref=3e-009             dlcig=2.5e-009            xl=-3.5e-08+dxln_hvt
+ xw=1.5e-8+dxwn_hvt        vth0=0.3889967+dvthn_hvt  lvth0=3.2604396e-010+dlvthn_hvt
+ wvth0=-9.2679132e-009+dwvthn_hvt                    pvth0=-1.2088582e-016+dpvthn_hvt
+ k1=0.33                   k2=0.022596044+dk2n_hvt   lk2=-7.2520879e-010
+ wk2=1.1014042e-009        pk2=2.4177165e-017        k3=-2.45
+ k3b=1.2                   w0=-5.5e-008              dvt0=18.2
+ dvt1=1.35                 dvt2=0.12                 dvt0w=0
+ dvt1w=0                   dvt2w=0                   dsub=0.5
+ minv=0                    voffl=0                   dvtp0=7e-007
+ dvtp1=0                   lpe0=1.5e-008             lpeb=0
+ xj=1.5e-007               ngate=4e020               ndep=8.3687e017
+ nsd=1e020                 phin=0                    cdsc=0
+ cdscb=0                   cdscd=0                   lcdscd=0+dlcdscdn_hvt
+ cit=-0.00023936319        lcit=2.9787264e-010+dlcitn_hvt
+ wcit=7.0315254e-011       pcit=-1.4063051e-017      voff=-0.18015797
+ lvoff=-3.4763736e-010+dlvoffn_hvt                   wvoff=1.2525115e-008
+ pvoff=-3.4250984e-016+dpvoffn_hvt                   nfactor=0.6569
+ eta0=0.14393203+deta0n_hvt                          leta0=-2.7864066e-009
+ weta0=1.8737303e-009      peta0=-3.7474605e-016     etab=-0.08
+ u0=0.039556346            lu0=-5.9815385e-011       wu0=-2.1524393e-009
+ pu0=-4.835433e-018        ua=-4.2457143e-010        lua=5.1428571e-019
+ ub=1.2896176e-018         lub=8.4263736e-028        wub=7.5217846e-027
+ pub=1.1282677e-033        uc=2.0204819e-010         luc=-8.1766912e-018
+ wuc=-2.2034799e-017       puc=1.322088e-024         vsat=104146.81
+ lvsat=0.00053063736       wvsat=0.0006447244        pvsat=-1.2894488e-010+dpvsatn_hvt
+ a0=3.0556599              la0=-1.5987659e-007       wa0=-4.235705e-007
+ pa0=4.4848641e-014        ags=0.8506                a1=0
+ a2=1                      b0=0                      b1=0
+ keta=-0.038777143         lketa=7.9054286e-009      dwg=0
+ dwb=0                     pclm=1.01                 pdiblc1=0.1691
+ pdiblc2=0.0020766264      lpdiblc2=6.2062418e-011   wpdiblc2=1.0208136e-010
+ ppdiblc2=-6.1248818e-018  pdiblcb=-0.1              drout=0.5
+ pvag=1.252                delta=0.0075              pscbe1=9.264e008
+ pscbe2=1e-020             fprout=0                  pdits=0
+ pditsd=0                  pditsl=0                  rsh=10.5
+ rdsw=150                  prwg=0                    prwb=0
+ wr=1                      alpha0=0                  alpha1=0.03
+ beta0=8.7                 agidl=2.593e-009          bgidl=1.698e009
+ cgidl=0.25                egidl=0.2624              aigbacc=0.01238
+ bigbacc=0.006109          cigbacc=0.2809            nigbacc=4.05
+ aigbinv=0.35              bigbinv=0.03              cigbinv=0.006
+ eigbinv=1.1               nigbinv=1                 aigc=0.009898
+ bigc=0.001383             cigc=1.515e-005           aigsd=0.0086
+ bigsd=0.0004353           cigsd=3.925e-020          nigc=1
+ poxedge=1                 pigcd=1.672               ntox=ntoxn_hvt
+ xrcrg1=12                 xrcrg2=1                  cgso=cgon_hvt
+ cgdo=cgon_hvt             cgbo=0                    cgdl=cgln_hvt
+ cgsl=cgln_hvt             clc=1e-007                cle=0.6
+ cf=cfn_hvt                ckappas=0.6               acde=1.2
+ moin=12.6                 noff=1.686                voffcv=-0.05472
+ kt1=-0.21467137           lkt1=-3.2425714e-009      wkt1=-1.119537e-008
+ pkt1=1.0476771e-016       kt1l=0                    kt2=-0.041917143
+ lkt2=6.1542857e-010       ute=-0.8                  ua1=4.0255e-009
+ lua1=-1.4415e-016         wua1=-4.3653214e-017      pua1=2.6191929e-024
+ ub1=-3.5961e-018          lub1=1.7622e-025          uc1=-3.6428571e-012
+ luc1=9.3085714e-018       prt=0                     at=50000
+ jss=2.00e-07              jsws=6.71e-13             jswgs=5.40e-11
+ njs=1                     ijthsfwd=0.01             ijthsrev=0.01
+ bvs=10                    xjbvs=1                   pbs=0.496
+ cjs=cjn_hvt               mjs=0.336                 pbsws=0.8
+ cjsws=cjswn_hvt           mjsws=0.01                pbswgs=1.0004
+ cjswgs=cjswgn_hvt         mjswgs=0.5561             tpb=1.00e-03
+ tcj=8.34e-04              tpbsw=1.00e-03            tcjsw=3.57e-04
+ tpbswg=1.50e-03           tcjswg=7.67e-04           xtis=3
+ dmcg=9.25e-008            dmci=9.25e-008            dmdg=0
+ dmcgt=0                   dwj=0                     xgw=0
+ xgl=0                     rshg=0.1                  gbmin=1e-012
+ rbpb=50                   rbpd=50                   rbps=50
+ rbdb=50                   rbsb=50                   ngcon=1
+ saref=0.63e-6             sbref=0.63e-6             kvsat=0.1
+ wlod=0.8e-6               tku0=0.01                 ku0=-7.01e-8
+ llodku0=1                 wlodku0=1                 lku0=4.027e-7
+ wku0=8e-7                 pku0=-2.0e-13             kvth0=3.5e-9
+ stk2=1.65e-9              steta0=0                  lkvth0=-2.68e-11
+ wkvth0=1.5e-6             pkvth0=0                  llodvth=1
+ wlodvth=1                 lodk2=0.5                 lodeta0=1
+ fnoimod=1                 noia=3.75e+41             noib=6.25e+24
+ noic=8.75                 em=1.00e+08               ef=0.9
+ wpemod=wpeflag_hvt        kvth0we=0.00323           lkvth0we=0
+ wkvth0we=0                pkvth0we=0                ku0we=-0.0015
+ lku0we=6.00e-10           wku0we=0                  pku0we=0
+ k2we=0.0015               wk2we=0                   web=-210
+ wec=-3500                 scref=1.00e-06            ud=0
+ tnoimod=0                 minr=1e-3

     21: type=n
+ lmin=1.0000e-05-dxln_hvt  lmax=2.001e-05            wmin=1.20e-07
+ wmax=2.4000e-07-dxwn_hvt  version=4.5               binunit=2
+ paramchk=1                mobmod=0                  capmod=2
+ igcmod=1                  igbmod=1                  geomod=0
+ diomod=1                  rdsmod=0                  rbodymod=0
+ rgatemod=0                permod=1                  acnqsmod=0
+ trnqsmod=0                tnom=25                   toxe=toxn_hvt
+ toxm=toxn_hvt             dtox=3.03e-010            epsrox=3.9
+ wint=6e-009               lint=2.5e-009             ll=0
+ wl=0                      lln=1                     wln=1
+ lw=0                      ww=0                      lwn=1
+ wwn=1                     lwl=0                     wwl=0
+ llc=0                     wlc=0                     lwc=0
+ wwc=0                     lwlc=0                    wwlc=0
+ dlc=1.124e-008            dwc=0                     xpart=1
+ toxref=3e-009             dlcig=2.5e-009            xl=-3.5e-08+dxln_hvt
+ xw=1.5e-8+dxwn_hvt        vth0=0.366175+dvthn_hvt   wvth0=-1.743525e-009+dwvthn_hvt
+ lvth0=0+dlvthn_hvt        pvth0=0+dpvthn_hvt        k1=0.33
+ k2=0.031183+dk2n_hvt      wk2=4.68261e-010          k3=-2.45
+ k3b=1.2                   w0=-5.5e-008              dvt0=18.2
+ dvt1=1.35                 dvt2=0.12                 dvt0w=0
+ dvt1w=0                   dvt2w=0                   dsub=0.5
+ minv=0                    voffl=0                   dvtp0=7e-007
+ dvtp1=0                   lpe0=1.5e-008             lpeb=0
+ xj=1.5e-007               ngate=4e020               ndep=8.3687e017
+ nsd=1e020                 phin=0                    cdsc=0
+ cdscb=0                   cdscd=0                   lcdscd=0+dlcdscdn_hvt
+ cit=0                     voff=-0.12973             wvoff=1.29519e-009
+ lvoff=0+dlvoffn_hvt       lcit=0+dlcitn_hvt         pvoff=0+dpvoffn_hvt
+ nfactor=0.6569            eta0=0.13+deta0n_hvt      etab=-0.08
+ u0=0.03450725             wu0=-1.0685318e-009       ua=-4.28e-010
+ ub=1.414e-018             uc=1.453e-010             vsat=106902.3
+ lvsat=-0.0010188582       wvsat=-2.4857685e-005     pvsat=2.4758254e-010+dpvsatn_hvt
+ a0=2.33                   ags=0.8506                a1=0
+ a2=1                      b0=0                      b1=0
+ keta=0.006644             dwg=0                     dwb=0
+ pclm=1.01                 pdiblc1=0.1691            pdiblc2=0.0001103
+ pdiblcb=-0.1              drout=0.5                 pvag=1.252
+ delta=0.0075              pscbe1=9.264e008          pscbe2=1e-020
+ fprout=0                  pdits=0                   pditsd=0
+ pditsl=0                  rsh=10.5                  rdsw=150
+ prwg=0                    prwb=0                    wr=1
+ alpha0=0                  alpha1=0.03               beta0=8.7
+ agidl=2.593e-009          bgidl=1.698e009           cgidl=0.25
+ egidl=0.2624              aigbacc=0.01238           bigbacc=0.006109
+ cigbacc=0.2809            nigbacc=4.05              aigbinv=0.35
+ bigbinv=0.03              cigbinv=0.006             eigbinv=1.1
+ nigbinv=1                 aigc=0.009898             bigc=0.001383
+ cigc=1.515e-005           aigsd=0.0086              bigsd=0.0004353
+ cigsd=3.925e-020          nigc=1                    poxedge=1
+ pigcd=1.672               ntox=ntoxn_hvt            xrcrg1=12
+ xrcrg2=1                  cgso=cgon_hvt             cgdo=cgon_hvt
+ cgbo=0                    cgdl=cgln_hvt             cgsl=cgln_hvt
+ clc=1e-007                cle=0.6                   cf=cfn_hvt
+ ckappas=0.6               acde=1.2                  moin=12.6
+ noff=1.686                voffcv=-0.05472           kt1=-0.2027
+ kt1l=0                    kt2=-0.0522               ute=-0.75
+ ua1=3.8348e-009           wua1=-2.78964e-017        ub1=-2.794725e-018
+ wub1=-5.2554825e-026      uc1=2.4e-010              prt=0
+ at=90000                  jss=2.00e-07              jsws=6.71e-13
+ jswgs=5.40e-11            njs=1                     ijthsfwd=0.01
+ ijthsrev=0.01             bvs=10                    xjbvs=1
+ pbs=0.496                 cjs=cjn_hvt               mjs=0.336
+ pbsws=0.8                 cjsws=cjswn_hvt           mjsws=0.01
+ pbswgs=1.0004             cjswgs=cjswgn_hvt         mjswgs=0.5561
+ tpb=1.00e-03              tcj=8.34e-04              tpbsw=1.00e-03
+ tcjsw=3.57e-04            tpbswg=1.50e-03           tcjswg=7.67e-04
+ xtis=3                    dmcg=9.25e-008            dmci=9.25e-008
+ dmdg=0                    dmcgt=0                   dwj=0
+ xgw=0                     xgl=0                     rshg=0.1
+ gbmin=1e-012              rbpb=50                   rbpd=50
+ rbps=50                   rbdb=50                   rbsb=50
+ ngcon=1                   saref=0.63e-6             sbref=0.63e-6
+ kvsat=0.1                 wlod=0.8e-6               tku0=0.01
+ ku0=-7.01e-8              llodku0=1                 wlodku0=1
+ lku0=4.027e-7             wku0=8e-7                 pku0=-2.0e-13
+ kvth0=3.5e-9              stk2=1.65e-9              steta0=0
+ lkvth0=-2.68e-11          wkvth0=1.5e-6             pkvth0=0
+ llodvth=1                 wlodvth=1                 lodk2=0.5
+ lodeta0=1                 fnoimod=1                 noia=3.75e+41
+ noib=6.25e+24             noic=8.75                 em=1.00e+08
+ ef=0.9                    wpemod=wpeflag_hvt        kvth0we=0.00323
+ lkvth0we=0                wkvth0we=0                pkvth0we=0
+ ku0we=-0.0015             lku0we=6.00e-10           wku0we=0
+ pku0we=0                  k2we=0.0015               wk2we=0
+ web=-210                  wec=-3500                 scref=1.00e-06
+ ud=0                      tnoimod=0                 minr=1e-3

     22: type=n
+ lmin=1.2000e-06-dxln_hvt  lmax=1.0000e-05-dxln_hvt  wmin=1.20e-07
+ wmax=2.4000e-07-dxwn_hvt  version=4.5               binunit=2
+ paramchk=1                mobmod=0                  capmod=2
+ igcmod=1                  igbmod=1                  geomod=0
+ diomod=1                  rdsmod=0                  rbodymod=0
+ rgatemod=0                permod=1                  acnqsmod=0
+ trnqsmod=0                tnom=25                   toxe=toxn_hvt
+ toxm=toxn_hvt             dtox=3.03e-010            epsrox=3.9
+ wint=6e-009               lint=2.5e-009             ll=0
+ wl=0                      lln=1                     wln=1
+ lw=0                      ww=0                      lwn=1
+ wwn=1                     lwl=0                     wwl=0
+ llc=0                     wlc=0                     lwc=0
+ wwc=0                     lwlc=0                    wwlc=0
+ dlc=1.124e-008            dwc=0                     xpart=1
+ toxref=3e-009             dlcig=2.5e-009            xl=-3.5e-08+dxln_hvt
+ xw=1.5e-8+dxwn_hvt        vth0=0.3652325+dvthn_hvt  lvth0=9.3873e-009+dlvthn_hvt
+ wvth0=-1.5465293e-009+dwvthn_hvt                    pvth0=-1.962077e-015+dpvthn_hvt
+ k1=0.33                   k2=0.031905825+dk2n_hvt   lk2=-7.199337e-009
+ wk2=4.242653e-010         pk2=4.3819719e-016        k3=-2.45
+ k3b=1.2                   w0=-5.5e-008              dvt0=18.2
+ dvt1=1.35                 dvt2=0.12                 dvt0w=0
+ dvt1w=0                   dvt2w=0                   dsub=0.5
+ minv=0                    voffl=0                   dvtp0=7e-007
+ dvtp1=0                   lpe0=1.5e-008             lpeb=0
+ xj=1.5e-007               ngate=4e020               ndep=8.3687e017
+ nsd=1e020                 phin=0                    cdsc=0
+ cdscb=0                   cdscd=0                   lcdscd=0+dlcdscdn_hvt
+ cit=-3.0318182e-005       lcit=3.0196909e-010+dlcitn_hvt
+ voff=-0.12526499          lvoff=-4.4471513e-008+dlvoffn_hvt
+ wvoff=8.0598406e-010      pvoff=4.8724912e-015+dpvoffn_hvt
+ nfactor=0.6569            eta0=0.13+deta0n_hvt      etab=-0.08
+ u0=0.034415439            lu0=9.1444118e-010        wu0=-1.0731283e-009
+ pu0=4.5781796e-017        ua=-4.28e-010             ub=1.414e-018
+ uc=1.4855591e-010         luc=-3.2428855e-017       vsat=106806.59
+ pvsat=0+dpvsatn_hvt       lvsat=-6.5645455e-005     a0=2.3752136
+ la0=-4.5032782e-007       ags=0.841465              lags=9.09846e-008
+ a1=0                      a2=1                      b0=0
+ b1=0                      keta=0.0094654364         lketa=-2.8101506e-008
+ dwg=0                     dwb=0                     pclm=1.01
+ pdiblc1=0.1691            pdiblc2=-6.4794091e-005   lpdiblc2=1.7439371e-009
+ wpdiblc2=-3.2044631e-011  ppdiblc2=3.1916452e-016   pdiblcb=-0.1
+ drout=0.5                 pvag=1.252                delta=0.0075
+ pscbe1=9.264e008          pscbe2=1e-020             fprout=0
+ pdits=0                   pditsd=0                  pditsl=0
+ rsh=10.5                  rdsw=150                  prwg=0
+ prwb=0                    wr=1                      alpha0=0
+ alpha1=0.03               beta0=8.7                 agidl=2.593e-009
+ bgidl=1.698e009           cgidl=0.25                egidl=0.2624
+ aigbacc=0.01238           bigbacc=0.006109          cigbacc=0.2809
+ nigbacc=4.05              aigbinv=0.35              bigbinv=0.03
+ cigbinv=0.006             eigbinv=1.1               nigbinv=1
+ aigc=0.009898             bigc=0.001383             cigc=1.515e-005
+ aigsd=0.0086              bigsd=0.0004353           cigsd=3.925e-020
+ nigc=1                    poxedge=1                 pigcd=1.672
+ ntox=ntoxn_hvt            xrcrg1=12                 xrcrg2=1
+ cgso=cgon_hvt             cgdo=cgon_hvt             cgbo=0
+ cgdl=cgln_hvt             cgsl=cgln_hvt             clc=1e-007
+ cle=0.6                   cf=cfn_hvt                ckappas=0.6
+ acde=1.2                  moin=12.6                 noff=1.686
+ voffcv=-0.05472           kt1=-0.19896625           lkt1=-3.718815e-008
+ wkt1=9.8497841e-011       pkt1=-9.810385e-016       kt1l=0
+ kt2=-0.053001455          lkt2=7.9824873e-009       ute=-0.74340909
+ lute=-6.5645455e-008      ua1=3.8766259e-009        lua1=-4.1658605e-016
+ wua1=-2.8290391e-017      pua1=3.924154e-024        ub1=-2.8094425e-018
+ lub1=1.465863e-025        wub1=-5.3014482e-026      pub1=4.5781796e-033
+ uc1=2.6161686e-010        luc1=-2.1530396e-016      prt=0
+ at=90000                  jss=2.00e-07              jsws=6.71e-13
+ jswgs=5.40e-11            njs=1                     ijthsfwd=0.01
+ ijthsrev=0.01             bvs=10                    xjbvs=1
+ pbs=0.496                 cjs=cjn_hvt               mjs=0.336
+ pbsws=0.8                 cjsws=cjswn_hvt           mjsws=0.01
+ pbswgs=1.0004             cjswgs=cjswgn_hvt         mjswgs=0.5561
+ tpb=1.00e-03              tcj=8.34e-04              tpbsw=1.00e-03
+ tcjsw=3.57e-04            tpbswg=1.50e-03           tcjswg=7.67e-04
+ xtis=3                    dmcg=9.25e-008            dmci=9.25e-008
+ dmdg=0                    dmcgt=0                   dwj=0
+ xgw=0                     xgl=0                     rshg=0.1
+ gbmin=1e-012              rbpb=50                   rbpd=50
+ rbps=50                   rbdb=50                   rbsb=50
+ ngcon=1                   saref=0.63e-6             sbref=0.63e-6
+ kvsat=0.1                 wlod=0.8e-6               tku0=0.01
+ ku0=-7.01e-8              llodku0=1                 wlodku0=1
+ lku0=4.027e-7             wku0=8e-7                 pku0=-2.0e-13
+ kvth0=3.5e-9              stk2=1.65e-9              steta0=0
+ lkvth0=-2.68e-11          wkvth0=1.5e-6             pkvth0=0
+ llodvth=1                 wlodvth=1                 lodk2=0.5
+ lodeta0=1                 fnoimod=1                 noia=3.75e+41
+ noib=6.25e+24             noic=8.75                 em=1.00e+08
+ ef=0.9                    wpemod=wpeflag_hvt        kvth0we=0.00323
+ lkvth0we=0                wkvth0we=0                pkvth0we=0
+ ku0we=-0.0015             lku0we=6.00e-10           wku0we=0
+ pku0we=0                  k2we=0.0015               wk2we=0
+ web=-210                  wec=-3500                 scref=1.00e-06
+ ud=0                      tnoimod=0                 minr=1e-3

     23: type=n
+ lmin=5.0000e-07-dxln_hvt  lmax=1.2000e-06-dxln_hvt  wmin=1.20e-07
+ wmax=2.4000e-07-dxwn_hvt  version=4.5               binunit=2
+ paramchk=1                mobmod=0                  capmod=2
+ igcmod=1                  igbmod=1                  geomod=0
+ diomod=1                  rdsmod=0                  rbodymod=0
+ rgatemod=0                permod=1                  acnqsmod=0
+ trnqsmod=0                tnom=25                   toxe=toxn_hvt
+ toxm=toxn_hvt             dtox=3.03e-010            epsrox=3.9
+ wint=6e-009               lint=2.5e-009             ll=0
+ wl=0                      lln=1                     wln=1
+ lw=0                      ww=0                      lwn=1
+ wwn=1                     lwl=0                     wwl=0
+ llc=0                     wlc=0                     lwc=0
+ wwc=0                     lwlc=0                    wwlc=0
+ dlc=1.124e-008            dwc=0                     xpart=1
+ toxref=3e-009             dlcig=2.5e-009            xl=-3.5e-08+dxln_hvt
+ xw=1.5e-8+dxwn_hvt        vth0=0.37864786+dvthn_hvt lvth0=-6.1745143e-009+dlvthn_hvt
+ wvth0=-3.8926864e-009+dwvthn_hvt                    pvth0=7.5946526e-016+dpvthn_hvt
+ k1=0.33                   k2=0.022186414+dk2n_hvt   lk2=4.0751794e-009
+ wk2=1.4960156e-009        pk2=-8.0503317e-016       k3=-2.45
+ k3b=1.2                   w0=-5.5e-008              dvt0=18.2
+ dvt1=1.35                 dvt2=0.12                 dvt0w=0
+ dvt1w=0                   dvt2w=0                   dsub=0.5
+ minv=0                    voffl=0                   dvtp0=7e-007
+ dvtp1=0                   lpe0=1.5e-008             lpeb=0
+ xj=1.5e-007               ngate=4e020               ndep=8.3687e017
+ nsd=1e020                 phin=0                    cdsc=0
+ cdscb=0                   cdscd=0                   lcdscd=0+dlcdscdn_hvt
+ cit=-0.00014457143        lcit=4.3450286e-010+dlcitn_hvt
+ voff=-0.18231136          lvoff=2.1702274e-008+dlvoffn_hvt
+ wvoff=8.0835512e-009      pvoff=-3.5694867e-015+dpvoffn_hvt
+ nfactor=0.6569            eta0=0.13+deta0n_hvt      etab=-0.08
+ u0=0.03567985             lu0=-5.52276e-010         wu0=-1.1285944e-009
+ pu0=1.1012246e-016        ua=-4.2931429e-010        lua=1.5245714e-018
+ ub=1.3950579e-018         lub=2.1972886e-026        wub=1.8495598e-026
+ pub=-2.1454894e-032       uc=7.9781571e-011         luc=4.7349377e-017
+ wuc=9.9188781e-018        puc=-1.1505899e-023       vsat=754154
+ lvsat=-0.75098864         wvsat=-0.15732716         pvsat=1.824995e-007+dpvsatn_hvt
+ a0=3.2579964              la0=-1.4743559e-006       wa0=-2.2342028e-007
+ pa0=2.5916752e-013        ags=0.93751143            lags=-2.0429257e-008
+ a1=0                      a2=1                      b0=0
+ b1=0                      keta=-0.013833429         lketa=-1.0748229e-009
+ dwg=0                     dwb=0                     pclm=1.01
+ pdiblc1=0.1691            pdiblc2=0.0038535244      lpdiblc2=-2.8013123e-009
+ wpdiblc2=-5.2079448e-011  ppdiblc2=3.4240491e-016   pdiblcb=-0.1
+ drout=0.5                 pvag=1.252                delta=0.0075
+ pscbe1=9.264e008          pscbe2=1e-020             fprout=0
+ pdits=0                   pditsd=0                  pditsl=0
+ rsh=10.5                  rdsw=150                  prwg=0
+ prwb=0                    wr=1                      alpha0=0
+ alpha1=0.03               beta0=8.7                 agidl=2.593e-009
+ bgidl=1.698e009           cgidl=0.25                egidl=0.2624
+ aigbacc=0.01238           bigbacc=0.006109          cigbacc=0.2809
+ nigbacc=4.05              aigbinv=0.35              bigbinv=0.03
+ cigbinv=0.006             eigbinv=1.1               nigbinv=1
+ aigc=0.009898             bigc=0.001383             cigc=1.515e-005
+ aigsd=0.0086              bigsd=0.0004353           cigsd=3.925e-020
+ nigc=1                    poxedge=1                 pigcd=1.672
+ ntox=ntoxn_hvt            xrcrg1=12                 xrcrg2=1
+ cgso=cgon_hvt             cgdo=cgon_hvt             cgbo=0
+ cgdl=cgln_hvt             cgsl=cgln_hvt             clc=1e-007
+ cle=0.6                   cf=cfn_hvt                ckappas=0.6
+ acde=1.2                  moin=12.6                 noff=1.686
+ voffcv=-0.05472           kt1=-0.21816143           lkt1=-1.4921743e-008
+ wkt1=-1.2382586e-009      pkt1=5.6959894e-016       kt1l=0
+ kt2=-0.047092571          lkt2=1.1281829e-009       ute=-0.8
+ ua1=3.6108471e-009        lua1=-1.0828269e-016      wua1=-2.5234856e-017
+ pua1=3.7973263e-025       ub1=-2.6997171e-018       lub1=1.9304886e-026
+ wub1=-5.3487077e-026      pub1=5.1263905e-033       uc1=1.4962314e-010
+ luc1=-8.5391246e-017      prt=0                     at=90000
+ jss=2.00e-07              jsws=6.71e-13             jswgs=5.40e-11
+ njs=1                     ijthsfwd=0.01             ijthsrev=0.01
+ bvs=10                    xjbvs=1                   pbs=0.496
+ cjs=cjn_hvt               mjs=0.336                 pbsws=0.8
+ cjsws=cjswn_hvt           mjsws=0.01                pbswgs=1.0004
+ cjswgs=cjswgn_hvt         mjswgs=0.5561             tpb=1.00e-03
+ tcj=8.34e-04              tpbsw=1.00e-03            tcjsw=3.57e-04
+ tpbswg=1.50e-03           tcjswg=7.67e-04           xtis=3
+ dmcg=9.25e-008            dmci=9.25e-008            dmdg=0
+ dmcgt=0                   dwj=0                     xgw=0
+ xgl=0                     rshg=0.1                  gbmin=1e-012
+ rbpb=50                   rbpd=50                   rbps=50
+ rbdb=50                   rbsb=50                   ngcon=1
+ saref=0.63e-6             sbref=0.63e-6             kvsat=0.1
+ wlod=0.8e-6               tku0=0.01                 ku0=-7.01e-8
+ llodku0=1                 wlodku0=1                 lku0=4.027e-7
+ wku0=8e-7                 pku0=-2.0e-13             kvth0=3.5e-9
+ stk2=1.65e-9              steta0=0                  lkvth0=-2.68e-11
+ wkvth0=1.5e-6             pkvth0=0                  llodvth=1
+ wlodvth=1                 lodk2=0.5                 lodeta0=1
+ fnoimod=1                 noia=3.75e+41             noib=6.25e+24
+ noic=8.75                 em=1.00e+08               ef=0.9
+ wpemod=wpeflag_hvt        kvth0we=0.00323           lkvth0we=0
+ wkvth0we=0                pkvth0we=0                ku0we=-0.0015
+ lku0we=6.00e-10           wku0we=0                  pku0we=0
+ k2we=0.0015               wk2we=0                   web=-210
+ wec=-3500                 scref=1.00e-06            ud=0
+ tnoimod=0                 minr=1e-3

     24: type=n
+ lmin=2.4000e-07-dxln_hvt  lmax=5.0000e-07-dxln_hvt  wmin=1.20e-07
+ wmax=2.4000e-07-dxwn_hvt  version=4.5               binunit=2
+ paramchk=1                mobmod=0                  capmod=2
+ igcmod=1                  igbmod=1                  geomod=0
+ diomod=1                  rdsmod=0                  rbodymod=0
+ rgatemod=0                permod=1                  acnqsmod=0
+ trnqsmod=0                tnom=25                   toxe=toxn_hvt
+ toxm=toxn_hvt             dtox=3.03e-010            epsrox=3.9
+ wint=6e-009               lint=2.5e-009             ll=0
+ wl=0                      lln=1                     wln=1
+ lw=0                      ww=0                      lwn=1
+ wwn=1                     lwl=0                     wwl=0
+ llc=0                     wlc=0                     lwc=0
+ wwc=0                     lwlc=0                    wwlc=0
+ dlc=1.124e-008            dwc=0                     xpart=1
+ toxref=3e-009             dlcig=2.5e-009            xl=-3.5e-08+dxln_hvt
+ xw=1.5e-8+dxwn_hvt        vth0=0.37141731+dvthn_hvt lvth0=-2.8484615e-009+dlvthn_hvt
+ wvth0=-2.6248673e-009+dwvthn_hvt                    pvth0=1.7626846e-016+dpvthn_hvt
+ k1=0.33                   k2=0.037789731+dk2n_hvt   lk2=-3.1023462e-009
+ wk2=-7.7136612e-010       pk2=2.3796242e-016        k3=-2.45
+ k3b=1.2                   w0=-5.5e-008              dvt0=18.2
+ dvt1=1.35                 dvt2=0.12                 dvt0w=0
+ dvt1w=0                   dvt2w=0                   dsub=0.5
+ minv=0                    voffl=0                   dvtp0=7e-007
+ dvtp1=0                   lpe0=1.5e-008             lpeb=0
+ xj=1.5e-007               ngate=4e020               ndep=8.3687e017
+ nsd=1e020                 phin=0                    cdsc=0
+ cdscb=0                   cdscd=0                   lcdscd=0+dlcdscdn_hvt
+ cit=0.00045384615         lcit=1.5923077e-010+dlcitn_hvt
+ voff=-0.12621327          lvoff=-4.1028462e-009+dlvoffn_hvt
+ wvoff=-1.1706525e-009     pvoff=6.87447e-016+dpvoffn_hvt
+ nfactor=0.6569            eta0=0.13+deta0n_hvt      etab=-0.08
+ u0=0.035833288            lu0=-6.2285769e-010       wu0=-1.1210291e-009
+ pu0=1.0664242e-016        ua=-4.2907692e-010        lua=1.4153846e-018
+ ub=1.4716135e-018         lub=-1.3242692e-026       wub=-3.9066456e-026
+ pub=5.0236512e-033        uc=2.3117481e-010         luc=-2.2291512e-017
+ wuc=-2.2587271e-017       puc=3.4469298e-024        vsat=-1636299.2
+ lvsat=0.34861985          wvsat=0.42357311          pvsat=-8.4714623e-008+dpvsatn_hvt
+ a0=-1.0567981             la0=5.1044962e-007        wa0=6.126287e-007
+ pa0=-1.2541501e-013       ags=0.92579231            lags=-1.5038462e-008
+ a1=0                      a2=1                      b0=0
+ b1=0                      keta=-0.029185385         lketa=5.9870769e-009
+ dwg=0                     dwb=0                     pclm=1.01
+ pdiblc1=0.1691            pdiblc2=-0.0070761388     lpdiblc2=2.2263328e-009
+ wpdiblc2=1.4817318e-009   ppdiblc2=-3.6314828e-016  pdiblcb=-0.1
+ drout=0.5                 pvag=1.252                delta=0.0075
+ pscbe1=9.264e008          pscbe2=1e-020             fprout=0
+ pdits=0                   pditsd=0                  pditsl=0
+ rsh=10.5                  rdsw=150                  prwg=0
+ prwb=0                    wr=1                      alpha0=0
+ alpha1=0.03               beta0=8.7                 agidl=2.593e-009
+ bgidl=1.698e009           cgidl=0.25                egidl=0.2624
+ aigbacc=0.01238           bigbacc=0.006109          cigbacc=0.2809
+ nigbacc=4.05              aigbinv=0.35              bigbinv=0.03
+ cigbinv=0.006             eigbinv=1.1               nigbinv=1
+ aigc=0.009898             bigc=0.001383             cigc=1.515e-005
+ aigsd=0.0086              bigsd=0.0004353           cigsd=3.925e-020
+ nigc=1                    poxedge=1                 pigcd=1.672
+ ntox=ntoxn_hvt            xrcrg1=12                 xrcrg2=1
+ cgso=cgon_hvt             cgdo=cgon_hvt             cgbo=0
+ cgdl=cgln_hvt             cgsl=cgln_hvt             clc=1e-007
+ cle=0.6                   cf=cfn_hvt                ckappas=0.6
+ acde=1.2                  moin=12.6                 noff=1.686
+ voffcv=-0.05472           kt1=-0.23198462           lkt1=-8.5630769e-009
+ kt1l=0                    kt2=-0.049101538          lkt2=2.0523077e-009
+ ute=-0.8                  ua1=3.4012e-009           lua1=-1.1845e-017
+ wua1=-1.2721985e-017      pua1=-5.3761881e-024      ub1=-2.6137115e-018
+ lub1=-2.0257692e-026      wub1=-7.4914096e-026      pub1=1.4982819e-032
+ uc1=-9.671e-011           luc1=2.7922e-017          prt=0
+ at=120769.23              lat=-0.014153846          jss=2.00e-07
+ jsws=6.71e-13             jswgs=5.40e-11            njs=1
+ ijthsfwd=0.01             ijthsrev=0.01             bvs=10
+ xjbvs=1                   pbs=0.496                 cjs=cjn_hvt
+ mjs=0.336                 pbsws=0.8                 cjsws=cjswn_hvt
+ mjsws=0.01                pbswgs=1.0004             cjswgs=cjswgn_hvt
+ mjswgs=0.5561             tpb=1.00e-03              tcj=8.34e-04
+ tpbsw=1.00e-03            tcjsw=3.57e-04            tpbswg=1.50e-03
+ tcjswg=7.67e-04           xtis=3                    dmcg=9.25e-008
+ dmci=9.25e-008            dmdg=0                    dmcgt=0
+ dwj=0                     xgw=0                     xgl=0
+ rshg=0.1                  gbmin=1e-012              rbpb=50
+ rbpd=50                   rbps=50                   rbdb=50
+ rbsb=50                   ngcon=1                   saref=0.63e-6
+ sbref=0.63e-6             kvsat=0.1                 wlod=0.8e-6
+ tku0=0.01                 ku0=-7.01e-8              llodku0=1
+ wlodku0=1                 lku0=4.027e-7             wku0=8e-7
+ pku0=-2.0e-13             kvth0=3.5e-9              stk2=1.65e-9
+ steta0=0                  lkvth0=-2.68e-11          wkvth0=1.5e-6
+ pkvth0=0                  llodvth=1                 wlodvth=1
+ lodk2=0.5                 lodeta0=1                 fnoimod=1
+ noia=3.75e+41             noib=6.25e+24             noic=8.75
+ em=1.00e+08               ef=0.9                    wpemod=wpeflag_hvt
+ kvth0we=0.00323           lkvth0we=0                wkvth0we=0
+ pkvth0we=0                ku0we=-0.0015             lku0we=6.00e-10
+ wku0we=0                  pku0we=0                  k2we=0.0015
+ wk2we=0                   web=-210                  wec=-3500
+ scref=1.00e-06            ud=0                      tnoimod=0
+ minr=1e-3

     25: type=n
+ lmin=1.0e-07              lmax=2.4000e-07-dxln_hvt  wmin=1.20e-07
+ wmax=2.4000e-07-dxwn_hvt  version=4.5               binunit=2
+ paramchk=1                mobmod=0                  capmod=2
+ igcmod=1                  igbmod=1                  geomod=0
+ diomod=1                  rdsmod=0                  rbodymod=0
+ rgatemod=0                permod=1                  acnqsmod=0
+ trnqsmod=0                tnom=25                   toxe=toxn_hvt
+ toxm=toxn_hvt             dtox=3.03e-010            epsrox=3.9
+ wint=6e-009               lint=2.5e-009             ll=0
+ wl=0                      lln=1                     wln=1
+ lw=0                      ww=0                      lwn=1
+ wwn=1                     lwl=0                     wwl=0
+ llc=0                     wlc=0                     lwc=0
+ wwc=0                     lwlc=0                    wwlc=0
+ dlc=1.124e-008            dwc=0                     xpart=1
+ toxref=3e-009             dlcig=2.5e-009            xl=-3.5e-08+dxln_hvt
+ xw=1.5e-8+dxwn_hvt        vth0=0.35583571+dvthn_hvt lvth0=2.6785714e-010+dlvthn_hvt
+ wvth0=-1.2097929e-009+dwvthn_hvt                    pvth0=-1.0674643e-016+dpvthn_hvt
+ k1=0.33                   k2=0.028613357+dk2n_hvt   lk2=-1.2670714e-009
+ wk2=-3.6080293e-010       pk2=1.5584979e-016        k3=-2.45
+ k3b=1.2                   w0=-5.5e-008              dvt0=18.2
+ dvt1=1.35                 dvt2=0.12                 dvt0w=0
+ dvt1w=0                   dvt2w=0                   dsub=0.5
+ minv=0                    voffl=0                   dvtp0=7e-007
+ dvtp1=0                   lpe0=1.5e-008             lpeb=0
+ xj=1.5e-007               ngate=4e020               ndep=8.3687e017
+ nsd=1e020                 phin=0                    cdsc=0
+ cdscb=0                   cdscd=0                   lcdscd=0+dlcdscdn_hvt
+ cit=9.3928571e-005        lcit=2.3121429e-010+dlcitn_hvt
+ wcit=-1.0674643e-011      pcit=2.1349286e-018       voff=-0.12770643
+ lvoff=-3.8042143e-009+dlvoffn_hvt                   wvoff=-2.2060929e-010
+ pvoff=4.9743836e-016+dpvoffn_hvt                    nfactor=0.6569
+ eta0=0.15115964+deta0n_hvt                          leta0=-4.2319286e-009
+ weta0=1.1742107e-010      peta0=-2.3484214e-017     etab=-0.08
+ u0=0.033051679            lu0=-6.6535714e-011       wu0=-5.7180504e-010
+ pu0=-3.2023929e-018       ua=-4.2457143e-010        lua=5.1428571e-019
+ ub=1.4522107e-018         lub=-9.3621429e-027       wub=-3.1988346e-026
+ pub=3.6080293e-033        uc=1.428375e-010          luc=-4.62405e-018
+ wuc=-7.6466025e-018       puc=4.5879615e-025        vsat=107678.57
+ lvsat=-0.00017571429      wvsat=-0.00021349286      pvsat=4.2698571e-011+dpvsatn_hvt
+ a0=1.3847607              la0=2.2137857e-008        wa0=-1.7541996e-008
+ pa0=6.1912929e-016        ags=0.8506                a1=0
+ a2=1                      b0=0                      b1=0
+ keta=-0.038777143         lketa=7.9054286e-009      dwg=0
+ dwb=0                     pclm=1.01                 pdiblc1=0.1691
+ pdiblc2=0.0044603214      lpdiblc2=-8.0959286e-011  wpdiblc2=-4.7715654e-010
+ ppdiblc2=2.8629392e-017   pdiblcb=-0.1              drout=0.5
+ pvag=1.252                delta=0.0075              pscbe1=9.264e008
+ pscbe2=1e-020             fprout=0                  pdits=0
+ pditsd=0                  pditsl=0                  rsh=10.5
+ rdsw=150                  prwg=0                    prwb=0
+ wr=1                      alpha0=0                  alpha1=0.03
+ beta0=8.7                 agidl=2.593e-009          bgidl=1.698e009
+ cgidl=0.25                egidl=0.2624              aigbacc=0.01238
+ bigbacc=0.006109          cigbacc=0.2809            nigbacc=4.05
+ aigbinv=0.35              bigbinv=0.03              cigbinv=0.006
+ eigbinv=1.1               nigbinv=1                 aigc=0.009898
+ bigc=0.001383             cigc=1.515e-005           aigsd=0.0086
+ bigsd=0.0004353           cigsd=3.925e-020          nigc=1
+ poxedge=1                 pigcd=1.672               ntox=ntoxn_hvt
+ xrcrg1=12                 xrcrg2=1                  cgso=cgon_hvt
+ cgdo=cgon_hvt             cgbo=0                    cgdl=cgln_hvt
+ cgsl=cgln_hvt             clc=1e-007                cle=0.6
+ cf=cfn_hvt                ckappas=0.6               acde=1.2
+ moin=12.6                 noff=1.686                voffcv=-0.05472
+ kt1=-0.26074286           lkt1=-2.8114286e-009      kt1l=0
+ kt2=-0.041917143          lkt2=6.1542857e-010       ute=-0.8
+ ua1=4.0646214e-009        lua1=-1.4452929e-016      wua1=-5.3159721e-017
+ pua1=2.7113593e-024       ub1=-3.5961e-018          lub1=1.7622e-025
+ uc1=-3.6428571e-012       luc1=9.3085714e-018       prt=0
+ at=50000                  jss=2.00e-07              jsws=6.71e-13
+ jswgs=5.40e-11            njs=1                     ijthsfwd=0.01
+ ijthsrev=0.01             bvs=10                    xjbvs=1
+ pbs=0.496                 cjs=cjn_hvt               mjs=0.336
+ pbsws=0.8                 cjsws=cjswn_hvt           mjsws=0.01
+ pbswgs=1.0004             cjswgs=cjswgn_hvt         mjswgs=0.5561
+ tpb=1.00e-03              tcj=8.34e-04              tpbsw=1.00e-03
+ tcjsw=3.57e-04            tpbswg=1.50e-03           tcjswg=7.67e-04
+ xtis=3                    dmcg=9.25e-008            dmci=9.25e-008
+ dmdg=0                    dmcgt=0                   dwj=0
+ xgw=0                     xgl=0                     rshg=0.1
+ gbmin=1e-012              rbpb=50                   rbpd=50
+ rbps=50                   rbdb=50                   rbsb=50
+ ngcon=1                   saref=0.63e-6             sbref=0.63e-6
+ kvsat=0.1                 wlod=0.8e-6               tku0=0.01
+ ku0=-7.01e-8              llodku0=1                 wlodku0=1
+ lku0=4.027e-7             wku0=8e-7                 pku0=-2.0e-13
+ kvth0=3.5e-9              stk2=1.65e-9              steta0=0
+ lkvth0=-2.68e-11          wkvth0=1.5e-6             pkvth0=0
+ llodvth=1                 wlodvth=1                 lodk2=0.5
+ lodeta0=1                 fnoimod=1                 noia=3.75e+41
+ noib=6.25e+24             noic=8.75                 em=1.00e+08
+ ef=0.9                    wpemod=wpeflag_hvt        kvth0we=0.00323
+ lkvth0we=0                wkvth0we=0                pkvth0we=0
+ ku0we=-0.0015             lku0we=6.00e-10           wku0we=0
+ pku0we=0                  k2we=0.0015               wk2we=0
+ web=-210                  wec=-3500                 scref=1.00e-06
+ ud=0                      tnoimod=0                 minr=1e-3

//  *****************************************************************************************
//
//             *
//                               1.0V HIGH VT PMOS DEVICE MODELS
//             *
//
//             *
//  *****************************************************************************************

     }
model pch_hvt bsim4  {
     1: type=p
+ lmin=1.0000e-05-dxlp_hvt  lmax=2.001e-05            wmin=1.0000e-05-dxwp_hvt
+ wmax=9.001e-04            version=4.5               binunit=2
+ paramchk=1                mobmod=0                  capmod=2
+ igcmod=1                  igbmod=1                  geomod=0
+ diomod=1                  rdsmod=0                  rbodymod=0
+ rgatemod=0                permod=1                  acnqsmod=0
+ trnqsmod=0                tnom=25                   toxe=toxp_hvt
+ toxm=toxp_hvt             dtox=5.1e-010             epsrox=3.9
+ wint=5e-009               lint=2.5e-009             ll=0
+ wl=0                      lln=1                     wln=1
+ lw=0                      ww=0                      lwn=1
+ wwn=1                     lwl=0                     wwl=0
+ llc=0                     wlc=0                     lwc=0
+ wwc=0                     lwlc=0                    wwlc=0
+ dlc=1.44e-08              dwc=0                     xpart=1
+ toxref=3e-009             dlcig=2.5e-009            xl=-3.5e-8+dxlp_hvt
+ xw=1.5e-8+dxwp_hvt        vth0=-0.3334+dvthp_hvt    wvth0=0+dwvthp_hvt
+ lvth0=0+dlvthp_hvt        pvth0=0+dpvthp_hvt        k1=0.3231
+ k2=0.01744+dk2p_hvt       k3=-2.8                   k3b=1.2
+ w0=1e-007                 dvt0=15.61                dvt1=1.25
+ dvt2=0                    dvt0w=0                   dvt1w=0
+ dvt2w=0                   dsub=0.5                  minv=0
+ voffl=0                   dvtp0=1.09e-008           dvtp1=4
+ lpe0=2.589e-008           lpeb=0                    xj=1.7e-007
+ ngate=1e020               ndep=8.3687e017           nsd=1e020
+ phin=0                    cdsc=0                    cdscb=0
+ cdscd=0                   cit=0.0001                voff=-0.09
+ nfactor=0.5               pvoff=0+dpvoffp_hvt       eta0=0.02
+ etab=-0.1                 u0=0.007961               ua=3.88e-010
+ ub=4.553e-019             uc=-6.121e-011            vsat=114000
+ a0=2.09                   ags=0.8809                pvsat=0+dpvsatp_hvt
+ a1=0                      a2=1                      b0=0
+ b1=0                      keta=-0.03748             dwg=0
+ dwb=0                     pclm=0.15                 pdiblc1=0
+ pdiblc2=0.0001            pdiblcb=0                 drout=0
+ pvag=1.5                  delta=0.005               pscbe1=9.264e008
+ pscbe2=1e-020             fprout=200                pdits=0
+ pditsd=0                  pditsl=0                  rsh=9.68
+ rdsw=210+drdswp_hvt       rsw=210                   rdw=210
+ rdswmin=0                 rdwmin=0                  prwg=0
+ prwb=0                    wr=1                      alpha0=0
+ alpha1=0.06               beta0=12                  agidl=9e-008
+ bgidl=2.3e009             cgidl=0.5                 egidl=0.53
+ aigbacc=0.01066           bigbacc=0.001949          cigbacc=0.1416
+ nigbacc=4.05              aigbinv=0.35              bigbinv=0.03
+ cigbinv=0.006             eigbinv=1.1               nigbinv=1
+ aigc=0.005985             bigc=0.000764             cigc=0
+ aigsd=0.004783            bigsd=0.0001597           cigsd=0.001522
+ nigc=1                    poxedge=1                 pigcd=1.495
+ ntox=ntoxp_hvt            xrcrg1=12                 xrcrg2=1
+ cgso=cgop_hvt             cgdo=cgop_hvt             cgbo=0
+ cgdl=cglp_hvt             cgsl=cglp_hvt             clc=1e-007
+ cle=0.6                   cf=cfp_hvt                ckappas=0.6
+ acde=1.2                  moin=8                    noff=1.568
+ voffcv=-0.0540472         kt1=-0.2435               kt1l=0
+ kt2=-0.04696              ute=-1.543                ua1=7.27e-010
+ ub1=-3.281e-018           uc1=-6.421e-011           prt=0
+ at=256700                 jss=1.50e-07              jsws=5.60e-13
+ jswgs=9.00e-12            njs=1                     ijthsfwd=0.01
+ ijthsrev=0.01             bvs=10                    xjbvs=1
+ pbs=0.751                 cjs=cjp_hvt               mjs=0.351
+ pbsws=0.8                 cjsws=cjswp_hvt           mjsws=0.01
+ pbswgs=1.15               cjswgs=cjswgp_hvt         mjswgs=0.678
+ tpb=1.56e-03              tcj=8.59e-04              tpbsw=1.56e-03
+ tcjsw=1.86e-04            tpbswg=3.00e-04           tcjswg=4.62e-04
+ xtis=3                    dmcg=9.25e-008            dmci=9.25e-008
+ dmdg=0                    dmcgt=0                   dwj=0
+ xgw=0                     xgl=0                     rshg=0.1
+ gbmin=1e-012              rbpb=50                   rbpd=50
+ rbps=50                   rbdb=50                   rbsb=50
+ ngcon=1                   saref=0.63e-6             sbref=0.63e-6
+ kvsat=-0.95               wlod=0.8e-6               tku0=0.1
+ ku0=1.3349e-7             llodku0=1                 wlodku0=1
+ lku0=1.5807e-7            wku0=6e-7                 pku0=0
+ kvth0=-1.5e-9             stk2=6e-10                steta0=0
+ lkvth0=-1.68e-15          wkvth0=0.5e-6             pkvth0=0
+ llodvth=2                 wlodvth=1                 lodk2=2
+ lodeta0=1                 fnoimod=1                 noia=1.30e+42
+ noib=9.00e+26             noic=8.75                 em=5.00e+07
+ ef=1.13                   wpemod=wpeflag_hvt        kvth0we=-0.0028
+ lkvth0we=0                wkvth0we=0                pkvth0we=0
+ ku0we=-0.0045             lku0we=4.50e-10           wku0we=0
+ pku0we=0                  k2we=0.00045              wk2we=0
+ web=-180                  wec=-3000                 scref=1.00e-06
+ ud=0                      tnoimod=0                 minr=1e-3

     2: type=p
+ lmin=5.0000e-07-dxlp_hvt  lmax=1.0000e-05-dxlp_hvt  wmin=1.0000e-05-dxwp_hvt
+ wmax=9.001e-04            version=4.5               binunit=2
+ paramchk=1                mobmod=0                  capmod=2
+ igcmod=1                  igbmod=1                  geomod=0
+ diomod=1                  rdsmod=0                  rbodymod=0
+ rgatemod=0                permod=1                  acnqsmod=0
+ trnqsmod=0                tnom=25                   toxe=toxp_hvt
+ toxm=toxp_hvt             dtox=5.1e-010             epsrox=3.9
+ wint=5e-009               lint=2.5e-009             ll=0
+ wl=0                      lln=1                     wln=1
+ lw=0                      ww=0                      lwn=1
+ wwn=1                     lwl=0                     wwl=0
+ llc=0                     wlc=0                     lwc=0
+ wwc=0                     lwlc=0                    wwlc=0
+ dlc=1.44e-08              dwc=0                     xpart=1
+ toxref=3e-009             dlcig=2.5e-009            xl=-3.5e-8+dxlp_hvt
+ xw=1.5e-8+dxwp_hvt        vth0=-0.3334+dvthp_hvt    wvth0=0+dwvthp_hvt
+ lvth0=0+dlvthp_hvt        pvth0=0+dpvthp_hvt        k1=0.3231
+ k2=0.017135916+dk2p_hvt   lk2=3.0286787e-009        wk2=-4.2491934e-025
+ pk2=4.2321966e-030        k3=-2.8                   k3b=1.2
+ w0=1e-007                 dvt0=15.61                dvt1=1.25
+ dvt2=0                    dvt0w=0                   dvt1w=0
+ dvt2w=0                   dsub=0.5                  minv=0
+ voffl=0                   dvtp0=1.09e-008           dvtp1=4
+ lpe0=2.589e-008           lpeb=0                    xj=1.7e-007
+ ngate=1e020               ndep=8.3687e017           nsd=1e020
+ phin=0                    cdsc=0                    cdscb=0
+ cdscd=0                   cit=0.0001                voff=-0.09
+ nfactor=0.48226337        pvoff=0+dpvoffp_hvt       lnfactor=1.7665685e-007
+ wnfactor=-2.7194838e-023  pnfactor=2.7086058e-028   eta0=0.016126316
+ leta0=3.8581895e-008      weta0=-6.7987094e-024     peta0=6.7715146e-029
+ etab=-0.1                 u0=0.0078989242           lu0=6.1827486e-010
+ wu0=-1.0622983e-025       pu0=1.0580491e-030        ua=4.0287979e-010
+ lua=-1.482027e-016        wua=2.5327166e-032        pua=-2.5225857e-037
+ ub=4.2049979e-019         lub=3.466101e-025         wub=-4.7175523e-041
+ pub=4.6986821e-046        uc=-6.2692168e-011        luc=1.4762397e-017
+ wuc=-3.1658958e-033       puc=3.1532322e-038        vsat=114000
+ a0=2.1002168              la0=-1.0175975e-007       pvsat=0+dpvsatp_hvt
+ wa0=1.3597419e-023        pa0=-1.3543029e-028       ags=0.84448253
+ lags=3.6271804e-007       wags=-5.4389675e-023      pags=5.4172116e-028
+ a1=0                      a2=1                      b0=0
+ b1=0                      keta=-0.034635263         lketa=-2.8333579e-008
+ wketa=3.3993547e-024      pketa=-3.3857573e-029     dwg=0
+ dwb=0                     pclm=0.10884211           lpclm=4.0993263e-007
+ wpclm=-5.4389675e-023     ppclm=5.4172116e-028      pdiblc1=-9.6842105e-020
+ lpdiblc1=9.6454737e-025   wpdiblc1=-1.8870209e-040  ppdiblc1=1.8794728e-045
+ pdiblc2=3.2210526e-005    lpdiblc2=6.7518316e-010   wpdiblc2=-1.0622983e-025
+ ppdiblc2=1.0580491e-030   pdiblcb=0                 drout=0
+ pvag=1.5                  delta=0.0047578947        ldelta=2.4113684e-009
+ wdelta=-4.2491934e-025    pdelta=4.2321966e-030     pscbe1=9.264e008
+ pscbe2=1e-020             fprout=200                pdits=0
+ pditsd=0                  pditsl=0                  rsh=9.68
+ rdsw=210+drdswp_hvt       rsw=210                   rdw=210
+ rdswmin=0                 rdwmin=0                  prwg=0
+ prwb=0                    wr=1                      alpha0=0
+ alpha1=0.06               beta0=12                  agidl=9e-008
+ bgidl=2.3e009             cgidl=0.5                 egidl=0.53
+ aigbacc=0.01066           bigbacc=0.001949          cigbacc=0.1416
+ nigbacc=4.05              aigbinv=0.35              bigbinv=0.03
+ cigbinv=0.006             eigbinv=1.1               nigbinv=1
+ aigc=0.005985             bigc=0.000764             cigc=0
+ aigsd=0.004783            bigsd=0.0001597           cigsd=0.001522
+ nigc=1                    poxedge=1                 pigcd=1.495
+ ntox=ntoxp_hvt            xrcrg1=12                 xrcrg2=1
+ cgso=cgop_hvt             cgdo=cgop_hvt             cgbo=0
+ cgdl=cglp_hvt             cgsl=cglp_hvt             clc=1e-007
+ cle=0.6                   cf=cfp_hvt                ckappas=0.6
+ acde=1.2                  moin=8                    noff=1.568
+ voffcv=-0.0540472         kt1=-0.2435               kt1l=0
+ kt2=-0.04696              ute=-1.5504568            lute=7.4270147e-008
+ wute=-1.3597419e-023      pute=1.3543029e-028       ua1=7.27e-010
+ ub1=-3.31228e-018         lub1=3.115488e-025        wub1=-4.7175523e-041
+ pub1=4.6986821e-046       uc1=-6.421e-011           prt=0
+ at=256700                 jss=1.50e-07              jsws=5.60e-13
+ jswgs=9.00e-12            njs=1                     ijthsfwd=0.01
+ ijthsrev=0.01             bvs=10                    xjbvs=1
+ pbs=0.751                 cjs=cjp_hvt               mjs=0.351
+ pbsws=0.8                 cjsws=cjswp_hvt           mjsws=0.01
+ pbswgs=1.15               cjswgs=cjswgp_hvt         mjswgs=0.678
+ tpb=1.56e-03              tcj=8.59e-04              tpbsw=1.56e-03
+ tcjsw=1.86e-04            tpbswg=3.00e-04           tcjswg=4.62e-04
+ xtis=3                    dmcg=9.25e-008            dmci=9.25e-008
+ dmdg=0                    dmcgt=0                   dwj=0
+ xgw=0                     xgl=0                     rshg=0.1
+ gbmin=1e-012              rbpb=50                   rbpd=50
+ rbps=50                   rbdb=50                   rbsb=50
+ ngcon=1                   saref=0.63e-6             sbref=0.63e-6
+ kvsat=-0.95               wlod=0.8e-6               tku0=0.1
+ ku0=1.3349e-7             llodku0=1                 wlodku0=1
+ lku0=1.5807e-7            wku0=6e-7                 pku0=0
+ kvth0=-1.5e-9             stk2=6e-10                steta0=0
+ lkvth0=-1.68e-15          wkvth0=0.5e-6             pkvth0=0
+ llodvth=2                 wlodvth=1                 lodk2=2
+ lodeta0=1                 fnoimod=1                 noia=1.30e+42
+ noib=9.00e+26             noic=8.75                 em=5.00e+07
+ ef=1.13                   wpemod=wpeflag_hvt        kvth0we=-0.0028
+ lkvth0we=0                wkvth0we=0                pkvth0we=0
+ ku0we=-0.0045             lku0we=4.50e-10           wku0we=0
+ pku0we=0                  k2we=0.00045              wk2we=0
+ web=-180                  wec=-3000                 scref=1.00e-06
+ ud=0                      tnoimod=0                 minr=1e-3

     3: type=p
+ lmin=2.4000e-07-dxlp_hvt  lmax=5.0000e-07-dxlp_hvt  wmin=1.0000e-05-dxwp_hvt
+ wmax=9.001e-04            version=4.5               binunit=2
+ paramchk=1                mobmod=0                  capmod=2
+ igcmod=1                  igbmod=1                  geomod=0
+ diomod=1                  rdsmod=0                  rbodymod=0
+ rgatemod=0                permod=1                  acnqsmod=0
+ trnqsmod=0                tnom=25                   toxe=toxp_hvt
+ toxm=toxp_hvt             dtox=5.1e-010             epsrox=3.9
+ wint=5e-009               lint=2.5e-009             ll=0
+ wl=0                      lln=1                     wln=1
+ lw=0                      ww=0                      lwn=1
+ wwn=1                     lwl=0                     wwl=0
+ llc=0                     wlc=0                     lwc=0
+ wwc=0                     lwlc=0                    wwlc=0
+ dlc=1.44e-08              dwc=0                     xpart=1
+ toxref=3e-009             dlcig=2.5e-009            xl=-3.5e-8+dxlp_hvt
+ xw=1.5e-8+dxwp_hvt        vth0=-0.3334+dvthp_hvt    wvth0=0+dwvthp_hvt
+ lvth0=0+dlvthp_hvt        pvth0=0+dpvthp_hvt        k1=0.3231
+ k2=0.019858462+dk2p_hvt   lk2=1.7763077e-009        k3=-2.8
+ k3b=1.2                   w0=1e-007                 dvt0=15.61
+ dvt1=1.25                 dvt2=0                    dvt0w=0
+ dvt1w=0                   dvt2w=0                   dsub=0.5
+ minv=0                    voffl=0                   dvtp0=1.09e-008
+ dvtp1=4                   lpe0=2.589e-008           lpeb=0
+ xj=1.7e-007               ngate=1e020               ndep=8.3687e017
+ nsd=1e020                 phin=0                    cdsc=0
+ cdscb=0                   cdscd=0                   cit=0.0001
+ voff=-0.09                pvoff=0+dpvoffp_hvt       nfactor=0.70653077
+ lnfactor=7.3493846e-008   eta0=0.038461538          leta0=2.8307692e-008
+ etab=-0.1                 u0=0.009186               lu0=2.622e-011
+ ua=8.07e-011              ub=1.084e-018             lub=4.14e-026
+ uc=-9.4346154e-011        luc=2.9323231e-017        vsat=114000
+ a0=2.139                  la0=-1.196e-007           pvsat=0+dpvsatp_hvt
+ ags=0.58146154            lags=4.8370769e-007       a1=0
+ a2=1                      b0=0                      b1=0
+ keta=-0.077406923         lketa=-8.6586154e-009     dwg=0
+ dwb=0                     pclm=1.1538462            lpclm=-7.0769231e-008
+ pdiblc1=2e-018            pdiblc2=0.0015            pdiblcb=0
+ drout=0                   pvag=1.5                  delta=0.01
+ pscbe1=9.264e008          pscbe2=1e-020             fprout=200
+ pdits=0                   pditsd=0                  pditsl=0
+ rsh=9.68                  rdsw=210+drdswp_hvt       rsw=210
+ rdw=210                   rdswmin=0                 rdwmin=0
+ prwg=0                    prwb=0                    wr=1
+ alpha0=0                  alpha1=0.06               beta0=12
+ agidl=9e-008              bgidl=2.3e009             cgidl=0.5
+ egidl=0.53                aigbacc=0.01066           bigbacc=0.001949
+ cigbacc=0.1416            nigbacc=4.05              aigbinv=0.35
+ bigbinv=0.03              cigbinv=0.006             eigbinv=1.1
+ nigbinv=1                 aigc=0.005985             bigc=0.000764
+ cigc=0                    aigsd=0.004783            bigsd=0.0001597
+ cigsd=0.001522            nigc=1                    poxedge=1
+ pigcd=1.495               ntox=ntoxp_hvt            xrcrg1=12
+ xrcrg2=1                  cgso=cgop_hvt             cgdo=cgop_hvt
+ cgbo=0                    cgdl=cglp_hvt             cgsl=cglp_hvt
+ clc=1e-007                cle=0.6                   cf=cfp_hvt
+ ckappas=0.6               acde=1.2                  moin=8
+ noff=1.568                voffcv=-0.0540472         kt1=-0.2435
+ kt1l=0                    kt2=-0.04696              ute=-1.4166923
+ lute=1.2738462e-008       ua1=7.27e-010             ub1=-2.8196154e-018
+ lub1=8.4923077e-026       uc1=-6.421e-011           prt=0
+ at=351469.23              lat=-0.043593846          jss=1.50e-07
+ jsws=5.60e-13             jswgs=9.00e-12            njs=1
+ ijthsfwd=0.01             ijthsrev=0.01             bvs=10
+ xjbvs=1                   pbs=0.751                 cjs=cjp_hvt
+ mjs=0.351                 pbsws=0.8                 cjsws=cjswp_hvt
+ mjsws=0.01                pbswgs=1.15               cjswgs=cjswgp_hvt
+ mjswgs=0.678              tpb=1.56e-03              tcj=8.59e-04
+ tpbsw=1.56e-03            tcjsw=1.86e-04            tpbswg=3.00e-04
+ tcjswg=4.62e-04           xtis=3                    dmcg=9.25e-008
+ dmci=9.25e-008            dmdg=0                    dmcgt=0
+ dwj=0                     xgw=0                     xgl=0
+ rshg=0.1                  gbmin=1e-012              rbpb=50
+ rbpd=50                   rbps=50                   rbdb=50
+ rbsb=50                   ngcon=1                   saref=0.63e-6
+ sbref=0.63e-6             kvsat=-0.95               wlod=0.8e-6
+ tku0=0.1                  ku0=1.3349e-7             llodku0=1
+ wlodku0=1                 lku0=1.5807e-7            wku0=6e-7
+ pku0=0                    kvth0=-1.5e-9             stk2=6e-10
+ steta0=0                  lkvth0=-1.68e-15          wkvth0=0.5e-6
+ pkvth0=0                  llodvth=2                 wlodvth=1
+ lodk2=2                   lodeta0=1                 fnoimod=1
+ noia=1.30e+42             noib=9.00e+26             noic=8.75
+ em=5.00e+07               ef=1.13                   wpemod=wpeflag_hvt
+ kvth0we=-0.0028           lkvth0we=0                wkvth0we=0
+ pkvth0we=0                ku0we=-0.0045             lku0we=4.50e-10
+ wku0we=0                  pku0we=0                  k2we=0.00045
+ wk2we=0                   web=-180                  wec=-3000
+ scref=1.00e-06            ud=0                      tnoimod=0
+ minr=1e-3

     4: type=p
+ lmin=1.000e-07            lmax=2.4000e-07-dxlp_hvt  wmin=1.0000e-05-dxwp_hvt
+ wmax=9.001e-04            version=4.5               binunit=2
+ paramchk=1                mobmod=0                  capmod=2
+ igcmod=1                  igbmod=1                  geomod=0
+ diomod=1                  rdsmod=0                  rbodymod=0
+ rgatemod=0                permod=1                  acnqsmod=0
+ trnqsmod=0                tnom=25                   toxe=toxp_hvt
+ toxm=toxp_hvt             dtox=5.1e-010             epsrox=3.9
+ wint=5e-009               lint=2.5e-009             ll=0
+ wl=0                      lln=1                     wln=1
+ lw=0                      ww=0                      lwn=1
+ wwn=1                     lwl=0                     wwl=0
+ llc=0                     wlc=0                     lwc=0
+ wwc=0                     lwlc=0                    wwlc=0
+ dlc=1.44e-08              dwc=0                     xpart=1
+ toxref=3e-009             dlcig=2.5e-009            xl=-3.5e-8+dxlp_hvt
+ xw=1.5e-8+dxwp_hvt        vth0=-0.3304+dvthp_hvt    wvth0=0+dwvthp_hvt
+ lvth0=-6e-010+dlvthp_hvt  pvth0=0+dpvthp_hvt        k1=0.29918571
+ lk1=4.7828571e-009        k2=0.018437143+dk2p_hvt   lk2=2.0605714e-009
+ k3=-2.8                   k3b=1.2                   w0=1e-007
+ dvt0=15.61                dvt1=1.25                 dvt2=0
+ dvt0w=0                   dvt1w=0                   dvt2w=0
+ dsub=0.5                  minv=0                    voffl=0
+ dvtp0=1.09e-008           dvtp1=4                   lpe0=2.589e-008
+ lpeb=0                    xj=1.7e-007               ngate=1e020
+ ndep=8.3687e017           nsd=1e020                 phin=0
+ cdsc=0                    cdscb=0                   cdscd=0
+ cit=0.0001                voff=-0.085114286         lvoff=-9.7714286e-010
+ nfactor=0.42042857        pvoff=0+dpvoffp_hvt       lnfactor=1.3071429e-007
+ eta0=0.15642857           leta0=4.7142857e-009      etab=-0.1
+ u0=0.010229571            lu0=-1.8249429e-010       ua=2.5037143e-010
+ lua=-3.3934286e-017       ub=1.0617143e-018         lub=4.5857143e-026
+ uc=-7.0571429e-012        luc=1.1865429e-017        vsat=114000
+ a0=1.4021429              la0=2.7771429e-008        pvsat=0+dpvsatp_hvt
+ ags=1.737                 lags=2.526e-007           a1=0
+ a2=1                      b0=0                      b1=0
+ keta=-0.16551743          lketa=8.9634857e-009      dwg=0
+ dwb=0                     pclm=1.0142857            lpclm=-4.2857143e-008
+ pdiblc1=2e-018            pdiblc2=0.0015            pdiblcb=0
+ drout=0                   pvag=1.5                  delta=0.01
+ pscbe1=9.264e008          pscbe2=1e-020             fprout=200
+ pdits=0                   pditsd=0                  pditsl=0
+ rsh=9.68                  rdsw=210+drdswp_hvt       rsw=210
+ rdw=210                   rdswmin=0                 rdwmin=0
+ prwg=0                    prwb=0                    wr=1
+ alpha0=0                  alpha1=0.06               beta0=12
+ agidl=9e-008              bgidl=2.3e009             cgidl=0.5
+ egidl=0.53                aigbacc=0.01066           bigbacc=0.001949
+ cigbacc=0.1416            nigbacc=4.05              aigbinv=0.35
+ bigbinv=0.03              cigbinv=0.006             eigbinv=1.1
+ nigbinv=1                 aigc=0.005985             bigc=0.000764
+ cigc=0                    aigsd=0.004783            bigsd=0.0001597
+ cigsd=0.001522            nigc=1                    poxedge=1
+ pigcd=1.495               ntox=ntoxp_hvt            xrcrg1=12
+ xrcrg2=1                  cgso=cgop_hvt             cgdo=cgop_hvt
+ cgbo=0                    cgdl=cglp_hvt             cgsl=cglp_hvt
+ clc=1e-007                cle=0.6                   cf=cfp_hvt
+ ckappas=0.6               acde=1.2                  moin=8
+ noff=1.568                voffcv=-0.0540472         kt1=-0.22044286
+ lkt1=-4.6114286e-009      kt1l=0                    kt2=-0.04696
+ ute=-1.4301429            lute=1.5428571e-008       ua1=7.27e-010
+ ub1=-2.7691429e-018       lub1=7.4828571e-026       uc1=-6.421e-011
+ prt=0                     at=151131.43              lat=-0.0035262857
+ jss=1.50e-07              jsws=5.60e-13             jswgs=9.00e-12
+ njs=1                     ijthsfwd=0.01             ijthsrev=0.01
+ bvs=10                    xjbvs=1                   pbs=0.751
+ cjs=cjp_hvt               mjs=0.351                 pbsws=0.8
+ cjsws=cjswp_hvt           mjsws=0.01                pbswgs=1.15
+ cjswgs=cjswgp_hvt         mjswgs=0.678              tpb=1.56e-03
+ tcj=8.59e-04              tpbsw=1.56e-03            tcjsw=1.86e-04
+ tpbswg=3.00e-04           tcjswg=4.62e-04           xtis=3
+ dmcg=9.25e-008            dmci=9.25e-008            dmdg=0
+ dmcgt=0                   dwj=0                     xgw=0
+ xgl=0                     rshg=0.1                  gbmin=1e-012
+ rbpb=50                   rbpd=50                   rbps=50
+ rbdb=50                   rbsb=50                   ngcon=1
+ saref=0.63e-6             sbref=0.63e-6             kvsat=-0.95
+ wlod=0.8e-6               tku0=0.1                  ku0=1.3349e-7
+ llodku0=1                 wlodku0=1                 lku0=1.5807e-7
+ wku0=6e-7                 pku0=0                    kvth0=-1.5e-9
+ stk2=6e-10                steta0=0                  lkvth0=-1.68e-15
+ wkvth0=0.5e-6             pkvth0=0                  llodvth=2
+ wlodvth=1                 lodk2=2                   lodeta0=1
+ fnoimod=1                 noia=1.30e+42             noib=9.00e+26
+ noic=8.75                 em=5.00e+07               ef=1.13
+ wpemod=wpeflag_hvt        kvth0we=-0.0028           lkvth0we=0
+ wkvth0we=0                pkvth0we=0                ku0we=-0.0045
+ lku0we=4.50e-10           wku0we=0                  pku0we=0
+ k2we=0.00045              wk2we=0                   web=-180
+ wec=-3000                 scref=1.00e-06            ud=0
+ tnoimod=0                 minr=1e-3

     5: type=p
+ lmin=1.0000e-05-dxlp_hvt  lmax=2.001e-05            wmin=1.0000e-06-dxwp_hvt
+ wmax=1.0000e-05-dxwp_hvt  version=4.5               binunit=2
+ paramchk=1                mobmod=0                  capmod=2
+ igcmod=1                  igbmod=1                  geomod=0
+ diomod=1                  rdsmod=0                  rbodymod=0
+ rgatemod=0                permod=1                  acnqsmod=0
+ trnqsmod=0                tnom=25                   toxe=toxp_hvt
+ toxm=toxp_hvt             dtox=5.1e-010             epsrox=3.9
+ wint=5e-009               lint=2.5e-009             ll=0
+ wl=0                      lln=1                     wln=1
+ lw=0                      ww=0                      lwn=1
+ wwn=1                     lwl=0                     wwl=0
+ llc=0                     wlc=0                     lwc=0
+ wwc=0                     lwlc=0                    wwlc=0
+ dlc=1.44e-08              dwc=0                     xpart=1
+ toxref=3e-009             dlcig=2.5e-009            xl=-3.5e-8+dxlp_hvt
+ xw=1.5e-8+dxwp_hvt        vth0=-0.3334+dvthp_hvt    wvth0=0+dwvthp_hvt
+ lvth0=0+dlvthp_hvt        pvth0=0+dpvthp_hvt        k1=0.3231
+ k2=0.018005033+dk2p_hvt   wk2=-5.6531585e-009       k3=-2.8
+ k3b=1.2                   w0=1e-007                 dvt0=15.61
+ dvt1=1.25                 dvt2=0                    dvt0w=0
+ dvt1w=0                   dvt2w=0                   dsub=0.5
+ minv=0                    voffl=0                   dvtp0=1.09e-008
+ dvtp1=4                   lpe0=2.589e-008           lpeb=0
+ xj=1.7e-007               ngate=1e020               ndep=8.3687e017
+ nsd=1e020                 phin=0                    cdsc=0
+ cdscb=0                   cdscd=0                   cit=0.0001
+ voff=-0.09                pvoff=0+dpvoffp_hvt       nfactor=0.5
+ eta0=0.02                 etab=-0.1                 u0=0.0080321317
+ wu0=-7.1167232e-010       ua=3.88e-010              ub=4.53089e-019
+ wub=2.2121055e-026        uc=-5.9433383e-011        wuc=-1.777505e-017
+ vsat=114000               a0=2.09                   pvsat=0+dpvsatp_hvt
+ ags=0.87696933            wags=3.932632e-008        a1=0
+ a2=1                      b0=0                      b1=0
+ keta=-0.04133049          wketa=3.8524152e-008      dwg=0
+ dwb=0                     pclm=0.15                 pdiblc1=0
+ pdiblc2=0.00010044667     wpdiblc2=-4.4689e-012     pdiblcb=0
+ drout=0                   pvag=1.5                  delta=0.005
+ pscbe1=9.264e008          pscbe2=1e-020             fprout=200
+ pdits=0                   pditsd=0                  pditsl=0
+ rsh=9.68                  rdsw=210+drdswp_hvt       rsw=210
+ rdw=210                   rdswmin=0                 rdwmin=0
+ prwg=0                    prwb=0                    wr=1
+ alpha0=0                  alpha1=0.06               beta0=12
+ agidl=9e-008              bgidl=2.3e009             cgidl=0.5
+ egidl=0.53                aigbacc=0.01066           bigbacc=0.001949
+ cigbacc=0.1416            nigbacc=4.05              aigbinv=0.35
+ bigbinv=0.03              cigbinv=0.006             eigbinv=1.1
+ nigbinv=1                 aigc=0.005985             bigc=0.000764
+ cigc=0                    aigsd=0.0047661383        waigsd=1.6870098e-010
+ bigsd=0.0001597           cigsd=0.001522            nigc=1
+ poxedge=1                 pigcd=1.495               ntox=ntoxp_hvt
+ xrcrg1=12                 xrcrg2=1                  cgso=cgop_hvt
+ cgdo=cgop_hvt             cgbo=0                    cgdl=cglp_hvt
+ cgsl=cglp_hvt             clc=1e-007                cle=0.6
+ cf=cfp_hvt                ckappas=0.6               acde=1.2
+ moin=8                    noff=1.568                voffcv=-0.0540472
+ kt1=-0.2435               kt1l=0                    kt2=-0.04696
+ ute=-1.543                ua1=7.27e-010             ub1=-3.281e-018
+ uc1=-6.421e-011           prt=0                     at=256700
+ jss=1.50e-07              jsws=5.60e-13             jswgs=9.00e-12
+ njs=1                     ijthsfwd=0.01             ijthsrev=0.01
+ bvs=10                    xjbvs=1                   pbs=0.751
+ cjs=cjp_hvt               mjs=0.351                 pbsws=0.8
+ cjsws=cjswp_hvt           mjsws=0.01                pbswgs=1.15
+ cjswgs=cjswgp_hvt         mjswgs=0.678              tpb=1.56e-03
+ tcj=8.59e-04              tpbsw=1.56e-03            tcjsw=1.86e-04
+ tpbswg=3.00e-04           tcjswg=4.62e-04           xtis=3
+ dmcg=9.25e-008            dmci=9.25e-008            dmdg=0
+ dmcgt=0                   dwj=0                     xgw=0
+ xgl=0                     rshg=0.1                  gbmin=1e-012
+ rbpb=50                   rbpd=50                   rbps=50
+ rbdb=50                   rbsb=50                   ngcon=1
+ saref=0.63e-6             sbref=0.63e-6             kvsat=-0.95
+ wlod=0.8e-6               tku0=0.1                  ku0=1.3349e-7
+ llodku0=1                 wlodku0=1                 lku0=1.5807e-7
+ wku0=6e-7                 pku0=0                    kvth0=-1.5e-9
+ stk2=6e-10                steta0=0                  lkvth0=-1.68e-15
+ wkvth0=0.5e-6             pkvth0=0                  llodvth=2
+ wlodvth=1                 lodk2=2                   lodeta0=1
+ fnoimod=1                 noia=1.30e+42             noib=9.00e+26
+ noic=8.75                 em=5.00e+07               ef=1.13
+ wpemod=wpeflag_hvt        kvth0we=-0.0028           lkvth0we=0
+ wkvth0we=0                pkvth0we=0                ku0we=-0.0045
+ lku0we=4.50e-10           wku0we=0                  pku0we=0
+ k2we=0.00045              wk2we=0                   web=-180
+ wec=-3000                 scref=1.00e-06            ud=0
+ tnoimod=0                 minr=1e-3

     6: type=p
+ lmin=5.0000e-07-dxlp_hvt  lmax=1.0000e-05-dxlp_hvt  wmin=1.0000e-06-dxwp_hvt
+ wmax=1.0000e-05-dxwp_hvt  version=4.5               binunit=2
+ paramchk=1                mobmod=0                  capmod=2
+ igcmod=1                  igbmod=1                  geomod=0
+ diomod=1                  rdsmod=0                  rbodymod=0
+ rgatemod=0                permod=1                  acnqsmod=0
+ trnqsmod=0                tnom=25                   toxe=toxp_hvt
+ toxm=toxp_hvt             dtox=5.1e-010             epsrox=3.9
+ wint=5e-009               lint=2.5e-009             ll=0
+ wl=0                      lln=1                     wln=1
+ lw=0                      ww=0                      lwn=1
+ wwn=1                     lwl=0                     wwl=0
+ llc=0                     wlc=0                     lwc=0
+ wwc=0                     lwlc=0                    wwlc=0
+ dlc=1.44e-08              dwc=0                     xpart=1
+ toxref=3e-009             dlcig=2.5e-009            xl=-3.5e-8+dxlp_hvt
+ xw=1.5e-8+dxwp_hvt        vth0=-0.3334+dvthp_hvt    wvth0=0+dwvthp_hvt
+ lvth0=0+dlvthp_hvt        pvth0=0+dpvthp_hvt        k1=0.3231
+ k2=0.017707924+dk2p_hvt   lk2=2.9592072e-009        wk2=-5.7229439e-009
+ pk2=6.950626e-016         k3=-2.8                   k3b=1.2
+ w0=1e-007                 dvt0=15.61                dvt1=1.25
+ dvt2=0                    dvt0w=0                   dvt1w=0
+ dvt2w=0                   dsub=0.5                  minv=0
+ voffl=0                   dvtp0=1.09e-008           dvtp1=4
+ lpe0=2.589e-008           lpeb=0                    xj=1.7e-007
+ ngate=1e020               ndep=8.3687e017           nsd=1e020
+ phin=0                    cdsc=0                    cdscb=0
+ cdscd=0                   cit=0.0001                voff=-0.09
+ nfactor=0.48174808        pvoff=0+dpvoffp_hvt       lnfactor=1.8178913e-007
+ wnfactor=5.1554642e-009   pnfactor=-5.1348423e-014  eta0=0.016126316
+ leta0=3.8581895e-008      weta0=-7.5074961e-025     peta0=7.4774661e-030
+ etab=-0.1                 u0=0.007965833            lu0=6.6033475e-010
+ wu0=-6.694224e-010        pu0=-4.2080922e-016       ua=4.0287979e-010
+ lua=-1.482027e-016        wua=2.7967602e-033        pua=-2.7855732e-038
+ ub=4.1818173e-019         lub=3.476764e-025         wub=2.319218e-026
+ pub=-1.0668403e-032       uc=-6.0829526e-011        luc=1.3905582e-017
+ wuc=-1.8635736e-017       puc=8.5724387e-024        vsat=114000
+ a0=2.1002168              la0=-1.0175975e-007       pvsat=0+dpvsatp_hvt
+ wa0=1.5014992e-024        pa0=-1.4954932e-029       ags=0.84036153
+ lags=3.6461369e-007       wags=4.1230542e-008       pags=-1.8966049e-014
+ a1=0                      a2=1                      b0=0
+ b1=0                      keta=-0.038672198         lketa=-2.6476589e-008
+ wketa=4.0389532e-008      pketa=-1.8579185e-014     dwg=0
+ dwb=0                     pclm=0.10884211           lpclm=4.0993263e-007
+ wpclm=-6.0059969e-024     ppclm=5.9819729e-029      pdiblc1=-9.6842105e-020
+ lpdiblc1=9.6454737e-025   wpdiblc1=-2.0837488e-041  ppdiblc1=2.0754138e-046
+ pdiblc2=3.2678821e-005    lpdiblc2=6.7496774e-010   wpdiblc2=-4.6852888e-012
+ ppdiblc2=2.1552329e-018   pdiblcb=0                 drout=0
+ pvag=1.5                  delta=0.0047578947        ldelta=2.4113684e-009
+ wdelta=-4.6921851e-026    pdelta=4.6734163e-031     pscbe1=9.264e008
+ pscbe2=1e-020             fprout=200                pdits=0
+ pditsd=0                  pditsl=0                  rsh=9.68
+ rdsw=210+drdswp_hvt       rsw=210                   rdw=210
+ rdswmin=0                 rdwmin=0                  prwg=0
+ prwb=0                    wr=1                      alpha0=0
+ alpha1=0.06               beta0=12                  agidl=9e-008
+ bgidl=2.3e009             cgidl=0.5                 egidl=0.53
+ aigbacc=0.01066           bigbacc=0.001949          cigbacc=0.1416
+ nigbacc=4.05              aigbinv=0.35              bigbinv=0.03
+ cigbinv=0.006             eigbinv=1.1               nigbinv=1
+ aigc=0.005985             bigc=0.000764             cigc=0
+ aigsd=0.0047661383        waigsd=1.6870098e-010     bigsd=0.0001597
+ cigsd=0.001522            nigc=1                    poxedge=1
+ pigcd=1.495               ntox=ntoxp_hvt            xrcrg1=12
+ xrcrg2=1                  cgso=cgop_hvt             cgdo=cgop_hvt
+ cgbo=0                    cgdl=cglp_hvt             cgsl=cglp_hvt
+ clc=1e-007                cle=0.6                   cf=cfp_hvt
+ ckappas=0.6               acde=1.2                  moin=8
+ noff=1.568                voffcv=-0.0540472         kt1=-0.2435
+ kt1l=0                    kt2=-0.04696              ute=-1.5502892
+ lute=7.2600677e-008       wute=-1.6770135e-009      pute=1.6703055e-014
+ ua1=7.27e-010             ub1=-3.3134641e-018       lub1=3.233428e-025
+ wub1=1.1847289e-026       pub1=-1.17999e-031        uc1=-6.421e-011
+ prt=0                     at=256755.69              lat=-0.00055469512
+ wat=-0.00055720127        pat=5.5497246e-009        jss=1.50e-07
+ jsws=5.60e-13             jswgs=9.00e-12            njs=1
+ ijthsfwd=0.01             ijthsrev=0.01             bvs=10
+ xjbvs=1                   pbs=0.751                 cjs=cjp_hvt
+ mjs=0.351                 pbsws=0.8                 cjsws=cjswp_hvt
+ mjsws=0.01                pbswgs=1.15               cjswgs=cjswgp_hvt
+ mjswgs=0.678              tpb=1.56e-03              tcj=8.59e-04
+ tpbsw=1.56e-03            tcjsw=1.86e-04            tpbswg=3.00e-04
+ tcjswg=4.62e-04           xtis=3                    dmcg=9.25e-008
+ dmci=9.25e-008            dmdg=0                    dmcgt=0
+ dwj=0                     xgw=0                     xgl=0
+ rshg=0.1                  gbmin=1e-012              rbpb=50
+ rbpd=50                   rbps=50                   rbdb=50
+ rbsb=50                   ngcon=1                   saref=0.63e-6
+ sbref=0.63e-6             kvsat=-0.95               wlod=0.8e-6
+ tku0=0.1                  ku0=1.3349e-7             llodku0=1
+ wlodku0=1                 lku0=1.5807e-7            wku0=6e-7
+ pku0=0                    kvth0=-1.5e-9             stk2=6e-10
+ steta0=0                  lkvth0=-1.68e-15          wkvth0=0.5e-6
+ pkvth0=0                  llodvth=2                 wlodvth=1
+ lodk2=2                   lodeta0=1                 fnoimod=1
+ noia=1.30e+42             noib=9.00e+26             noic=8.75
+ em=5.00e+07               ef=1.13                   wpemod=wpeflag_hvt
+ kvth0we=-0.0028           lkvth0we=0                wkvth0we=0
+ pkvth0we=0                ku0we=-0.0045             lku0we=4.50e-10
+ wku0we=0                  pku0we=0                  k2we=0.00045
+ wk2we=0                   web=-180                  wec=-3000
+ scref=1.00e-06            ud=0                      tnoimod=0
+ minr=1e-3

     7: type=p
+ lmin=2.4000e-07-dxlp_hvt  lmax=5.0000e-07-dxlp_hvt  wmin=1.0000e-06-dxwp_hvt
+ wmax=1.0000e-05-dxwp_hvt  version=4.5               binunit=2
+ paramchk=1                mobmod=0                  capmod=2
+ igcmod=1                  igbmod=1                  geomod=0
+ diomod=1                  rdsmod=0                  rbodymod=0
+ rgatemod=0                permod=1                  acnqsmod=0
+ trnqsmod=0                tnom=25                   toxe=toxp_hvt
+ toxm=toxp_hvt             dtox=5.1e-010             epsrox=3.9
+ wint=5e-009               lint=2.5e-009             ll=0
+ wl=0                      lln=1                     wln=1
+ lw=0                      ww=0                      lwn=1
+ wwn=1                     lwl=0                     wwl=0
+ llc=0                     wlc=0                     lwc=0
+ wwc=0                     lwlc=0                    wwlc=0
+ dlc=1.44e-08              dwc=0                     xpart=1
+ toxref=3e-009             dlcig=2.5e-009            xl=-3.5e-8+dxlp_hvt
+ xw=1.5e-8+dxwp_hvt        vth0=-0.3334+dvthp_hvt    wvth0=0+dwvthp_hvt
+ lvth0=0+dlvthp_hvt        pvth0=0+dpvthp_hvt        k1=0.3231
+ k2=0.020145445+dk2p_hvt   lk2=1.8379477e-009        wk2=-2.8712683e-009
+ pk2=-6.167082e-016        k3=-2.8                   k3b=1.2
+ w0=1e-007                 dvt0=15.61                dvt1=1.25
+ dvt2=0                    dvt0w=0                   dvt1w=0
+ dvt2w=0                   dsub=0.5                  minv=0
+ voffl=0                   dvtp0=1.09e-008           dvtp1=4
+ lpe0=2.589e-008           lpeb=0                    xj=1.7e-007
+ ngate=1e020               ndep=8.3687e017           nsd=1e020
+ phin=0                    cdsc=0                    cdscb=0
+ cdscd=0                   cit=0.0001                voff=-0.09
+ nfactor=0.72535863        pvoff=0+dpvoffp_hvt       lnfactor=6.9728274e-008
+ wnfactor=-1.8837273e-007  pnfactor=3.7674546e-014   eta0=0.039346282
+ leta0=2.790071e-008       weta0=-8.8518596e-009     peta0=4.0718554e-015
+ etab=-0.1                 u0=0.0093277565           lu0=3.3849926e-011
+ wu0=-1.4182742e-009       pu0=-7.6337406e-017       ua=8.07e-011
+ ub=1.0906141e-018         lub=3.8357513e-026        wub=-6.6174096e-026
+ pub=3.0440084e-032        uc=-9.7608538e-011        luc=3.0823928e-017
+ wuc=3.2640158e-017        puc=-1.5014473e-023       vsat=114000
+ a0=2.1138321              la0=-1.0802274e-007       pvsat=0+dpvsatp_hvt
+ wa0=2.5180533e-007        pa0=-1.1583045e-013       ags=0.67423077
+ lags=4.4103385e-007       wags=-9.2815615e-007      pags=4.2695183e-013
+ a1=0                      a2=1                      b0=0
+ b1=0                      keta=-0.077406923         lketa=-8.6586154e-009
+ dwg=0                     dwb=0                     pclm=1.158141
+ lpclm=-7.2744872e-008     wpclm=-4.2970192e-008     ppclm=1.9766288e-014
+ pdiblc1=2e-018            pdiblc2=0.0015            pdiblcb=0
+ drout=0                   pvag=1.5                  delta=0.01
+ pscbe1=9.264e008          pscbe2=1e-020             fprout=200
+ pdits=0                   pditsd=0                  pditsl=0
+ rsh=9.68                  rdsw=210+drdswp_hvt       rsw=210
+ rdw=210                   rdswmin=0                 rdwmin=0
+ prwg=0                    prwb=0                    wr=1
+ alpha0=0                  alpha1=0.06               beta0=12
+ agidl=9e-008              bgidl=2.3e009             cgidl=0.5
+ egidl=0.53                aigbacc=0.01066           bigbacc=0.001949
+ cigbacc=0.1416            nigbacc=4.05              aigbinv=0.35
+ bigbinv=0.03              cigbinv=0.006             eigbinv=1.1
+ nigbinv=1                 aigc=0.005985             bigc=0.000764
+ cigc=0                    aigsd=0.0047661383        waigsd=1.6870098e-010
+ bigsd=0.0001597           cigsd=0.001522            nigc=1
+ poxedge=1                 pigcd=1.495               ntox=ntoxp_hvt
+ xrcrg1=12                 xrcrg2=1                  cgso=cgop_hvt
+ cgdo=cgop_hvt             cgbo=0                    cgdl=cglp_hvt
+ cgsl=cglp_hvt             clc=1e-007                cle=0.6
+ cf=cfp_hvt                ckappas=0.6               acde=1.2
+ moin=8                    noff=1.568                voffcv=-0.0540472
+ kt1=-0.2435               kt1l=0                    kt2=-0.04696
+ ute=-1.419295             lute=1.2343333e-008       wute=2.6039937e-008
+ pute=3.9532577e-015       ua1=7.27e-010             ub1=-2.8045232e-018
+ lub1=8.9229974e-026       wub1=-1.5099726e-025      pub1=-4.3090509e-032
+ uc1=-6.421e-011           prt=0                     at=354725.6
+ lat=-0.045620854          wat=-0.03258              pat=2.0280212e-008
+ jss=1.50e-07              jsws=5.60e-13             jswgs=9.00e-12
+ njs=1                     ijthsfwd=0.01             ijthsrev=0.01
+ bvs=10                    xjbvs=1                   pbs=0.751
+ cjs=cjp_hvt               mjs=0.351                 pbsws=0.8
+ cjsws=cjswp_hvt           mjsws=0.01                pbswgs=1.15
+ cjswgs=cjswgp_hvt         mjswgs=0.678              tpb=1.56e-03
+ tcj=8.59e-04              tpbsw=1.56e-03            tcjsw=1.86e-04
+ tpbswg=3.00e-04           tcjswg=4.62e-04           xtis=3
+ dmcg=9.25e-008            dmci=9.25e-008            dmdg=0
+ dmcgt=0                   dwj=0                     xgw=0
+ xgl=0                     rshg=0.1                  gbmin=1e-012
+ rbpb=50                   rbpd=50                   rbps=50
+ rbdb=50                   rbsb=50                   ngcon=1
+ saref=0.63e-6             sbref=0.63e-6             kvsat=-0.95
+ wlod=0.8e-6               tku0=0.1                  ku0=1.3349e-7
+ llodku0=1                 wlodku0=1                 lku0=1.5807e-7
+ wku0=6e-7                 pku0=0                    kvth0=-1.5e-9
+ stk2=6e-10                steta0=0                  lkvth0=-1.68e-15
+ wkvth0=0.5e-6             pkvth0=0                  llodvth=2
+ wlodvth=1                 lodk2=2                   lodeta0=1
+ fnoimod=1                 noia=1.30e+42             noib=9.00e+26
+ noic=8.75                 em=5.00e+07               ef=1.13
+ wpemod=wpeflag_hvt        kvth0we=-0.0028           lkvth0we=0
+ wkvth0we=0                pkvth0we=0                ku0we=-0.0045
+ lku0we=4.50e-10           wku0we=0                  pku0we=0
+ k2we=0.00045              wk2we=0                   web=-180
+ wec=-3000                 scref=1.00e-06            ud=0
+ tnoimod=0                 minr=1e-3

     8: type=p
+ lmin=1.000e-07            lmax=2.4000e-07-dxlp_hvt  wmin=1.0000e-06-dxwp_hvt
+ wmax=1.0000e-05-dxwp_hvt  version=4.5               binunit=2
+ paramchk=1                mobmod=0                  capmod=2
+ igcmod=1                  igbmod=1                  geomod=0
+ diomod=1                  rdsmod=0                  rbodymod=0
+ rgatemod=0                permod=1                  acnqsmod=0
+ trnqsmod=0                tnom=25                   toxe=toxp_hvt
+ toxm=toxp_hvt             dtox=5.1e-010             epsrox=3.9
+ wint=5e-009               lint=2.5e-009             ll=0
+ wl=0                      lln=1                     wln=1
+ lw=0                      ww=0                      lwn=1
+ wwn=1                     lwl=0                     wwl=0
+ llc=0                     wlc=0                     lwc=0
+ wwc=0                     lwlc=0                    wwlc=0
+ dlc=1.44e-08              dwc=0                     xpart=1
+ toxref=3e-009             dlcig=2.5e-009            xl=-3.5e-8+dxlp_hvt
+ xw=1.5e-8+dxwp_hvt        vth0=-0.33106521+dvthp_hvt
+ lvth0=-4.6695714e-010+dlvthp_hvt                    wvth0=6.6554689e-009+dwvthp_hvt
+ pvth0=-1.3310938e-015+dpvthp_hvt                    k1=0.30105214
+ lk1=4.4095714e-009        wk1=-1.8673618e-008       pk1=3.7347236e-015
+ k2=0.017947883+dk2p_hvt   lk2=2.27746e-009          wk2=4.8950415e-009
+ pk2=-2.1699702e-015       k3=-2.8                   k3b=1.2
+ w0=1e-007                 dvt0=15.61                dvt1=1.25
+ dvt2=0                    dvt0w=0                   dvt1w=0
+ dvt2w=0                   dsub=0.5                  minv=0
+ voffl=0                   dvtp0=1.09e-008           dvtp1=4
+ lpe0=2.589e-008           lpeb=0                    xj=1.7e-007
+ ngate=1e020               ndep=8.3687e017           nsd=1e020
+ phin=0                    cdsc=0                    cdscb=0
+ cdscd=0                   cit=0.0001                voff=-0.085702929
+ lvoff=-8.5941429e-010     wvoff=5.8893718e-009      pvoff=-1.1778744e-015+dpvoffp_hvt
+ nfactor=0.40430071        lnfactor=1.3393986e-007   wnfactor=1.6135921e-007
+ pnfactor=-3.2271842e-014  eta0=0.15264626           leta0=5.2407143e-009
+ weta0=3.7842007e-008      peta0=-5.2669179e-015     etab=-0.1
+ u0=0.010462508            lu0=-1.9310039e-010       wu0=-2.3305313e-009
+ pu0=1.0611403e-016        ua=2.5081171e-010         lua=-3.4022343e-017
+ wua=-4.4050586e-018       pua=8.8101171e-025        ub=1.0653195e-018
+ lub=4.3416429e-026        wub=-3.6070407e-026       pub=2.4419346e-032
+ uc=-2.4772143e-012        luc=1.1797663e-017        wuc=-4.5822185e-017
+ puc=6.7799597e-025        vsat=114000               pvsat=0+dpvsatp_hvt
+ a0=1.4462512              la0=2.5493429e-008        wa0=-4.4130387e-007
+ pa0=2.279139e-014         ags=2.2372507             lags=1.2842986e-007
+ wags=-5.0050084e-006      pags=1.2423223e-012       a1=0
+ a2=1                      b0=0                      b1=0
+ keta=-0.16533959          lketa=8.9279183e-009      wketa=-1.7792606e-009
+ pketa=3.5585212e-016      dwg=0                     dwb=0
+ pclm=1.0063095            lpclm=-4.2378571e-008     wpclm=7.9801786e-008
+ ppclm=-4.7881071e-015     pdiblc1=2e-018            pdiblc2=0.0014760714
+ lpdiblc2=4.7857143e-012   wpdiblc2=2.3940536e-010   ppdiblc2=-4.7881071e-017
+ pdiblcb=0                 drout=0                   pvag=1.5
+ delta=0.01                pscbe1=9.264e008          pscbe2=1e-020
+ fprout=200                pdits=0                   pditsd=0
+ pditsl=0                  rsh=9.68                  rdsw=210+drdswp_hvt
+ rsw=210                   rdw=210                   rdswmin=0
+ rdwmin=0                  prwg=0                    prwb=0
+ wr=1                      alpha0=0                  alpha1=0.06
+ beta0=12                  agidl=9e-008              bgidl=2.3e009
+ cgidl=0.5                 egidl=0.53                aigbacc=0.01066
+ bigbacc=0.001949          cigbacc=0.1416            nigbacc=4.05
+ aigbinv=0.35              bigbinv=0.03              cigbinv=0.006
+ eigbinv=1.1               nigbinv=1                 aigc=0.005985
+ bigc=0.000764             cigc=0                    aigsd=0.0047661383
+ waigsd=1.6870098e-010     bigsd=0.0001597           cigsd=0.001522
+ nigc=1                    poxedge=1                 pigcd=1.495
+ ntox=ntoxp_hvt            xrcrg1=12                 xrcrg2=1
+ cgso=cgop_hvt             cgdo=cgop_hvt             cgbo=0
+ cgdl=cglp_hvt             cgsl=cglp_hvt             clc=1e-007
+ cle=0.6                   cf=cfp_hvt                ckappas=0.6
+ acde=1.2                  moin=8                    noff=1.568
+ voffcv=-0.0540472         kt1=-0.21973457           lkt1=-4.7530857e-009
+ wkt1=-7.0863986e-009      pkt1=1.4172797e-015       kt1l=0
+ kt2=-0.04696              ute=-1.4440533            lute=1.7295e-008
+ wute=1.3917431e-007       pute=-1.8673618e-014      ua1=7.27e-010
+ ub1=-2.782144e-018        lub1=8.4754143e-026       wub1=1.3007691e-025
+ pub1=-9.9305342e-032      uc1=-6.421e-011           prt=0
+ at=142072.39              lat=-0.0030902114         wat=0.090635676
+ pat=-4.3629232e-009       jss=1.50e-07              jsws=5.60e-13
+ jswgs=9.00e-12            njs=1                     ijthsfwd=0.01
+ ijthsrev=0.01             bvs=10                    xjbvs=1
+ pbs=0.751                 cjs=cjp_hvt               mjs=0.351
+ pbsws=0.8                 cjsws=cjswp_hvt           mjsws=0.01
+ pbswgs=1.15               cjswgs=cjswgp_hvt         mjswgs=0.678
+ tpb=1.56e-03              tcj=8.59e-04              tpbsw=1.56e-03
+ tcjsw=1.86e-04            tpbswg=3.00e-04           tcjswg=4.62e-04
+ xtis=3                    dmcg=9.25e-008            dmci=9.25e-008
+ dmdg=0                    dmcgt=0                   dwj=0
+ xgw=0                     xgl=0                     rshg=0.1
+ gbmin=1e-012              rbpb=50                   rbpd=50
+ rbps=50                   rbdb=50                   rbsb=50
+ ngcon=1                   saref=0.63e-6             sbref=0.63e-6
+ kvsat=-0.95               wlod=0.8e-6               tku0=0.1
+ ku0=1.3349e-7             llodku0=1                 wlodku0=1
+ lku0=1.5807e-7            wku0=6e-7                 pku0=0
+ kvth0=-1.5e-9             stk2=6e-10                steta0=0
+ lkvth0=-1.68e-15          wkvth0=0.5e-6             pkvth0=0
+ llodvth=2                 wlodvth=1                 lodk2=2
+ lodeta0=1                 fnoimod=1                 noia=1.30e+42
+ noib=9.00e+26             noic=8.75                 em=5.00e+07
+ ef=1.13                   wpemod=wpeflag_hvt        kvth0we=-0.0028
+ lkvth0we=0                wkvth0we=0                pkvth0we=0
+ ku0we=-0.0045             lku0we=4.50e-10           wku0we=0
+ pku0we=0                  k2we=0.00045              wk2we=0
+ web=-180                  wec=-3000                 scref=1.00e-06
+ ud=0                      tnoimod=0                 minr=1e-3

     9: type=p
+ lmin=1.0000e-05-dxlp_hvt  lmax=2.001e-05            wmin=5.0000e-07-dxwp_hvt
+ wmax=1.0000e-06-dxwp_hvt  version=4.5               binunit=2
+ paramchk=1                mobmod=0                  capmod=2
+ igcmod=1                  igbmod=1                  geomod=0
+ diomod=1                  rdsmod=0                  rbodymod=0
+ rgatemod=0                permod=1                  acnqsmod=0
+ trnqsmod=0                tnom=25                   toxe=toxp_hvt
+ toxm=toxp_hvt             dtox=5.1e-010             epsrox=3.9
+ wint=5e-009               lint=2.5e-009             ll=0
+ wl=0                      lln=1                     wln=1
+ lw=0                      ww=0                      lwn=1
+ wwn=1                     lwl=0                     wwl=0
+ llc=0                     wlc=0                     lwc=0
+ wwc=0                     lwlc=0                    wwlc=0
+ dlc=1.44e-08              dwc=0                     xpart=1
+ toxref=3e-009             dlcig=2.5e-009            xl=-3.5e-8+dxlp_hvt
+ xw=1.5e-8+dxwp_hvt        vth0=-0.3334+dvthp_hvt    wvth0=0+dwvthp_hvt
+ lvth0=0+dlvthp_hvt        pvth0=0+dpvthp_hvt        k1=0.3231
+ k2=0.01922073+dk2p_hvt    wk2=-6.8749336e-009       k3=-2.8
+ k3b=1.2                   w0=1e-007                 dvt0=15.61
+ dvt1=1.25                 dvt2=0                    dvt0w=0
+ dvt1w=0                   dvt2w=0                   dsub=0.5
+ minv=0                    voffl=0                   dvtp0=1.09e-008
+ dvtp1=4                   lpe0=2.589e-008           lpeb=0
+ xj=1.7e-007               ngate=1e020               ndep=8.3687e017
+ nsd=1e020                 phin=0                    cdsc=0
+ cdscb=0                   cdscd=0                   cit=0.0001
+ voff=-0.09                pvoff=0+dpvoffp_hvt       nfactor=0.5
+ eta0=0.02                 etab=-0.1                 u0=0.007324
+ ua=3.88e-010              ub=4.751e-019             uc=-7.712e-011
+ vsat=114000               a0=2.09                   pvsat=0+dpvsatp_hvt
+ ags=0.9161                a1=0                      a2=1
+ b0=0                      b1=0                      keta=0.01896142
+ wketa=-2.2069217e-008     dwg=0                     dwb=0
+ pclm=0.15                 pdiblc1=0                 pdiblc2=9.6e-005
+ pdiblcb=0                 drout=0                   pvag=1.5
+ delta=0.005               pscbe1=9.264e008          pscbe2=1e-020
+ fprout=200                pdits=0                   pditsd=0
+ pditsl=0                  rsh=9.68                  rdsw=210+drdswp_hvt
+ rsw=210                   rdw=210                   rdswmin=0
+ rdwmin=0                  prwg=0                    prwb=0
+ wr=1                      alpha0=0                  alpha1=0.06
+ beta0=12                  agidl=9e-008              bgidl=2.3e009
+ cgidl=0.5                 egidl=0.53                aigbacc=0.01066
+ bigbacc=0.001949          cigbacc=0.1416            nigbacc=4.05
+ aigbinv=0.35              bigbinv=0.03              cigbinv=0.006
+ eigbinv=1.1               nigbinv=1                 aigc=0.005985
+ bigc=0.000764             cigc=0                    aigsd=0.004934
+ bigsd=0.0001597           cigsd=0.001522            nigc=1
+ poxedge=1                 pigcd=1.495               ntox=ntoxp_hvt
+ xrcrg1=12                 xrcrg2=1                  cgso=cgop_hvt
+ cgdo=cgop_hvt             cgbo=0                    cgdl=cglp_hvt
+ cgsl=cglp_hvt             clc=1e-007                cle=0.6
+ cf=cfp_hvt                ckappas=0.6               acde=1.2
+ moin=8                    noff=1.568                voffcv=-0.0540472
+ kt1=-0.2435               kt1l=0                    kt2=-0.04696
+ ute=-1.543                ua1=7.27e-010             ub1=-3.281e-018
+ uc1=-6.421e-011           prt=0                     at=256700
+ jss=1.50e-07              jsws=5.60e-13             jswgs=9.00e-12
+ njs=1                     ijthsfwd=0.01             ijthsrev=0.01
+ bvs=10                    xjbvs=1                   pbs=0.751
+ cjs=cjp_hvt               mjs=0.351                 pbsws=0.8
+ cjsws=cjswp_hvt           mjsws=0.01                pbswgs=1.15
+ cjswgs=cjswgp_hvt         mjswgs=0.678              tpb=1.56e-03
+ tcj=8.59e-04              tpbsw=1.56e-03            tcjsw=1.86e-04
+ tpbswg=3.00e-04           tcjswg=4.62e-04           xtis=3
+ dmcg=9.25e-008            dmci=9.25e-008            dmdg=0
+ dmcgt=0                   dwj=0                     xgw=0
+ xgl=0                     rshg=0.1                  gbmin=1e-012
+ rbpb=50                   rbpd=50                   rbps=50
+ rbdb=50                   rbsb=50                   ngcon=1
+ saref=0.63e-6             sbref=0.63e-6             kvsat=-0.95
+ wlod=0.8e-6               tku0=0.1                  ku0=1.3349e-7
+ llodku0=1                 wlodku0=1                 lku0=1.5807e-7
+ wku0=6e-7                 pku0=0                    kvth0=-1.5e-9
+ stk2=6e-10                steta0=0                  lkvth0=-1.68e-15
+ wkvth0=0.5e-6             pkvth0=0                  llodvth=2
+ wlodvth=1                 lodk2=2                   lodeta0=1
+ fnoimod=1                 noia=1.30e+42             noib=9.00e+26
+ noic=8.75                 em=5.00e+07               ef=1.13
+ wpemod=wpeflag_hvt        kvth0we=-0.0028           lkvth0we=0
+ wkvth0we=0                pkvth0we=0                ku0we=-0.0045
+ lku0we=4.50e-10           wku0we=0                  pku0we=0
+ k2we=0.00045              wk2we=0                   web=-180
+ wec=-3000                 scref=1.00e-06            ud=0
+ tnoimod=0                 minr=1e-3

     10: type=p
+ lmin=5.0000e-07-dxlp_hvt  lmax=1.0000e-05-dxlp_hvt  wmin=5.0000e-07-dxwp_hvt
+ wmax=1.0000e-06-dxwp_hvt  version=4.5               binunit=2
+ paramchk=1                mobmod=0                  capmod=2
+ igcmod=1                  igbmod=1                  geomod=0
+ diomod=1                  rdsmod=0                  rbodymod=0
+ rgatemod=0                permod=1                  acnqsmod=0
+ trnqsmod=0                tnom=25                   toxe=toxp_hvt
+ toxm=toxp_hvt             dtox=5.1e-010             epsrox=3.9
+ wint=5e-009               lint=2.5e-009             ll=0
+ wl=0                      lln=1                     wln=1
+ lw=0                      ww=0                      lwn=1
+ wwn=1                     lwl=0                     wwl=0
+ llc=0                     wlc=0                     lwc=0
+ wwc=0                     lwlc=0                    wwlc=0
+ dlc=1.44e-08              dwc=0                     xpart=1
+ toxref=3e-009             dlcig=2.5e-009            xl=-3.5e-8+dxlp_hvt
+ xw=1.5e-8+dxwp_hvt        vth0=-0.3334+dvthp_hvt    wvth0=0+dwvthp_hvt
+ lvth0=0+dlvthp_hvt        pvth0=0+dpvthp_hvt        k1=0.3231
+ k2=0.019185418+dk2p_hvt   lk2=3.5170773e-010        wk2=-7.2078252e-009
+ pk2=3.3155996e-015        k3=-2.8                   k3b=1.2
+ w0=1e-007                 dvt0=15.61                dvt1=1.25
+ dvt2=0                    dvt0w=0                   dvt1w=0
+ dvt2w=0                   dsub=0.5                  minv=0
+ voffl=0                   dvtp0=1.09e-008           dvtp1=4
+ lpe0=2.589e-008           lpeb=0                    xj=1.7e-007
+ ngate=1e020               ndep=8.3687e017           nsd=1e020
+ phin=0                    cdsc=0                    cdscb=0
+ cdscd=0                   cit=0.0001                voff=-0.089427808
+ lvoff=-5.6990281e-009     wvoff=-5.7505254e-010     pvoff=5.7275233e-015+dpvoffp_hvt
+ nfactor=0.47820699        lnfactor=2.1705836e-007   wnfactor=8.7142577e-009
+ pnfactor=-8.6794006e-014  eta0=0.016126316          leta0=3.8581895e-008
+ weta0=-6.8209035e-025     peta0=6.7936199e-030      etab=-0.1
+ u0=0.0072997411           lu0=2.4161912e-010        wu0=-5.3288309e-027
+ pu0=5.3075155e-032        ua=4.0287979e-010         lua=-1.482027e-016
+ wua=2.5409846e-033        pua=-2.5308206e-038       ub=4.4125853e-019
+ lub=3.3706108e-025        wub=-4.7329526e-042       pub=4.7140208e-047
+ uc=-7.9372547e-011        luc=2.2435372e-017        wuc=-3.1762307e-034
+ puc=3.1635258e-039        vsat=114000               a0=2.1002168
+ la0=-1.0175975e-007       pvsat=0+dpvsatp_hvt       wa0=1.3641807e-024
+ pa0=-1.358724e-029        ags=0.88138695            lags=3.45742e-007
+ wags=-5.4567228e-024      pags=5.4348959e-029       a1=0
+ a2=1                      b0=0                      b1=0
+ keta=0.02453911           lketa=-5.5553791e-008     wketa=-2.3137832e-008
+ pketa=1.0643403e-014      dwg=0                     dwb=0
+ pclm=0.10884211           lpclm=4.0993263e-007      wpclm=-5.4567228e-024
+ ppclm=5.4348959e-029      pdiblc1=-9.6842105e-020   lpdiblc1=9.6454737e-025
+ wpdiblc1=-1.893181e-041   ppdiblc1=1.8856083e-046   pdiblc2=2.8016842e-005
+ lpdiblc2=6.7711225e-010   wpdiblc2=-1.0657662e-026  ppdiblc2=1.0615031e-031
+ pdiblcb=0                 drout=0                   pvag=1.5
+ delta=0.0047578947        ldelta=2.4113684e-009     wdelta=-4.2630647e-026
+ pdelta=4.2460124e-031     pscbe1=9.264e008          pscbe2=1e-020
+ fprout=200                pdits=0                   pditsd=0
+ pditsl=0                  rsh=9.68                  rdsw=210+drdswp_hvt
+ rsw=210                   rdw=210                   rdswmin=0
+ rdwmin=0                  prwg=0                    prwb=0
+ wr=1                      alpha0=0                  alpha1=0.06
+ beta0=12                  agidl=9e-008              bgidl=2.3e009
+ cgidl=0.5                 egidl=0.53                aigbacc=0.01066
+ bigbacc=0.001949          cigbacc=0.1416            nigbacc=4.05
+ aigbinv=0.35              bigbinv=0.03              cigbinv=0.006
+ eigbinv=1.1               nigbinv=1                 aigc=0.005985
+ bigc=0.000764             cigc=0                    aigsd=0.004934
+ bigsd=0.0001597           cigsd=0.001522            nigc=1
+ poxedge=1                 pigcd=1.495               ntox=ntoxp_hvt
+ xrcrg1=12                 xrcrg2=1                  cgso=cgop_hvt
+ cgdo=cgop_hvt             cgbo=0                    cgdl=cglp_hvt
+ cgsl=cglp_hvt             clc=1e-007                cle=0.6
+ cf=cfp_hvt                ckappas=0.6               acde=1.2
+ moin=8                    noff=1.568                voffcv=-0.0540472
+ kt1=-0.2435               kt1l=0                    kt2=-0.04696
+ ute=-1.55499              lute=1.1942061e-007       wute=3.0472869e-009
+ pute=-3.0350978e-014      ua1=7.27e-010             ub1=-3.3016758e-018
+ lub1=2.0593086e-025       wub1=-2.3664763e-042      pub1=2.3570104e-047
+ uc1=-6.421e-011           prt=0                     at=255570.39
+ lat=0.011250963           wat=0.00063403228         pat=-6.3149616e-009
+ jss=1.50e-07              jsws=5.60e-13             jswgs=9.00e-12
+ njs=1                     ijthsfwd=0.01             ijthsrev=0.01
+ bvs=10                    xjbvs=1                   pbs=0.751
+ cjs=cjp_hvt               mjs=0.351                 pbsws=0.8
+ cjsws=cjswp_hvt           mjsws=0.01                pbswgs=1.15
+ cjswgs=cjswgp_hvt         mjswgs=0.678              tpb=1.56e-03
+ tcj=8.59e-04              tpbsw=1.56e-03            tcjsw=1.86e-04
+ tpbswg=3.00e-04           tcjswg=4.62e-04           xtis=3
+ dmcg=9.25e-008            dmci=9.25e-008            dmdg=0
+ dmcgt=0                   dwj=0                     xgw=0
+ xgl=0                     rshg=0.1                  gbmin=1e-012
+ rbpb=50                   rbpd=50                   rbps=50
+ rbdb=50                   rbsb=50                   ngcon=1
+ saref=0.63e-6             sbref=0.63e-6             kvsat=-0.95
+ wlod=0.8e-6               tku0=0.1                  ku0=1.3349e-7
+ llodku0=1                 wlodku0=1                 lku0=1.5807e-7
+ wku0=6e-7                 pku0=0                    kvth0=-1.5e-9
+ stk2=6e-10                steta0=0                  lkvth0=-1.68e-15
+ wkvth0=0.5e-6             pkvth0=0                  llodvth=2
+ wlodvth=1                 lodk2=2                   lodeta0=1
+ fnoimod=1                 noia=1.30e+42             noib=9.00e+26
+ noic=8.75                 em=5.00e+07               ef=1.13
+ wpemod=wpeflag_hvt        kvth0we=-0.0028           lkvth0we=0
+ wkvth0we=0                pkvth0we=0                ku0we=-0.0045
+ lku0we=4.50e-10           wku0we=0                  pku0we=0
+ k2we=0.00045              wk2we=0                   web=-180
+ wec=-3000                 scref=1.00e-06            ud=0
+ tnoimod=0                 minr=1e-3

     11: type=p
+ lmin=2.4000e-07-dxlp_hvt  lmax=5.0000e-07-dxlp_hvt  wmin=5.0000e-07-dxwp_hvt
+ wmax=1.0000e-06-dxwp_hvt  version=4.5               binunit=2
+ paramchk=1                mobmod=0                  capmod=2
+ igcmod=1                  igbmod=1                  geomod=0
+ diomod=1                  rdsmod=0                  rbodymod=0
+ rgatemod=0                permod=1                  acnqsmod=0
+ trnqsmod=0                tnom=25                   toxe=toxp_hvt
+ toxm=toxp_hvt             dtox=5.1e-010             epsrox=3.9
+ wint=5e-009               lint=2.5e-009             ll=0
+ wl=0                      lln=1                     wln=1
+ lw=0                      ww=0                      lwn=1
+ wwn=1                     lwl=0                     wwl=0
+ llc=0                     wlc=0                     lwc=0
+ wwc=0                     lwlc=0                    wwlc=0
+ dlc=1.44e-08              dwc=0                     xpart=1
+ toxref=3e-009             dlcig=2.5e-009            xl=-3.5e-8+dxlp_hvt
+ xw=1.5e-8+dxwp_hvt        vth0=-0.3334+dvthp_hvt    wvth0=0+dwvthp_hvt
+ lvth0=0+dlvthp_hvt        pvth0=0+dpvthp_hvt        k1=0.3231
+ k2=0.018181923+dk2p_hvt   lk2=8.1331538e-010        wk2=-8.9792885e-010
+ pk2=4.1304727e-016        k3=-2.8                   k3b=1.2
+ w0=1e-007                 dvt0=15.61                dvt1=1.25
+ dvt2=0                    dvt0w=0                   dvt1w=0
+ dvt2w=0                   dsub=0.5                  minv=0
+ voffl=0                   dvtp0=1.09e-008           dvtp1=4
+ lpe0=2.589e-008           lpeb=0                    xj=1.7e-007
+ ngate=1e020               ndep=8.3687e017           nsd=1e020
+ phin=0                    cdsc=0                    cdscb=0
+ cdscd=0                   cit=0.0001                voff=-0.10601238
+ lvoff=1.9298769e-009      wvoff=1.6092447e-008      pvoff=-1.9395263e-015+dpvoffp_hvt
+ nfactor=0.69617454        lnfactor=1.1679329e-007   wnfactor=-1.5904272e-007
+ pnfactor=-9.6257972e-015  eta0=0.023856923          leta0=3.5025815e-008
+ weta0=6.7149462e-009      peta0=-3.0888752e-015     etab=-0.1
+ u0=0.0076073231           lu0=1.0013138e-010        wu0=3.1076146e-010
+ pu0=-1.4295027e-016       ua=8.07e-011              ub=1.0247692e-018
+ lub=6.8646154e-026        uc=-5.4284923e-011        luc=1.0895065e-017
+ wuc=-1.0900075e-017       puc=5.0140347e-024        vsat=114000
+ a0=2.3643846              pvsat=0+dpvsatp_hvt       la0=-2.2327692e-007
+ ags=-0.24930769           lags=8.6586154e-007       a1=0
+ a2=1                      b0=0                      b1=0
+ keta=-0.077406923         lketa=-8.6586154e-009     dwg=0
+ dwb=0                     pclm=1.1153846            lpclm=-5.3076923e-008
+ pdiblc1=2e-018            pdiblc2=0.0015            pdiblcb=0
+ drout=0                   pvag=1.5                  delta=0.01
+ pscbe1=9.264e008          pscbe2=1e-020             fprout=200
+ pdits=0                   pditsd=0                  pditsl=0
+ rsh=9.68                  rdsw=210+drdswp_hvt       rsw=210
+ rdw=210                   rdswmin=0                 rdwmin=0
+ prwg=0                    prwb=0                    wr=1
+ alpha0=0                  alpha1=0.06               beta0=12
+ agidl=9e-008              bgidl=2.3e009             cgidl=0.5
+ egidl=0.53                aigbacc=0.01066           bigbacc=0.001949
+ cigbacc=0.1416            nigbacc=4.05              aigbinv=0.35
+ bigbinv=0.03              cigbinv=0.006             eigbinv=1.1
+ nigbinv=1                 aigc=0.005985             bigc=0.000764
+ cigc=0                    aigsd=0.004934            bigsd=0.0001597
+ cigsd=0.001522            nigc=1                    poxedge=1
+ pigcd=1.495               ntox=ntoxp_hvt            xrcrg1=12
+ xrcrg2=1                  cgso=cgop_hvt             cgdo=cgop_hvt
+ cgbo=0                    cgdl=cglp_hvt             cgsl=cglp_hvt
+ clc=1e-007                cle=0.6                   cf=cfp_hvt
+ ckappas=0.6               acde=1.2                  moin=8
+ noff=1.568                voffcv=-0.0540472         kt1=-0.2435
+ kt1l=0                    kt2=-0.04696              ute=-1.3059031
+ lute=4.8406154e-009       wute=-8.7918946e-008      pute=1.1493489e-014
+ ua1=7.27e-010             ub1=-3.0316846e-018       lub1=8.1734923e-026
+ wub1=7.7299962e-026       pub1=-3.5557982e-032      uc1=-6.421e-011
+ prt=0                     at=339376.69              lat=-0.027299938
+ wat=-0.017154345          pat=1.867692e-009         jss=1.50e-07
+ jsws=5.60e-13             jswgs=9.00e-12            njs=1
+ ijthsfwd=0.01             ijthsrev=0.01             bvs=10
+ xjbvs=1                   pbs=0.751                 cjs=cjp_hvt
+ mjs=0.351                 pbsws=0.8                 cjsws=cjswp_hvt
+ mjsws=0.01                pbswgs=1.15               cjswgs=cjswgp_hvt
+ mjswgs=0.678              tpb=1.56e-03              tcj=8.59e-04
+ tpbsw=1.56e-03            tcjsw=1.86e-04            tpbswg=3.00e-04
+ tcjswg=4.62e-04           xtis=3                    dmcg=9.25e-008
+ dmci=9.25e-008            dmdg=0                    dmcgt=0
+ dwj=0                     xgw=0                     xgl=0
+ rshg=0.1                  gbmin=1e-012              rbpb=50
+ rbpd=50                   rbps=50                   rbdb=50
+ rbsb=50                   ngcon=1                   saref=0.63e-6
+ sbref=0.63e-6             kvsat=-0.95               wlod=0.8e-6
+ tku0=0.1                  ku0=1.3349e-7             llodku0=1
+ wlodku0=1                 lku0=1.5807e-7            wku0=6e-7
+ pku0=0                    kvth0=-1.5e-9             stk2=6e-10
+ steta0=0                  lkvth0=-1.68e-15          wkvth0=0.5e-6
+ pkvth0=0                  llodvth=2                 wlodvth=1
+ lodk2=2                   lodeta0=1                 fnoimod=1
+ noia=1.30e+42             noib=9.00e+26             noic=8.75
+ em=5.00e+07               ef=1.13                   wpemod=wpeflag_hvt
+ kvth0we=-0.0028           lkvth0we=0                wkvth0we=0
+ pkvth0we=0                ku0we=-0.0045             lku0we=4.50e-10
+ wku0we=0                  pku0we=0                  k2we=0.00045
+ wk2we=0                   web=-180                  wec=-3000
+ scref=1.00e-06            ud=0                      tnoimod=0
+ minr=1e-3

     12: type=p
+ lmin=1.000e-07            lmax=2.4000e-07-dxlp_hvt  wmin=5.0000e-07-dxwp_hvt
+ wmax=1.0000e-06-dxwp_hvt  version=4.5               binunit=2
+ paramchk=1                mobmod=0                  capmod=2
+ igcmod=1                  igbmod=1                  geomod=0
+ diomod=1                  rdsmod=0                  rbodymod=0
+ rgatemod=0                permod=1                  acnqsmod=0
+ trnqsmod=0                tnom=25                   toxe=toxp_hvt
+ toxm=toxp_hvt             dtox=5.1e-010             epsrox=3.9
+ wint=5e-009               lint=2.5e-009             ll=0
+ wl=0                      lln=1                     wln=1
+ lw=0                      ww=0                      lwn=1
+ wwn=1                     lwl=0                     wwl=0
+ llc=0                     wlc=0                     lwc=0
+ wwc=0                     lwlc=0                    wwlc=0
+ dlc=1.44e-08              dwc=0                     xpart=1
+ toxref=3e-009             dlcig=2.5e-009            xl=-3.5e-8+dxlp_hvt
+ xw=1.5e-8+dxwp_hvt        vth0=-0.32405329+dvthp_hvt
+ lvth0=-1.8693429e-009+dlvthp_hvt                    wvth0=-3.9151929e-010+dwvthp_hvt
+ pvth0=7.8303857e-017+dpvthp_hvt                     k1=0.28247143
+ lk1=8.1257143e-009        k2=0.021159286+dk2p_hvt   lk2=2.1784286e-010
+ wk2=1.6675821e-009        pk2=-1.0005493e-016       k3=-2.8
+ k3b=1.2                   w0=1e-007                 dvt0=15.61
+ dvt1=1.25                 dvt2=0                    dvt0w=0
+ dvt1w=0                   dvt2w=0                   dsub=0.5
+ minv=0                    voffl=0                   dvtp0=1.09e-008
+ dvtp1=4                   lpe0=2.589e-008           lpeb=0
+ xj=1.7e-007               ngate=1e020               ndep=8.3687e017
+ nsd=1e020                 phin=0                    cdsc=0
+ cdscb=0                   cdscd=0                   cit=0.0001
+ voff=-0.084517714         lvoff=-2.3690571e-009     wvoff=4.6982314e-009
+ pvoff=3.3931671e-016+dpvoffp_hvt                    nfactor=0.76454857
+ lnfactor=1.0311849e-007   wnfactor=-2.0068989e-007  pnfactor=-1.2963639e-015
+ eta0=0.198986             weta0=-8.72943e-009       etab=-0.1
+ u0=0.0085442529           lu0=-8.7254571e-011       wu0=-4.0268484e-010
+ pu0=-2.6101286e-019       ua=2.4642857e-010         lua=-3.3145714e-017
+ ub=9.7662e-019            lub=7.8276e-026           wub=5.3072614e-026
+ pub=-1.0614523e-032       uc=-6.8213714e-011        luc=1.3680823e-017
+ wuc=2.0242997e-017        puc=-1.2145798e-024       vsat=116770.29
+ lvsat=-0.00055405714      wvsat=-0.0027841371       pvsat=5.5682743e-010+dpvsatp_hvt
+ a0=0.88551                la0=7.2498e-008           wa0=1.2224102e-007
+ pa0=-2.4448204e-014       ags=-6.7424571            lags=2.1644914e-006
+ wags=4.019598e-006        pags=-8.039196e-013       a1=0
+ a2=1                      b0=0                      b1=0
+ keta=-0.16711             lketa=9.282e-009          dwg=0
+ dwb=0                     pclm=1.0857143            lpclm=-4.7142857e-008
+ pdiblc1=2e-018            pdiblc2=0.0019307143      lpdiblc2=-8.6142857e-011
+ wpdiblc2=-2.1751071e-010  ppdiblc2=4.3502143e-017   pdiblcb=0
+ drout=0                   pvag=1.5                  delta=0.01
+ pscbe1=9.264e008          pscbe2=1e-020             fprout=200
+ pdits=0                   pditsd=0                  pditsl=0
+ rsh=9.68                  rdsw=210+drdswp_hvt       rsw=210
+ rdw=210                   rdswmin=0                 rdwmin=0
+ prwg=0                    prwb=0                    wr=1
+ alpha0=0                  alpha1=0.06               beta0=12
+ agidl=9e-008              bgidl=2.3e009             cgidl=0.5
+ egidl=0.53                aigbacc=0.01066           bigbacc=0.001949
+ cigbacc=0.1416            nigbacc=4.05              aigbinv=0.35
+ bigbinv=0.03              cigbinv=0.006             eigbinv=1.1
+ nigbinv=1                 aigc=0.005985             bigc=0.000764
+ cigc=0                    aigsd=0.004934            bigsd=0.0001597
+ cigsd=0.001522            nigc=1                    poxedge=1
+ pigcd=1.495               ntox=ntoxp_hvt            xrcrg1=12
+ xrcrg2=1                  cgso=cgop_hvt             cgdo=cgop_hvt
+ cgbo=0                    cgdl=cglp_hvt             cgsl=cglp_hvt
+ clc=1e-007                cle=0.6                   cf=cfp_hvt
+ ckappas=0.6               acde=1.2                  moin=8
+ noff=1.568                voffcv=-0.0540472         kt1=-0.22150486
+ lkt1=-4.3990286e-009      wkt1=-5.3072614e-009      pkt1=1.0614523e-015
+ kt1l=0                    kt2=-0.04696              ute=-1.1752814
+ lute=-2.1283714e-008      wute=-1.3094145e-007      pute=2.009799e-014
+ ua1=7.27e-010             ub1=-2.1912886e-018       lub1=-8.6344286e-026
+ wub1=-4.6373284e-025      pub1=7.2648579e-032       uc1=-6.421e-011
+ prt=0                     at=249643.57              lat=-0.0093533143
+ wat=-0.017473361          pat=1.9314951e-009        jss=1.50e-07
+ jsws=5.60e-13             jswgs=9.00e-12            njs=1
+ ijthsfwd=0.01             ijthsrev=0.01             bvs=10
+ xjbvs=1                   pbs=0.751                 cjs=cjp_hvt
+ mjs=0.351                 pbsws=0.8                 cjsws=cjswp_hvt
+ mjsws=0.01                pbswgs=1.15               cjswgs=cjswgp_hvt
+ mjswgs=0.678              tpb=1.56e-03              tcj=8.59e-04
+ tpbsw=1.56e-03            tcjsw=1.86e-04            tpbswg=3.00e-04
+ tcjswg=4.62e-04           xtis=3                    dmcg=9.25e-008
+ dmci=9.25e-008            dmdg=0                    dmcgt=0
+ dwj=0                     xgw=0                     xgl=0
+ rshg=0.1                  gbmin=1e-012              rbpb=50
+ rbpd=50                   rbps=50                   rbdb=50
+ rbsb=50                   ngcon=1                   saref=0.63e-6
+ sbref=0.63e-6             kvsat=-0.95               wlod=0.8e-6
+ tku0=0.1                  ku0=1.3349e-7             llodku0=1
+ wlodku0=1                 lku0=1.5807e-7            wku0=6e-7
+ pku0=0                    kvth0=-1.5e-9             stk2=6e-10
+ steta0=0                  lkvth0=-1.68e-15          wkvth0=0.5e-6
+ pkvth0=0                  llodvth=2                 wlodvth=1
+ lodk2=2                   lodeta0=1                 fnoimod=1
+ noia=1.30e+42             noib=9.00e+26             noic=8.75
+ em=5.00e+07               ef=1.13                   wpemod=wpeflag_hvt
+ kvth0we=-0.0028           lkvth0we=0                wkvth0we=0
+ pkvth0we=0                ku0we=-0.0045             lku0we=4.50e-10
+ wku0we=0                  pku0we=0                  k2we=0.00045
+ wk2we=0                   web=-180                  wec=-3000
+ scref=1.00e-06            ud=0                      tnoimod=0
+ minr=1e-3

     13: type=p
+ lmin=1.0000e-05-dxlp_hvt  lmax=2.001e-05            wmin=2.4000e-07-dxwp_hvt
+ wmax=5.0000e-07-dxwp_hvt  version=4.5               binunit=2
+ paramchk=1                mobmod=0                  capmod=2
+ igcmod=1                  igbmod=1                  geomod=0
+ diomod=1                  rdsmod=0                  rbodymod=0
+ rgatemod=0                permod=1                  acnqsmod=0
+ trnqsmod=0                tnom=25                   toxe=toxp_hvt
+ toxm=toxp_hvt             dtox=5.1e-010             epsrox=3.9
+ wint=5e-009               lint=2.5e-009             ll=0
+ wl=0                      lln=1                     wln=1
+ lw=0                      ww=0                      lwn=1
+ wwn=1                     lwl=0                     wwl=0
+ llc=0                     wlc=0                     lwc=0
+ wwc=0                     lwlc=0                    wwlc=0
+ dlc=1.44e-08              dwc=0                     xpart=1
+ toxref=3e-009             dlcig=2.5e-009            xl=-3.5e-8+dxlp_hvt
+ xw=1.5e-8+dxwp_hvt        vth0=-0.3334+dvthp_hvt    wvth0=0+dwvthp_hvt
+ lvth0=0+dlvthp_hvt        pvth0=0+dpvthp_hvt        k1=0.3231
+ k2=0.010233165+dk2p_hvt   wk2=-2.3362135e-009       k3=-2.8
+ k3b=1.2                   w0=1e-007                 dvt0=15.61
+ dvt1=1.25                 dvt2=0                    dvt0w=0
+ dvt1w=0                   dvt2w=0                   dsub=0.5
+ minv=0                    voffl=0                   dvtp0=1.09e-008
+ dvtp1=4                   lpe0=2.589e-008           lpeb=0
+ xj=1.7e-007               ngate=1e020               ndep=8.3687e017
+ nsd=1e020                 phin=0                    cdsc=0
+ cdscb=0                   cdscd=0                   cit=0.0001
+ voff=-0.09                pvoff=0+dpvoffp_hvt       nfactor=0.5
+ eta0=0.02                 etab=-0.1                 u0=0.0067718077
+ wu0=2.7885712e-010        ua=3.88e-010              ub=4.751e-019
+ uc=-8.6571346e-011        wuc=4.7729298e-018        vsat=114000
+ a0=2.09                   ags=0.9161                pvsat=0+dpvsatp_hvt
+ a1=0                      a2=1                      b0=0
+ b1=0                      keta=0.0049238462         wketa=-1.4980242e-008
+ dwg=0                     dwb=0                     pclm=0.15
+ pdiblc1=0                 pdiblc2=9.6e-005          pdiblcb=0
+ drout=0                   pvag=1.5                  delta=0.005
+ pscbe1=9.264e008          pscbe2=1e-020             fprout=200
+ pdits=0                   pditsd=0                  pditsl=0
+ rsh=9.68                  rdsw=210+drdswp_hvt       rsw=210
+ rdw=210                   rdswmin=0                 rdwmin=0
+ prwg=0                    prwb=0                    wr=1
+ alpha0=0                  alpha1=0.06               beta0=12
+ agidl=9e-008              bgidl=2.3e009             cgidl=0.5
+ egidl=0.53                aigbacc=0.01066           bigbacc=0.001949
+ cigbacc=0.1416            nigbacc=4.05              aigbinv=0.35
+ bigbinv=0.03              cigbinv=0.006             eigbinv=1.1
+ nigbinv=1                 aigc=0.005985             bigc=0.000764
+ cigc=0                    aigsd=0.0048143269        waigsd=6.0434904e-011
+ bigsd=0.0001597           cigsd=0.001522            nigc=1
+ poxedge=1                 pigcd=1.495               ntox=ntoxp_hvt
+ xrcrg1=12                 xrcrg2=1                  cgso=cgop_hvt
+ cgdo=cgop_hvt             cgbo=0                    cgdl=cglp_hvt
+ cgsl=cglp_hvt             clc=1e-007                cle=0.6
+ cf=cfp_hvt                ckappas=0.6               acde=1.2
+ moin=8                    noff=1.568                voffcv=-0.0540472
+ kt1=-0.2435               kt1l=0                    kt2=-0.04696
+ ute=-1.543                ua1=7.27e-010             ub1=-3.281e-018
+ uc1=-6.421e-011           prt=0                     at=256700
+ jss=1.50e-07              jsws=5.60e-13             jswgs=9.00e-12
+ njs=1                     ijthsfwd=0.01             ijthsrev=0.01
+ bvs=10                    xjbvs=1                   pbs=0.751
+ cjs=cjp_hvt               mjs=0.351                 pbsws=0.8
+ cjsws=cjswp_hvt           mjsws=0.01                pbswgs=1.15
+ cjswgs=cjswgp_hvt         mjswgs=0.678              tpb=1.56e-03
+ tcj=8.59e-04              tpbsw=1.56e-03            tcjsw=1.86e-04
+ tpbswg=3.00e-04           tcjswg=4.62e-04           xtis=3
+ dmcg=9.25e-008            dmci=9.25e-008            dmdg=0
+ dmcgt=0                   dwj=0                     xgw=0
+ xgl=0                     rshg=0.1                  gbmin=1e-012
+ rbpb=50                   rbpd=50                   rbps=50
+ rbdb=50                   rbsb=50                   ngcon=1
+ saref=0.63e-6             sbref=0.63e-6             kvsat=-0.95
+ wlod=0.8e-6               tku0=0.1                  ku0=1.3349e-7
+ llodku0=1                 wlodku0=1                 lku0=1.5807e-7
+ wku0=6e-7                 pku0=0                    kvth0=-1.5e-9
+ stk2=6e-10                steta0=0                  lkvth0=-1.68e-15
+ wkvth0=0.5e-6             pkvth0=0                  llodvth=2
+ wlodvth=1                 lodk2=2                   lodeta0=1
+ fnoimod=1                 noia=1.30e+42             noib=9.00e+26
+ noic=8.75                 em=5.00e+07               ef=1.13
+ wpemod=wpeflag_hvt        kvth0we=-0.0028           lkvth0we=0
+ wkvth0we=0                pkvth0we=0                ku0we=-0.0045
+ lku0we=4.50e-10           wku0we=0                  pku0we=0
+ k2we=0.00045              wk2we=0                   web=-180
+ wec=-3000                 scref=1.00e-06            ud=0
+ tnoimod=0                 minr=1e-3

     14: type=p
+ lmin=5.0000e-07-dxlp_hvt  lmax=1.0000e-05-dxlp_hvt  wmin=2.4000e-07-dxwp_hvt
+ wmax=5.0000e-07-dxwp_hvt  version=4.5               binunit=2
+ paramchk=1                mobmod=0                  capmod=2
+ igcmod=1                  igbmod=1                  geomod=0
+ diomod=1                  rdsmod=0                  rbodymod=0
+ rgatemod=0                permod=1                  acnqsmod=0
+ trnqsmod=0                tnom=25                   toxe=toxp_hvt
+ toxm=toxp_hvt             dtox=5.1e-010             epsrox=3.9
+ wint=5e-009               lint=2.5e-009             ll=0
+ wl=0                      lln=1                     wln=1
+ lw=0                      ww=0                      lwn=1
+ wwn=1                     lwl=0                     wwl=0
+ llc=0                     wlc=0                     lwc=0
+ wwc=0                     lwlc=0                    wwlc=0
+ dlc=1.44e-08              dwc=0                     xpart=1
+ toxref=3e-009             dlcig=2.5e-009            xl=-3.5e-8+dxlp_hvt
+ xw=1.5e-8+dxwp_hvt        vth0=-0.3334+dvthp_hvt    wvth0=0+dwvthp_hvt
+ lvth0=0+dlvthp_hvt        pvth0=0+dpvthp_hvt        k1=0.3231
+ k2=0.0093075314+dk2p_hvt  lk2=9.2193144e-009        wk2=-2.2194925e-009
+ pk2=-1.1625418e-015       k3=-2.8                   k3b=1.2
+ w0=1e-007                 dvt0=15.61                dvt1=1.25
+ dvt2=0                    dvt0w=0                   dvt1w=0
+ dvt2w=0                   dsub=0.5                  minv=0
+ voffl=0                   dvtp0=1.09e-008           dvtp1=4
+ lpe0=2.589e-008           lpeb=0                    xj=1.7e-007
+ ngate=1e020               ndep=8.3687e017           nsd=1e020
+ phin=0                    cdsc=0                    cdscb=0
+ cdscd=0                   cit=0.0001                voff=-0.091100368
+ lvoff=1.0959669e-008      wvoff=2.6959026e-010      pvoff=-2.685119e-015+dpvoffp_hvt
+ nfactor=0.50790101        lnfactor=-7.8694081e-008  wnfactor=-6.2812227e-009
+ pnfactor=6.2560978e-014   eta0=0.016126316          leta0=3.8581895e-008
+ weta0=-3.1977064e-025     peta0=3.1849156e-030      etab=-0.1
+ u0=0.0067311685           lu0=4.0476674e-010        wu0=2.8712916e-010
+ pu0=-8.2389549e-017       ua=4.0287979e-010         lua=-1.482027e-016
+ wua=1.1912385e-033        pua=-1.1864735e-038       ub=4.3592011e-019
+ lub=3.9023175e-025        wub=2.6959026e-027        pub=-2.685119e-032
+ uc=-8.9281538e-011        luc=2.6993507e-017        wuc=5.0040401e-018
+ puc=-2.3018584e-024       vsat=114000               a0=2.1002168
+ la0=-1.0175975e-007       pvsat=0+dpvsatp_hvt       wa0=6.3954128e-025
+ pa0=-6.3698311e-030       ags=0.89183565            lags=2.4167291e-007
+ wags=-5.2765957e-009      pags=5.2554894e-014       a1=0
+ a2=1                      b0=0                      b1=0
+ keta=0.0098218219         lketa=-4.8783838e-008     wketa=-1.5705601e-008
+ pketa=7.2245766e-015      dwg=0                     dwb=0
+ pclm=0.10884211           lpclm=4.0993263e-007      wpclm=-2.5581651e-024
+ ppclm=2.5479324e-029      pdiblc1=-9.6842105e-020   lpdiblc1=9.6454737e-025
+ wpdiblc1=-8.8754181e-042  ppdiblc1=8.8399165e-047   pdiblc2=2.8016842e-005
+ lpdiblc2=6.7711225e-010   wpdiblc2=-4.9964162e-027  ppdiblc2=4.9764306e-032
+ pdiblcb=0                 drout=0                   pvag=1.5
+ delta=0.0047578947        ldelta=2.4113684e-009     wdelta=-1.9985665e-026
+ pdelta=1.9905722e-031     pscbe1=9.264e008          pscbe2=1e-020
+ fprout=200                pdits=0                   pditsd=0
+ pditsl=0                  rsh=9.68                  rdsw=210+drdswp_hvt
+ rsw=210                   rdw=210                   rdswmin=0
+ rdwmin=0                  prwg=0                    prwb=0
+ wr=1                      alpha0=0                  alpha1=0.06
+ beta0=12                  agidl=9e-008              bgidl=2.3e009
+ cgidl=0.5                 egidl=0.53                aigbacc=0.01066
+ bigbacc=0.001949          cigbacc=0.1416            nigbacc=4.05
+ aigbinv=0.35              bigbinv=0.03              cigbinv=0.006
+ eigbinv=1.1               nigbinv=1                 aigc=0.005985
+ bigc=0.000764             cigc=0                    aigsd=0.0048143269
+ waigsd=6.0434904e-011     bigsd=0.0001597           cigsd=0.001522
+ nigc=1                    poxedge=1                 pigcd=1.495
+ ntox=ntoxp_hvt            xrcrg1=12                 xrcrg2=1
+ cgso=cgop_hvt             cgdo=cgop_hvt             cgbo=0
+ cgdl=cglp_hvt             cgsl=cglp_hvt             clc=1e-007
+ cle=0.6                   cf=cfp_hvt                ckappas=0.6
+ acde=1.2                  moin=8                    noff=1.568
+ voffcv=-0.0540472         kt1=-0.2435               kt1l=0
+ kt2=-0.04696              ute=-1.544028             lute=1.0239041e-008
+ wute=-2.4885255e-009      pute=2.4785714e-014       ua1=7.27e-010
+ ub1=-3.2822385e-018       lub1=1.2335077e-026       wub1=-9.8158506e-027
+ pub1=9.7765872e-032       uc1=-6.421e-011           prt=0
+ at=256944.53              lat=-0.0024354821         wat=-5.9908947e-005
+ pat=5.9669312e-010        jss=1.50e-07              jsws=5.60e-13
+ jswgs=9.00e-12            njs=1                     ijthsfwd=0.01
+ ijthsrev=0.01             bvs=10                    xjbvs=1
+ pbs=0.751                 cjs=cjp_hvt               mjs=0.351
+ pbsws=0.8                 cjsws=cjswp_hvt           mjsws=0.01
+ pbswgs=1.15               cjswgs=cjswgp_hvt         mjswgs=0.678
+ tpb=1.56e-03              tcj=8.59e-04              tpbsw=1.56e-03
+ tcjsw=1.86e-04            tpbswg=3.00e-04           tcjswg=4.62e-04
+ xtis=3                    dmcg=9.25e-008            dmci=9.25e-008
+ dmdg=0                    dmcgt=0                   dwj=0
+ xgw=0                     xgl=0                     rshg=0.1
+ gbmin=1e-012              rbpb=50                   rbpd=50
+ rbps=50                   rbdb=50                   rbsb=50
+ ngcon=1                   saref=0.63e-6             sbref=0.63e-6
+ kvsat=-0.95               wlod=0.8e-6               tku0=0.1
+ ku0=1.3349e-7             llodku0=1                 wlodku0=1
+ lku0=1.5807e-7            wku0=6e-7                 pku0=0
+ kvth0=-1.5e-9             stk2=6e-10                steta0=0
+ lkvth0=-1.68e-15          wkvth0=0.5e-6             pkvth0=0
+ llodvth=2                 wlodvth=1                 lodk2=2
+ lodeta0=1                 fnoimod=1                 noia=1.30e+42
+ noib=9.00e+26             noic=8.75                 em=5.00e+07
+ ef=1.13                   wpemod=wpeflag_hvt        kvth0we=-0.0028
+ lkvth0we=0                wkvth0we=0                pkvth0we=0
+ ku0we=-0.0045             lku0we=4.50e-10           wku0we=0
+ pku0we=0                  k2we=0.00045              wk2we=0
+ web=-180                  wec=-3000                 scref=1.00e-06
+ ud=0                      tnoimod=0                 minr=1e-3

     15: type=p
+ lmin=2.4000e-07-dxlp_hvt  lmax=5.0000e-07-dxlp_hvt  wmin=2.4000e-07-dxwp_hvt
+ wmax=5.0000e-07-dxwp_hvt  version=4.5               binunit=2
+ paramchk=1                mobmod=0                  capmod=2
+ igcmod=1                  igbmod=1                  geomod=0
+ diomod=1                  rdsmod=0                  rbodymod=0
+ rgatemod=0                permod=1                  acnqsmod=0
+ trnqsmod=0                tnom=25                   toxe=toxp_hvt
+ toxm=toxp_hvt             dtox=5.1e-010             epsrox=3.9
+ wint=5e-009               lint=2.5e-009             ll=0
+ wl=0                      lln=1                     wln=1
+ lw=0                      ww=0                      lwn=1
+ wwn=1                     lwl=0                     wwl=0
+ llc=0                     wlc=0                     lwc=0
+ wwc=0                     lwlc=0                    wwlc=0
+ dlc=1.44e-08              dwc=0                     xpart=1
+ toxref=3e-009             dlcig=2.5e-009            xl=-3.5e-8+dxlp_hvt
+ xw=1.5e-8+dxwp_hvt        vth0=-0.3334+dvthp_hvt    wvth0=0+dwvthp_hvt
+ lvth0=0+dlvthp_hvt        pvth0=0+dpvthp_hvt        k1=0.3231
+ k2=0.027184209+dk2p_hvt   lk2=9.960429e-010         wk2=-5.444083e-009
+ pk2=3.2076987e-016        k3=-2.8                   k3b=1.2
+ w0=1e-007                 dvt0=15.61                dvt1=1.25
+ dvt2=0                    dvt0w=0                   dvt1w=0
+ dvt2w=0                   dsub=0.5                  minv=0
+ voffl=0                   dvtp0=1.09e-008           dvtp1=4
+ lpe0=2.589e-008           lpeb=0                    xj=1.7e-007
+ ngate=1e020               ndep=8.3687e017           nsd=1e020
+ phin=0                    cdsc=0                    cdscb=0
+ cdscd=0                   cit=0.0001                voff=-0.059206953
+ lvoff=-3.7113018e-009     wvoff=-7.5442966e-009     pvoff=9.0926893e-016+dpvoffp_hvt
+ nfactor=0.074713018       lnfactor=1.205724e-007    wnfactor=1.5479535e-007
+ pnfactor=-1.1534245e-014  eta0=0.014176036          leta0=3.9479024e-008
+ weta0=1.1603794e-008      peta0=-5.3377454e-015     etab=-0.1
+ u0=0.0080566287           lu0=-2.0494497e-010       wu0=8.3862123e-011
+ pu0=1.1113287e-017        ua=8.07e-011              ub=1.2198269e-018
+ lub=2.9634615e-026        wub=-9.8504135e-026       pub=1.9700827e-032
+ uc=-7.3701923e-011        luc=1.9826885e-017        wuc=-1.0944904e-018
+ puc=5.0346558e-025        vsat=114000               a0=2.3643846
+ la0=-2.2327692e-007       pvsat=0+dpvsatp_hvt       ags=-0.27590976
+ lags=7.788358e-007        wags=1.3434046e-008       pags=4.3947999e-014
+ a1=0                      a2=1                      b0=0
+ b1=0                      keta=-0.077406923         lketa=-8.6586154e-009
+ dwg=0                     dwb=0                     pclm=1.079142
+ lpclm=-3.6405325e-008     wpclm=1.8302515e-008      ppclm=-8.4191568e-015
+ pdiblc1=2e-018            pdiblc2=0.0015            pdiblcb=0
+ drout=0                   pvag=1.5                  delta=0.01
+ pscbe1=9.264e008          pscbe2=1e-020             fprout=200
+ pdits=0                   pditsd=0                  pditsl=0
+ rsh=9.68                  rdsw=210+drdswp_hvt       rsw=210
+ rdw=210                   rdswmin=0                 rdwmin=0
+ prwg=0                    prwb=0                    wr=1
+ alpha0=0                  alpha1=0.06               beta0=12
+ agidl=9e-008              bgidl=2.3e009             cgidl=0.5
+ egidl=0.53                aigbacc=0.01066           bigbacc=0.001949
+ cigbacc=0.1416            nigbacc=4.05              aigbinv=0.35
+ bigbinv=0.03              cigbinv=0.006             eigbinv=1.1
+ nigbinv=1                 aigc=0.005985             bigc=0.000764
+ cigc=0                    aigsd=0.0048143269        waigsd=6.0434904e-011
+ bigsd=0.0001597           cigsd=0.001522            nigc=1
+ poxedge=1                 pigcd=1.495               ntox=ntoxp_hvt
+ xrcrg1=12                 xrcrg2=1                  cgso=cgop_hvt
+ cgdo=cgop_hvt             cgbo=0                    cgdl=cglp_hvt
+ cgsl=cglp_hvt             clc=1e-007                cle=0.6
+ cf=cfp_hvt                ckappas=0.6               acde=1.2
+ moin=8                    noff=1.568                voffcv=-0.0540472
+ kt1=-0.2435               kt1l=0                    kt2=-0.04696
+ ute=-1.7383373            lute=9.9621302e-008       wute=1.3046033e-007
+ pute=-3.6370757e-014      ua1=7.27e-010             ub1=-3.5888254e-018
+ lub1=1.5336509e-025       wub1=3.5865608e-025       pub1=-7.1731216e-032
+ uc1=-6.421e-011           prt=0                     at=304769.82
+ lat=-0.024435118          wat=0.00032212426         pat=4.2095784e-010
+ jss=1.50e-07              jsws=5.60e-13             jswgs=9.00e-12
+ njs=1                     ijthsfwd=0.01             ijthsrev=0.01
+ bvs=10                    xjbvs=1                   pbs=0.751
+ cjs=cjp_hvt               mjs=0.351                 pbsws=0.8
+ cjsws=cjswp_hvt           mjsws=0.01                pbswgs=1.15
+ cjswgs=cjswgp_hvt         mjswgs=0.678              tpb=1.56e-03
+ tcj=8.59e-04              tpbsw=1.56e-03            tcjsw=1.86e-04
+ tpbswg=3.00e-04           tcjswg=4.62e-04           xtis=3
+ dmcg=9.25e-008            dmci=9.25e-008            dmdg=0
+ dmcgt=0                   dwj=0                     xgw=0
+ xgl=0                     rshg=0.1                  gbmin=1e-012
+ rbpb=50                   rbpd=50                   rbps=50
+ rbdb=50                   rbsb=50                   ngcon=1
+ saref=0.63e-6             sbref=0.63e-6             kvsat=-0.95
+ wlod=0.8e-6               tku0=0.1                  ku0=1.3349e-7
+ llodku0=1                 wlodku0=1                 lku0=1.5807e-7
+ wku0=6e-7                 pku0=0                    kvth0=-1.5e-9
+ stk2=6e-10                steta0=0                  lkvth0=-1.68e-15
+ wkvth0=0.5e-6             pkvth0=0                  llodvth=2
+ wlodvth=1                 lodk2=2                   lodeta0=1
+ fnoimod=1                 noia=1.30e+42             noib=9.00e+26
+ noic=8.75                 em=5.00e+07               ef=1.13
+ wpemod=wpeflag_hvt        kvth0we=-0.0028           lkvth0we=0
+ wkvth0we=0                pkvth0we=0                ku0we=-0.0045
+ lku0we=4.50e-10           wku0we=0                  pku0we=0
+ k2we=0.00045              wk2we=0                   web=-180
+ wec=-3000                 scref=1.00e-06            ud=0
+ tnoimod=0                 minr=1e-3

     16: type=p
+ lmin=1.000e-07            lmax=2.4000e-07-dxlp_hvt  wmin=2.4000e-07-dxwp_hvt
+ wmax=5.0000e-07-dxwp_hvt  version=4.5               binunit=2
+ paramchk=1                mobmod=0                  capmod=2
+ igcmod=1                  igbmod=1                  geomod=0
+ diomod=1                  rdsmod=0                  rbodymod=0
+ rgatemod=0                permod=1                  acnqsmod=0
+ trnqsmod=0                tnom=25                   toxe=toxp_hvt
+ toxm=toxp_hvt             dtox=5.1e-010             epsrox=3.9
+ wint=5e-009               lint=2.5e-009             ll=0
+ wl=0                      lln=1                     wln=1
+ lw=0                      ww=0                      lwn=1
+ wwn=1                     lwl=0                     wwl=0
+ llc=0                     wlc=0                     lwc=0
+ wwc=0                     lwlc=0                    wwlc=0
+ dlc=1.44e-08              dwc=0                     xpart=1
+ toxref=3e-009             dlcig=2.5e-009            xl=-3.5e-8+dxlp_hvt
+ xw=1.5e-8+dxwp_hvt        vth0=-0.3268478+dvthp_hvt lvth0=-1.3104396e-009+dlvthp_hvt
+ wvth0=1.0197115e-009+dwvthp_hvt                     pvth0=-2.0394231e-016+dpvthp_hvt
+ k1=0.30326951             lk1=3.9660989e-009        wk1=-1.0503029e-008
+ pk1=2.1006058e-015        k2=0.020709698+dk2p_hvt   lk2=2.2909451e-009
+ wk2=1.894624e-009         pk2=-1.1469715e-015       k3=-2.8
+ k3b=1.2                   w0=1e-007                 dvt0=15.61
+ dvt1=1.25                 dvt2=0                    dvt0w=0
+ dvt1w=0                   dvt2w=0                   dsub=0.5
+ minv=0                    voffl=0                   dvtp0=1.09e-008
+ dvtp1=4                   lpe0=2.589e-008           lpeb=0
+ xj=1.7e-007               ngate=1e020               ndep=8.3687e017
+ nsd=1e020                 phin=0                    cdsc=0
+ cdscb=0                   cdscd=0                   cit=0.0001
+ voff=-0.078646978         lvoff=1.767033e-010       wvoff=1.7335096e-009
+ pvoff=-9.4629231e-016+dpvoffp_hvt                   nfactor=-0.11033791
+ lnfactor=1.5758258e-007   wnfactor=2.4112779e-007   pnfactor=-2.8800733e-014
+ eta0=0.2167               leta0=-1.0257692e-009     weta0=-1.7675e-008
+ peta0=5.1801346e-016      etab=-0.1                 u0=0.0072954918
+ lu0=-5.2717582e-011       wu0=2.2793952e-010        pu0=-1.7702192e-017
+ ua=2.4642857e-010         lua=-3.3145714e-017       ub=1.0417335e-018
+ lub=6.5253297e-026        wub=2.0190288e-026        pub=-4.0380577e-033
+ uc=-6.7486071e-011        luc=1.8583714e-017        wuc=1.9875538e-017
+ puc=-3.69054e-024         vsat=119657.14            lvsat=-0.0011314286
+ wvsat=-0.004242           pvsat=8.484e-010+dpvsatp_hvt
+ a0=1.1275714              la0=2.4085714e-008        ags=0.44848901
+ lags=6.3395604e-007       wags=3.8817019e-007       pags=-3.0999231e-014
+ a1=0                      a2=1                      b0=0
+ b1=0                      keta=-0.16711             lketa=9.282e-009
+ dwg=0                     dwb=0                     pclm=1.153022
+ lpclm=-5.1181319e-008     wpclm=-3.3990385e-008     ppclm=2.0394231e-015
+ pdiblc1=2e-018            pdiblc2=0.0012980769      lpdiblc2=4.0384615e-011
+ wpdiblc2=1.0197115e-010   ppdiblc2=-2.0394231e-017  pdiblcb=0
+ drout=0                   pvag=1.5                  delta=0.01
+ pscbe1=9.264e008          pscbe2=1e-020             fprout=200
+ pdits=0                   pditsd=0                  pditsl=0
+ rsh=9.68                  rdsw=210+drdswp_hvt       rsw=210
+ rdw=210                   rdswmin=0                 rdwmin=0
+ prwg=0                    prwb=0                    wr=1
+ alpha0=0                  alpha1=0.06               beta0=12
+ agidl=9e-008              bgidl=2.3e009             cgidl=0.5
+ egidl=0.53                aigbacc=0.01066           bigbacc=0.001949
+ cigbacc=0.1416            nigbacc=4.05              aigbinv=0.35
+ bigbinv=0.03              cigbinv=0.006             eigbinv=1.1
+ nigbinv=1                 aigc=0.005985             bigc=0.000764
+ cigc=0                    aigsd=0.0048143269        waigsd=6.0434904e-011
+ bigsd=0.0001597           cigsd=0.001522            nigc=1
+ poxedge=1                 pigcd=1.495               ntox=ntoxp_hvt
+ xrcrg1=12                 xrcrg2=1                  cgso=cgop_hvt
+ cgdo=cgop_hvt             cgbo=0                    cgdl=cglp_hvt
+ cgsl=cglp_hvt             clc=1e-007                cle=0.6
+ cf=cfp_hvt                ckappas=0.6               acde=1.2
+ moin=8                    noff=1.568                voffcv=-0.0540472
+ kt1=-0.22119121           lkt1=-4.4617582e-009      wkt1=-5.4656538e-009
+ pkt1=1.0931308e-015       kt1l=0                    kt2=-0.04696
+ ute=-1.3889368            lute=2.9741209e-008       wute=-2.3045481e-008
+ pute=-5.6695962e-015      ua1=7.27e-010             ub1=-3.3143214e-018
+ lub1=9.8464286e-026       wub1=1.0339875e-025       pub1=-2.067975e-032
+ uc1=-6.421e-011           prt=0                     at=210398.63
+ lat=-0.0055608791         wat=0.0023453365          pat=1.6315385e-011
+ jss=1.50e-07              jsws=5.60e-13             jswgs=9.00e-12
+ njs=1                     ijthsfwd=0.01             ijthsrev=0.01
+ bvs=10                    xjbvs=1                   pbs=0.751
+ cjs=cjp_hvt               mjs=0.351                 pbsws=0.8
+ cjsws=cjswp_hvt           mjsws=0.01                pbswgs=1.15
+ cjswgs=cjswgp_hvt         mjswgs=0.678              tpb=1.56e-03
+ tcj=8.59e-04              tpbsw=1.56e-03            tcjsw=1.86e-04
+ tpbswg=3.00e-04           tcjswg=4.62e-04           xtis=3
+ dmcg=9.25e-008            dmci=9.25e-008            dmdg=0
+ dmcgt=0                   dwj=0                     xgw=0
+ xgl=0                     rshg=0.1                  gbmin=1e-012
+ rbpb=50                   rbpd=50                   rbps=50
+ rbdb=50                   rbsb=50                   ngcon=1
+ saref=0.63e-6             sbref=0.63e-6             kvsat=-0.95
+ wlod=0.8e-6               tku0=0.1                  ku0=1.3349e-7
+ llodku0=1                 wlodku0=1                 lku0=1.5807e-7
+ wku0=6e-7                 pku0=0                    kvth0=-1.5e-9
+ stk2=6e-10                steta0=0                  lkvth0=-1.68e-15
+ wkvth0=0.5e-6             pkvth0=0                  llodvth=2
+ wlodvth=1                 lodk2=2                   lodeta0=1
+ fnoimod=1                 noia=1.30e+42             noib=9.00e+26
+ noic=8.75                 em=5.00e+07               ef=1.13
+ wpemod=wpeflag_hvt        kvth0we=-0.0028           lkvth0we=0
+ wkvth0we=0                pkvth0we=0                ku0we=-0.0045
+ lku0we=4.50e-10           wku0we=0                  pku0we=0
+ k2we=0.00045              wk2we=0                   web=-180
+ wec=-3000                 scref=1.00e-06            ud=0
+ tnoimod=0                 minr=1e-3

     17: type=p
+ lmin=1.0000e-05-dxlp_hvt  lmax=2.001e-05            wmin=1.200e-07
+ wmax=2.4000e-07-dxwp_hvt  version=4.5               binunit=2
+ paramchk=1                mobmod=0                  capmod=2
+ igcmod=1                  igbmod=1                  geomod=0
+ diomod=1                  rdsmod=0                  rbodymod=0
+ rgatemod=0                permod=1                  acnqsmod=0
+ trnqsmod=0                tnom=25                   toxe=toxp_hvt
+ toxm=toxp_hvt             dtox=5.1e-010             epsrox=3.9
+ wint=5e-009               lint=2.5e-009             ll=0
+ wl=0                      lln=1                     wln=1
+ lw=0                      ww=0                      lwn=1
+ wwn=1                     lwl=0                     wwl=0
+ llc=0                     wlc=0                     lwc=0
+ wwc=0                     lwlc=0                    wwlc=0
+ dlc=1.44e-08              dwc=0                     xpart=1
+ toxref=3e-009             dlcig=2.5e-009            xl=-3.5e-8+dxlp_hvt
+ xw=1.5e-8+dxwp_hvt        vth0=-0.3334+dvthp_hvt    wvth0=0+dwvthp_hvt
+ lvth0=0+dlvthp_hvt        pvth0=0+dpvthp_hvt        k1=0.3231
+ k2=0.019424267+dk2p_hvt   wk2=-4.5880333e-009       k3=-2.8
+ k3b=1.2                   w0=1e-007                 dvt0=15.61
+ dvt1=1.25                 dvt2=0                    dvt0w=0
+ dvt1w=0                   dvt2w=0                   dsub=0.5
+ minv=0                    voffl=0                   dvtp0=1.09e-008
+ dvtp1=4                   lpe0=2.589e-008           lpeb=0
+ xj=1.7e-007               ngate=1e020               ndep=8.3687e017
+ nsd=1e020                 phin=0                    cdsc=0
+ cdscb=0                   cdscd=0                   cit=0.0001
+ voff=-0.09                pvoff=0+dpvoffp_hvt       nfactor=0.5
+ eta0=0.02                 etab=-0.1                 u0=0.0077454167
+ wu0=4.0322917e-011        ua=3.88e-010              ub=4.751e-019
+ uc=-6.709e-011            vsat=114000               pvsat=0+dpvsatp_hvt
+ a0=2.743125               wa0=-1.6001562e-007       ags=0.59120417
+ wags=7.9599479e-008       a1=0                      a2=1
+ b0=0                      b1=0                      keta=-0.02693875
+ wketa=-7.1739063e-009     dwg=0                     dwb=0
+ pclm=0.15                 pdiblc1=0                 pdiblc2=9.6e-005
+ pdiblcb=0                 drout=0                   pvag=1.5
+ delta=0.005               pscbe1=9.264e008          pscbe2=1e-020
+ fprout=200                pdits=0                   pditsd=0
+ pditsl=0                  rsh=9.68                  rdsw=210+drdswp_hvt
+ rsw=210                   rdw=210                   rdswmin=0
+ rdwmin=0                  prwg=0                    prwb=0
+ wr=1                      alpha0=0                  alpha1=0.06
+ beta0=12                  agidl=9e-008              bgidl=2.3e009
+ cgidl=0.5                 egidl=0.53                aigbacc=0.01066
+ bigbacc=0.001949          cigbacc=0.1416            nigbacc=4.05
+ aigbinv=0.35              bigbinv=0.03              cigbinv=0.006
+ eigbinv=1.1               nigbinv=1                 aigc=0.005985
+ bigc=0.000764             cigc=0                    aigsd=0.0049182917
+ waigsd=3.4963542e-011     bigsd=0.0001597           cigsd=0.001522
+ nigc=1                    poxedge=1                 pigcd=1.495
+ ntox=ntoxp_hvt            xrcrg1=12                 xrcrg2=1
+ cgso=cgop_hvt             cgdo=cgop_hvt             cgbo=0
+ cgdl=cglp_hvt             cgsl=cglp_hvt             clc=1e-007
+ cle=0.6                   cf=cfp_hvt                ckappas=0.6
+ acde=1.2                  moin=8                    noff=1.568
+ voffcv=-0.0540472         kt1=-0.2435               kt1l=0
+ kt2=-0.04696              ute=-1.543                ua1=7.27e-010
+ ub1=-3.281e-018           uc1=-6.421e-011           prt=0
+ at=256700                 jss=1.50e-07              jsws=5.60e-13
+ jswgs=9.00e-12            njs=1                     ijthsfwd=0.01
+ ijthsrev=0.01             bvs=10                    xjbvs=1
+ pbs=0.751                 cjs=cjp_hvt               mjs=0.351
+ pbsws=0.8                 cjsws=cjswp_hvt           mjsws=0.01
+ pbswgs=1.15               cjswgs=cjswgp_hvt         mjswgs=0.678
+ tpb=1.56e-03              tcj=8.59e-04              tpbsw=1.56e-03
+ tcjsw=1.86e-04            tpbswg=3.00e-04           tcjswg=4.62e-04
+ xtis=3                    dmcg=9.25e-008            dmci=9.25e-008
+ dmdg=0                    dmcgt=0                   dwj=0
+ xgw=0                     xgl=0                     rshg=0.1
+ gbmin=1e-012              rbpb=50                   rbpd=50
+ rbps=50                   rbdb=50                   rbsb=50
+ ngcon=1                   saref=0.63e-6             sbref=0.63e-6
+ kvsat=-0.95               wlod=0.8e-6               tku0=0.1
+ ku0=1.3349e-7             llodku0=1                 wlodku0=1
+ lku0=1.5807e-7            wku0=6e-7                 pku0=0
+ kvth0=-1.5e-9             stk2=6e-10                steta0=0
+ lkvth0=-1.68e-15          wkvth0=0.5e-6             pkvth0=0
+ llodvth=2                 wlodvth=1                 lodk2=2
+ lodeta0=1                 fnoimod=1                 noia=1.30e+42
+ noib=9.00e+26             noic=8.75                 em=5.00e+07
+ ef=1.13                   wpemod=wpeflag_hvt        kvth0we=-0.0028
+ lkvth0we=0                wkvth0we=0                pkvth0we=0
+ ku0we=-0.0045             lku0we=4.50e-10           wku0we=0
+ pku0we=0                  k2we=0.00045              wk2we=0
+ web=-180                  wec=-3000                 scref=1.00e-06
+ ud=0                      tnoimod=0                 minr=1e-3

     18: type=p
+ lmin=5.0000e-07-dxlp_hvt  lmax=1.0000e-05-dxlp_hvt  wmin=1.200e-07
+ wmax=2.4000e-07-dxwp_hvt  version=4.5               binunit=2
+ paramchk=1                mobmod=0                  capmod=2
+ igcmod=1                  igbmod=1                  geomod=0
+ diomod=1                  rdsmod=0                  rbodymod=0
+ rgatemod=0                permod=1                  acnqsmod=0
+ trnqsmod=0                tnom=25                   toxe=toxp_hvt
+ toxm=toxp_hvt             dtox=5.1e-010             epsrox=3.9
+ wint=5e-009               lint=2.5e-009             ll=0
+ wl=0                      lln=1                     wln=1
+ lw=0                      ww=0                      lwn=1
+ wwn=1                     lwl=0                     wwl=0
+ llc=0                     wlc=0                     lwc=0
+ wwc=0                     lwlc=0                    wwlc=0
+ dlc=1.44e-08              dwc=0                     xpart=1
+ toxref=3e-009             dlcig=2.5e-009            xl=-3.5e-8+dxlp_hvt
+ xw=1.5e-8+dxwp_hvt        vth0=-0.3334+dvthp_hvt    wvth0=0+dwvthp_hvt
+ lvth0=0+dlvthp_hvt        pvth0=0+dpvthp_hvt        k1=0.3231
+ k2=0.019089117+dk2p_hvt   lk2=3.3380895e-009        wk2=-4.615981e-009
+ pk2=2.7835832e-016        k3=-2.8                   k3b=1.2
+ w0=1e-007                 dvt0=15.61                dvt1=1.25
+ dvt2=0                    dvt0w=0                   dvt1w=0
+ dvt2w=0                   dsub=0.5                  minv=0
+ voffl=0                   dvtp0=1.09e-008           dvtp1=4
+ lpe0=2.589e-008           lpeb=0                    xj=1.7e-007
+ ngate=1e020               ndep=8.3687e017           nsd=1e020
+ phin=0                    cdsc=0                    cdscb=0
+ cdscd=0                   cit=0.0001                voff=-0.090453947
+ lvoff=4.5213158e-009      wvoff=1.1121711e-010      pvoff=-1.1077224e-015+dpvoffp_hvt
+ nfactor=0.48007938        lnfactor=1.984094e-007    wnfactor=5.3507785e-010
+ pnfactor=-5.3293754e-015  eta0=0.016126316          leta0=3.8581895e-008
+ weta0=-1.7149415e-025     peta0=1.7080818e-030      etab=-0.1
+ u0=0.0077674422           lu0=-2.1937424e-010       wu0=3.3242094e-011
+ pu0=7.0524991e-017        ua=4.0287979e-010         lua=-1.482027e-016
+ wua=6.3886551e-034        pua=-6.3631005e-039       ub=4.4425054e-019
+ lub=3.0726058e-025        wub=6.5494518e-028        pub=-6.5232539e-033
+ uc=-6.8093244e-011        luc=9.9923088e-018        wuc=-1.8709189e-019
+ puc=1.8634352e-024        vsat=114000               a0=2.7991905
+ la0=-5.5841264e-007       pvsat=0+dpvsatp_hvt       wa0=-1.7124855e-007
+ pa0=1.1187996e-013        ags=0.53532002            lags=5.5660613e-007
+ wags=8.2069735e-008       pags=-2.4603745e-014      a1=0
+ a2=1                      b0=0                      b1=0
+ keta=-0.022904187         lketa=-4.0184249e-008     wketa=-7.6877293e-009
+ pketa=5.1176773e-015      dwg=0                     dwb=0
+ pclm=0.10884211           lpclm=4.0993263e-007      wpclm=-1.3719532e-024
+ ppclm=1.3664654e-029      pdiblc1=-9.6842105e-020   lpdiblc1=9.6454737e-025
+ wpdiblc1=-4.759919e-042   ppdiblc1=4.7408793e-047   pdiblc2=2.8016842e-005
+ lpdiblc2=6.7711225e-010   wpdiblc2=-2.6795962e-027  ppdiblc2=2.6688778e-032
+ pdiblcb=0                 drout=0                   pvag=1.5
+ delta=0.0047578947        ldelta=2.4113684e-009     wdelta=-1.0718385e-026
+ pdelta=1.0675511e-031     pscbe1=9.264e008          pscbe2=1e-020
+ fprout=200                pdits=0                   pditsd=0
+ pditsl=0                  rsh=9.68                  rdsw=210+drdswp_hvt
+ rsw=210                   rdw=210                   rdswmin=0
+ rdwmin=0                  prwg=0                    prwb=0
+ wr=1                      alpha0=0                  alpha1=0.06
+ beta0=12                  agidl=9e-008              bgidl=2.3e009
+ cgidl=0.5                 egidl=0.53                aigbacc=0.01066
+ bigbacc=0.001949          cigbacc=0.1416            nigbacc=4.05
+ aigbinv=0.35              bigbinv=0.03              cigbinv=0.006
+ eigbinv=1.1               nigbinv=1                 aigc=0.005985
+ bigc=0.000764             cigc=0                    aigsd=0.0049182917
+ waigsd=3.4963542e-011     bigsd=0.0001597           cigsd=0.001522
+ nigc=1                    poxedge=1                 pigcd=1.495
+ ntox=ntoxp_hvt            xrcrg1=12                 xrcrg2=1
+ cgso=cgop_hvt             cgdo=cgop_hvt             cgbo=0
+ cgdl=cglp_hvt             cgsl=cglp_hvt             clc=1e-007
+ cle=0.6                   cf=cfp_hvt                ckappas=0.6
+ acde=1.2                  moin=8                    noff=1.568
+ voffcv=-0.0540472         kt1=-0.2435               kt1l=0
+ kt2=-0.04696              ute=-1.5634155            lute=2.0333864e-007
+ wute=2.2614145e-009       pute=-2.2523688e-014      ua1=7.27e-010
+ ub1=-3.3405115e-018       lub1=5.9273445e-025       wub1=4.4610417e-027
+ pub1=-4.4431975e-032      uc1=-6.421e-011           prt=0
+ at=256700                 jss=1.50e-07              jsws=5.60e-13
+ jswgs=9.00e-12            njs=1                     ijthsfwd=0.01
+ ijthsrev=0.01             bvs=10                    xjbvs=1
+ pbs=0.751                 cjs=cjp_hvt               mjs=0.351
+ pbsws=0.8                 cjsws=cjswp_hvt           mjsws=0.01
+ pbswgs=1.15               cjswgs=cjswgp_hvt         mjswgs=0.678
+ tpb=1.56e-03              tcj=8.59e-04              tpbsw=1.56e-03
+ tcjsw=1.86e-04            tpbswg=3.00e-04           tcjswg=4.62e-04
+ xtis=3                    dmcg=9.25e-008            dmci=9.25e-008
+ dmdg=0                    dmcgt=0                   dwj=0
+ xgw=0                     xgl=0                     rshg=0.1
+ gbmin=1e-012              rbpb=50                   rbpd=50
+ rbps=50                   rbdb=50                   rbsb=50
+ ngcon=1                   saref=0.63e-6             sbref=0.63e-6
+ kvsat=-0.95               wlod=0.8e-6               tku0=0.1
+ ku0=1.3349e-7             llodku0=1                 wlodku0=1
+ lku0=1.5807e-7            wku0=6e-7                 pku0=0
+ kvth0=-1.5e-9             stk2=6e-10                steta0=0
+ lkvth0=-1.68e-15          wkvth0=0.5e-6             pkvth0=0
+ llodvth=2                 wlodvth=1                 lodk2=2
+ lodeta0=1                 fnoimod=1                 noia=1.30e+42
+ noib=9.00e+26             noic=8.75                 em=5.00e+07
+ ef=1.13                   wpemod=wpeflag_hvt        kvth0we=-0.0028
+ lkvth0we=0                wkvth0we=0                pkvth0we=0
+ ku0we=-0.0045             lku0we=4.50e-10           wku0we=0
+ pku0we=0                  k2we=0.00045              wk2we=0
+ web=-180                  wec=-3000                 scref=1.00e-06
+ ud=0                      tnoimod=0                 minr=1e-3

     19: type=p
+ lmin=2.4000e-07-dxlp_hvt  lmax=5.0000e-07-dxlp_hvt  wmin=1.200e-07
+ wmax=2.4000e-07-dxwp_hvt  version=4.5               binunit=2
+ paramchk=1                mobmod=0                  capmod=2
+ igcmod=1                  igbmod=1                  geomod=0
+ diomod=1                  rdsmod=0                  rbodymod=0
+ rgatemod=0                permod=1                  acnqsmod=0
+ trnqsmod=0                tnom=25                   toxe=toxp_hvt
+ toxm=toxp_hvt             dtox=5.1e-010             epsrox=3.9
+ wint=5e-009               lint=2.5e-009             ll=0
+ wl=0                      lln=1                     wln=1
+ lw=0                      ww=0                      lwn=1
+ wwn=1                     lwl=0                     wwl=0
+ llc=0                     wlc=0                     lwc=0
+ wwc=0                     lwlc=0                    wwlc=0
+ dlc=1.44e-08              dwc=0                     xpart=1
+ toxref=3e-009             dlcig=2.5e-009            xl=-3.5e-8+dxlp_hvt
+ xw=1.5e-8+dxwp_hvt        vth0=-0.3334+dvthp_hvt    wvth0=0+dwvthp_hvt
+ lvth0=0+dlvthp_hvt        pvth0=0+dpvthp_hvt        k1=0.3231
+ k2=0.023992949+dk2p_hvt   lk2=1.0823269e-009        wk2=-4.6622244e-009
+ pk2=2.9963029e-016        k3=-2.8                   k3b=1.2
+ w0=1e-007                 dvt0=15.61                dvt1=1.25
+ dvt2=0                    dvt0w=0                   dvt1w=0
+ dvt2w=0                   dsub=0.5                  minv=0
+ voffl=0                   dvtp0=1.09e-008           dvtp1=4
+ lpe0=2.589e-008           lpeb=0                    xj=1.7e-007
+ ngate=1e020               ndep=8.3687e017           nsd=1e020
+ phin=0                    cdsc=0                    cdscb=0
+ cdscd=0                   cit=0.0001                voff=-0.080625
+ wvoff=-2.296875e-009      pvoff=0+dpvoffp_hvt       nfactor=0.58520865
+ lnfactor=1.5004994e-007   wnfactor=2.9723918e-008   pnfactor=-1.8756242e-014
+ eta0=0.021474359          leta0=3.6121795e-008      weta0=9.8157051e-009
+ peta0=-4.5152244e-015     etab=-0.1                 u0=0.0073498045
+ lu0=-2.7260897e-011       wu0=2.5703405e-010        pu0=-3.2419311e-017
+ ua=8.07e-011              ub=8.1688782e-019         lub=1.3584744e-025
+ wub=2.1594551e-028        pub=-6.3213141e-033       uc=-9.6520192e-011
+ luc=2.3068705e-017        wuc=4.4959856e-018        puc=-2.9078045e-025
+ vsat=114000               a0=1.9047692              pvsat=0+dpvsatp_hvt
+ la0=-1.4697885e-007       wa0=1.1260577e-007        pa0=-1.8693029e-014
+ ags=-0.13341667           lags=8.64225e-007         wags=-2.1476763e-008
+ pags=2.3027644e-014       a1=0                      a2=1
+ b0=0                      b1=0                      keta=-0.10223144
+ lketa=-3.6937115e-009     wketa=6.0820072e-009      pketa=-1.2164014e-015
+ dwg=0                     dwb=0                     pclm=1.1538462
+ lpclm=-7.0769231e-008     pdiblc1=2e-018            pdiblc2=0.0015
+ pdiblcb=0                 drout=0                   pvag=1.5
+ delta=0.01                pscbe1=9.264e008          pscbe2=1e-020
+ fprout=200                pdits=0                   pditsd=0
+ pditsl=0                  rsh=9.68                  rdsw=210+drdswp_hvt
+ rsw=210                   rdw=210                   rdswmin=0
+ rdwmin=0                  prwg=0                    prwb=0
+ wr=1                      alpha0=0                  alpha1=0.06
+ beta0=12                  agidl=9e-008              bgidl=2.3e009
+ cgidl=0.5                 egidl=0.53                aigbacc=0.01066
+ bigbacc=0.001949          cigbacc=0.1416            nigbacc=4.05
+ aigbinv=0.35              bigbinv=0.03              cigbinv=0.006
+ eigbinv=1.1               nigbinv=1                 aigc=0.005985
+ bigc=0.000764             cigc=0                    aigsd=0.0049182917
+ waigsd=3.4963542e-011     bigsd=0.0001597           cigsd=0.001522
+ nigc=1                    poxedge=1                 pigcd=1.495
+ ntox=ntoxp_hvt            xrcrg1=12                 xrcrg2=1
+ cgso=cgop_hvt             cgdo=cgop_hvt             cgbo=0
+ cgdl=cglp_hvt             cgsl=cglp_hvt             clc=1e-007
+ cle=0.6                   cf=cfp_hvt                ckappas=0.6
+ acde=1.2                  moin=8                    noff=1.568
+ voffcv=-0.0540472         kt1=-0.2435               kt1l=0
+ kt2=-0.04696              ute=-0.83172756           lute=-1.3323782e-007
+ wute=-9.1659054e-008      pute=2.0679728e-014       ua1=7.27e-010
+ ub1=-1.3538494e-018       lub1=-3.2113013e-025      wub1=-1.8891306e-025
+ pub1=4.4520112e-032       uc1=-6.421e-011           prt=0
+ at=295828.21              lat=-0.017998974          wat=0.0025128205
+ pat=-1.1558974e-009       jss=1.50e-07              jsws=5.60e-13
+ jswgs=9.00e-12            njs=1                     ijthsfwd=0.01
+ ijthsrev=0.01             bvs=10                    xjbvs=1
+ pbs=0.751                 cjs=cjp_hvt               mjs=0.351
+ pbsws=0.8                 cjsws=cjswp_hvt           mjsws=0.01
+ pbswgs=1.15               cjswgs=cjswgp_hvt         mjswgs=0.678
+ tpb=1.56e-03              tcj=8.59e-04              tpbsw=1.56e-03
+ tcjsw=1.86e-04            tpbswg=3.00e-04           tcjswg=4.62e-04
+ xtis=3                    dmcg=9.25e-008            dmci=9.25e-008
+ dmdg=0                    dmcgt=0                   dwj=0
+ xgw=0                     xgl=0                     rshg=0.1
+ gbmin=1e-012              rbpb=50                   rbpd=50
+ rbps=50                   rbdb=50                   rbsb=50
+ ngcon=1                   saref=0.63e-6             sbref=0.63e-6
+ kvsat=-0.95               wlod=0.8e-6               tku0=0.1
+ ku0=1.3349e-7             llodku0=1                 wlodku0=1
+ lku0=1.5807e-7            wku0=6e-7                 pku0=0
+ kvth0=-1.5e-9             stk2=6e-10                steta0=0
+ lkvth0=-1.68e-15          wkvth0=0.5e-6             pkvth0=0
+ llodvth=2                 wlodvth=1                 lodk2=2
+ lodeta0=1                 fnoimod=1                 noia=1.30e+42
+ noib=9.00e+26             noic=8.75                 em=5.00e+07
+ ef=1.13                   wpemod=wpeflag_hvt        kvth0we=-0.0028
+ lkvth0we=0                wkvth0we=0                pkvth0we=0
+ ku0we=-0.0045             lku0we=4.50e-10           wku0we=0
+ pku0we=0                  k2we=0.00045              wk2we=0
+ web=-180                  wec=-3000                 scref=1.00e-06
+ ud=0                      tnoimod=0                 minr=1e-3

     20: type=p
+ lmin=1.000e-07            lmax=2.4000e-07-dxlp_hvt  wmin=1.200e-07
+ wmax=2.4000e-07-dxwp_hvt  version=4.5               binunit=2
+ paramchk=1                mobmod=0                  capmod=2
+ igcmod=1                  igbmod=1                  geomod=0
+ diomod=1                  rdsmod=0                  rbodymod=0
+ rgatemod=0                permod=1                  acnqsmod=0
+ trnqsmod=0                tnom=25                   toxe=toxp_hvt
+ toxm=toxp_hvt             dtox=5.1e-010             epsrox=3.9
+ wint=5e-009               lint=2.5e-009             ll=0
+ wl=0                      lln=1                     wln=1
+ lw=0                      ww=0                      lwn=1
+ wwn=1                     lwl=0                     wwl=0
+ llc=0                     wlc=0                     lwc=0
+ wwc=0                     lwlc=0                    wwlc=0
+ dlc=1.44e-08              dwc=0                     xpart=1
+ toxref=3e-009             dlcig=2.5e-009            xl=-3.5e-8+dxlp_hvt
+ xw=1.5e-8+dxwp_hvt        vth0=-0.31969464+dvthp_hvt
+ lvth0=-2.7410714e-009+dlvthp_hvt                    wvth0=-7.328125e-010+dwvthp_hvt
+ pvth0=1.465625e-016+dpvthp_hvt                      k1=0.2604
+ lk1=1.254e-008            k2=0.046316369+dk2p_hvt   lk2=-3.3823571e-009
+ wk2=-4.3790104e-009       pk2=2.429875e-016         k3=-2.8
+ k3b=1.2                   w0=1e-007                 dvt0=15.61
+ dvt1=1.25                 dvt2=0                    dvt0w=0
+ dvt1w=0                   dvt2w=0                   dsub=0.5
+ minv=0                    voffl=0                   dvtp0=1.09e-008
+ dvtp1=4                   lpe0=2.589e-008           lpeb=0
+ xj=1.7e-007               ngate=1e020               ndep=8.3687e017
+ nsd=1e020                 phin=0                    cdsc=0
+ cdscb=0                   cdscd=0                   cit=0.0001
+ voff=-0.060053571         lvoff=-4.1142857e-009     wvoff=-2.821875e-009
+ pvoff=1.05e-016+dpvoffp_hvt                         nfactor=0.93893155
+ lnfactor=7.9305357e-008   wnfactor=-1.5943229e-008  pnfactor=-9.6228125e-015
+ eta0=0.20954226           leta0=-1.4917857e-009     weta0=-1.5921354e-008
+ peta0=6.321875e-016       etab=-0.1                 u0=0.0077803214
+ lu0=-1.1336429e-010       wu0=1.0915625e-010        pu0=-2.84375e-018
+ ua=2.4642857e-010         lua=-3.3145714e-017       ub=1.4080714e-018
+ lub=1.7610714e-026        wub=-6.95625e-026         pub=7.634375e-033
+ uc=2.7771012e-011         luc=-1.7895357e-018       wuc=-3.4624479e-018
+ puc=1.3009062e-024        vsat=140066.07            lvsat=-0.0052132143
+ wvsat=-0.0092421875       pvsat=1.8484375e-009+dpvsatp_hvt
+ a0=1.2686429              la0=-1.9753571e-008       wa0=-3.45625e-008
+ pa0=1.0740625e-014        ags=1.2059226             lags=5.9635714e-007
+ wags=2.0259896e-007       pags=-2.17875e-014        a1=0
+ a2=1                      b0=0                      b1=0
+ keta=-0.17510554          lketa=1.0881107e-008      wketa=1.9589062e-009
+ pketa=-3.9178125e-016     dwg=0                     dwb=0
+ pclm=1.0142857            lpclm=-4.2857143e-008     pdiblc1=2e-018
+ pdiblc2=0.0019375         lpdiblc2=-8.75e-011       wpdiblc2=-5.46875e-011
+ ppdiblc2=1.09375e-017     pdiblcb=0                 drout=0
+ pvag=1.5                  delta=0.01                pscbe1=9.264e008
+ pscbe2=1e-020             fprout=200                pdits=0
+ pditsd=0                  pditsl=0                  rsh=9.68
+ rdsw=210+drdswp_hvt       rsw=210                   rdw=210
+ rdswmin=0                 rdwmin=0                  prwg=0
+ prwb=0                    wr=1                      alpha0=0
+ alpha1=0.06               beta0=12                  agidl=9e-008
+ bgidl=2.3e009             cgidl=0.5                 egidl=0.53
+ aigbacc=0.01066           bigbacc=0.001949          cigbacc=0.1416
+ nigbacc=4.05              aigbinv=0.35              bigbinv=0.03
+ cigbinv=0.006             eigbinv=1.1               nigbinv=1
+ aigc=0.005985             bigc=0.000764             cigc=0
+ aigsd=0.0049182917        waigsd=3.4963542e-011     bigsd=0.0001597
+ cigsd=0.001522            nigc=1                    poxedge=1
+ pigcd=1.495               ntox=ntoxp_hvt            xrcrg1=12
+ xrcrg2=1                  cgso=cgop_hvt             cgdo=cgop_hvt
+ cgbo=0                    cgdl=cglp_hvt             cgsl=cglp_hvt
+ clc=1e-007                cle=0.6                   cf=cfp_hvt
+ ckappas=0.6               acde=1.2                  moin=8
+ noff=1.568                voffcv=-0.0540472         kt1=-0.2435
+ kt1l=0                    kt2=-0.04696              ute=-1.5996667
+ lute=2.035e-008           wute=2.8583333e-008       pute=-3.36875e-015
+ ua1=7.27e-010             ub1=-3.3668393e-018       lub1=8.1467857e-026
+ wub1=1.1626563e-025       pub1=-1.6515625e-032      uc1=-6.421e-011
+ prt=0                     at=245894.05              lat=-0.0080121429
+ wat=-0.0063510417         pat=6.16875e-010          jss=1.50e-07
+ jsws=5.60e-13             jswgs=9.00e-12            njs=1
+ ijthsfwd=0.01             ijthsrev=0.01             bvs=10
+ xjbvs=1                   pbs=0.751                 cjs=cjp_hvt
+ mjs=0.351                 pbsws=0.8                 cjsws=cjswp_hvt
+ mjsws=0.01                pbswgs=1.15               cjswgs=cjswgp_hvt
+ mjswgs=0.678              tpb=1.56e-03              tcj=8.59e-04
+ tpbsw=1.56e-03            tcjsw=1.86e-04            tpbswg=3.00e-04
+ tcjswg=4.62e-04           xtis=3                    dmcg=9.25e-008
+ dmci=9.25e-008            dmdg=0                    dmcgt=0
+ dwj=0                     xgw=0                     xgl=0
+ rshg=0.1                  gbmin=1e-012              rbpb=50
+ rbpd=50                   rbps=50                   rbdb=50
+ rbsb=50                   ngcon=1                   saref=0.63e-6
+ sbref=0.63e-6             kvsat=-0.95               wlod=0.8e-6
+ tku0=0.1                  ku0=1.3349e-7             llodku0=1
+ wlodku0=1                 lku0=1.5807e-7            wku0=6e-7
+ pku0=0                    kvth0=-1.5e-9             stk2=6e-10
+ steta0=0                  lkvth0=-1.68e-15          wkvth0=0.5e-6
+ pkvth0=0                  llodvth=2                 wlodvth=1
+ lodk2=2                   lodeta0=1                 fnoimod=1
+ noia=1.30e+42             noib=9.00e+26             noic=8.75
+ em=5.00e+07               ef=1.13                   wpemod=wpeflag_hvt
+ kvth0we=-0.0028           lkvth0we=0                wkvth0we=0
+ pkvth0we=0                ku0we=-0.0045             lku0we=4.50e-10
+ wku0we=0                  pku0we=0                  k2we=0.00045
+ wk2we=0                   web=-180                  wec=-3000
+ scref=1.00e-06            ud=0                      tnoimod=0
+ minr=1e-3

     }
endsection mos_hvt

//  *****************************************************************************************
//
//             *
//                                  1.0V LOW VT DEVICE MODELS
//             *
//
//             *
//  *****************************************************************************************
//

section mos_lvt
//
//  *****************************************************************************************
//
//             *
//                                1.0V LOW VT NMOS DEVICE MODELS
//             *
//
//             *
//  *****************************************************************************************

model nch_lvt bsim4  {
     1: type=n
+ lmin=1.0000e-05-dxln_lvt  lmax=2.001e-05            wmin=1.0000e-05-dxwn_lvt
+ wmax=9.001e-04            version=4.5               binunit=2
+ paramchk=1                mobmod=0                  capmod=2
+ diomod=1                  rdsmod=0                  rbodymod=0
+ rgatemod=0                permod=1                  acnqsmod=0
+ trnqsmod=0                tnom=25                   toxe=toxn_lvt
+ toxm=toxn_lvt             dtox=3.8e-010             epsrox=3.9
+ wint=6e-009               lint=2.5e-009             ll=0
+ wl=0                      lln=1                     wln=1
+ lw=0                      ww=0                      lwn=1
+ wwn=1                     lwl=0                     wwl=0
+ llc=0                     wlc=0                     lwc=0
+ wwc=0                     lwlc=0                    wwlc=0
+ dwc=0                     xpart=1                   toxref=3e-009
+ dlcig=2.5e-009            xl=-3.5e-08+dxln_lvt      xw=1.5e-8+dxwn_lvt
+ vth0=0.224+dvthn_lvt      lvth0=0+dlvthn_lvt        wvth0=0+dwvthn_lvt
+ pvth0=0+dpvthn_lvt        k1=0.27                   k2=0.024+dk2n_lvt
+ k3=-2.7                   k3b=1.2                   w0=0
+ dvt0=20                   dvt1=1.5                  dvt2=0
+ dvt0w=0                   dvt1w=0                   dvt2w=0
+ dsub=0.5+ddsubn_lvt       minv=0                    voffl=0
+ dvtp0=2e-007              dvtp1=1                   lpe0=1.5e-008
+ lpeb=0                    xj=1.5e-007               ngate=1.5e020
+ ndep=8.3687e017           nsd=1e020                 phin=0
+ cdsc=0                    cdscb=0                   cdscd=0
+ lcdscd=0+dlcdscdn_lvt     cit=0                     voff=-0.1054
+ nfactor=0.4               pvoff=0+dpvoffn_lvt       lvoff=0+dlvoffn_lvt
+ lcit=0+dlcitn_lvt         eta0=0.29+deta0n_lvt      etab=-0.05
+ u0=0.035                  peta0=0+dpeta0n_lvt       ua=-8.099e-010
+ ub=2.009e-018             uc=1.6e-010               vsat=118000
+ a0=2.1                    ags=1.035                 lvsat=0+dlvsatn_lvt
+ pvsat=0+dpvsatn_lvt       a1=0                      a2=1
+ b0=0                      b1=0                      keta=-0.06
+ dwg=0                     dwb=0                     pclm=0.1
+ pdiblc1=0                 ppclm=0+dppclmn_lvt       pdiblc2=1e-005
+ pdiblcb=0                 drout=0                   pvag=0
+ delta=0.009               pscbe1=9.264e008          pscbe2=1e-020
+ fprout=100                pdits=0                   pditsd=0
+ pditsl=0                  rdsw=140+drdswn_lvt       prwg=0
+ prwb=0                    wr=1                      alpha0=0
+ agidl=1.685e-007          bgidl=2.069e009           cgidl=0.375
+ egidl=0.779               aigbacc=0.01256           bigbacc=0.004998
+ cigbacc=0.07068           nigbacc=3.567             aigbinv=0.35
+ bigbinv=0.03              cigbinv=0.006             eigbinv=1.1
+ nigbinv=1                 aigc=0.0102               bigc=0.001561
+ cigc=0                    aigsd=0.00852             bigsd=0.0004929
+ cigsd=0.001386            nigc=1                    poxedge=1
+ pigcd=2.3                 ntox=ntoxn_lvt            xrcrg1=12
+ xrcrg2=1                  cgso=cgon_lvt             cgdo=cgon_lvt
+ cgbo=0                    cgdl=cgln_lvt             cgsl=cgln_lvt
+ clc=1e-007                cle=0.6                   cf=cfn_lvt
+ ckappas=0.6               kt1=-0.2268               kt1l=0
+ kt2=-0.04464              ute=-1.73                 ua1=2.706e-009
+ ub1=-4.244e-018           uc1=-2.742e-010           prt=0
+ at=270000                 njs=1                     ijthsfwd=0.01
+ ijthsrev=0.01             bvs=10                    xjbvs=1
+ cjs=cjn_lvt               cjsws=cjswn_lvt           cjswgs=cjswgn_lvt
+ xtis=3                    dmcg=9.25e-008            dmci=9.25e-008
+ dmdg=0                    dmcgt=0                   dwj=0
+ xgw=0                     xgl=0                     rshg=0.1
+ gbmin=1e-012              rbpb=50                   rbpd=50
+ rbps=50                   rbdb=50                   rbsb=50
+ igbmod=1                  igcmod=1                  rsh=10.5
+ voffcv=-0.05472           noff=1.686                moin=12.6
+ acde=1.2                  dlc=1.25e-008             beta0=5.8
+ alpha1=0.01               jswgs=9e-12               jsws=3.4e-13
+ jss=1.93e-07              tpbswg=3.00e-03           tcjswg=2.26e-03
+ tpbsw=1.90e-03            tcjsw=3.7e-04             tpb=1.20e-03
+ tcj=7.60e-04              pbswgs=0.78               pbsws=0.8
+ pbs=0.5                   mjswgs=0.52               mjsws=0.01
+ mjs=0.25                  ngcon=1                   saref=0.63e-6
+ sbref=0.63e-6             kvsat=0.3                 wlod=0.8e-6
+ tku0=0.01                 ku0=-6.86e-8              llodku0=1
+ wlodku0=1                 lku0=3.227e-7             wku0=8e-7
+ pku0=-1.7e-13             kvth0=3.5e-9              stk2=1.35e-9
+ steta0=0                  lkvth0=-2.68e-11          wkvth0=1.5e-6
+ pkvth0=0                  llodvth=1                 wlodvth=1
+ lodk2=0.5                 lodeta0=1                 fnoimod=1
+ tnoimod=0                 noia=3.39e41              noib=2.01e24
+ noic=8.75                 wpemod=wpeflag_lvt        kvth0we=0.00323
+ lkvth0we=0                wkvth0we=0                pkvth0we=0
+ ku0we=-0.003              lku0we=3.00e-10           wku0we=0
+ pku0we=0                  k2we=0.0015               wk2we=0
+ web=-210                  wec=-3500                 scref=1.00e-06
+ ud=0                      em=2.92e06                ef=0.89
+ minr=1e-3

     2: type=n
+ lmin=1.2000e-06-dxln_lvt  lmax=1.0000e-05-dxln_lvt  wmin=1.0000e-05-dxwn_lvt
+ wmax=9.001e-04            version=4.5               binunit=2
+ paramchk=1                mobmod=0                  capmod=2
+ diomod=1                  rdsmod=0                  rbodymod=0
+ rgatemod=0                permod=1                  acnqsmod=0
+ trnqsmod=0                tnom=25                   toxe=toxn_lvt
+ toxm=toxn_lvt             dtox=3.8e-010             epsrox=3.9
+ wint=6e-009               lint=2.5e-009             ll=0
+ wl=0                      lln=1                     wln=1
+ lw=0                      ww=0                      lwn=1
+ wwn=1                     lwl=0                     wwl=0
+ llc=0                     wlc=0                     lwc=0
+ wwc=0                     lwlc=0                    wwlc=0
+ dwc=0                     xpart=1                   toxref=3e-009
+ dlcig=2.5e-009            xl=-3.5e-08+dxln_lvt      xw=1.5e-8+dxwn_lvt
+ vth0=0.22281364+dvthn_lvt lvth0=1.1816182e-008+dlvthn_lvt
+ wvth0=0+dwvthn_lvt        pvth0=0+dpvthn_lvt        k1=0.27
+ k2=0.023557091+dk2n_lvt   lk2=4.4113745e-009        k3=-2.7
+ k3b=1.2                   w0=0                      dvt0=20
+ dvt1=1.5                  dvt2=0                    dvt0w=0
+ dvt1w=0                   dvt2w=0                   dsub=0.5+ddsubn_lvt
+ minv=0                    voffl=0                   dvtp0=2e-007
+ dvtp1=1                   lpe0=1.5e-008             lpeb=0
+ xj=1.5e-007               ngate=1.5e020             ndep=8.3687e017
+ nsd=1e020                 phin=0                    cdsc=0
+ cdscb=0                   cdscd=0                   lcdscd=0+dlcdscdn_lvt
+ cit=0                     voff=-0.10458273          pvoff=0+dpvoffn_lvt
+ lvoff=-8.1400364e-009+dlvoffn_lvt                   lcit=0+dlcitn_lvt
+ nfactor=0.4               eta0=0.29+deta0n_lvt      etab=-0.05
+ peta0=0+dpeta0n_lvt       u0=0.034907727            lu0=9.1903636e-010
+ ua=-8.1426318e-010        lua=4.3457291e-017        ub=2.0022773e-018
+ lub=6.6958364e-026        uc=1.5472727e-010         luc=5.2516364e-017
+ vsat=118000               lvsat=0+dlvsatn_lvt       pvsat=0+dpvsatn_lvt
+ a0=2.2005773              la0=-1.0017496e-006       ags=0.98121818
+ lags=5.3566691e-007       a1=0                      a2=1
+ b0=0                      b1=0                      keta=-0.056282727
+ lketa=-3.7024036e-008     dwg=0                     dwb=0
+ pclm=0.1                  pdiblc1=0                 pdiblc2=1e-005
+ ppclm=0+dppclmn_lvt       pdiblcb=0                 drout=0
+ pvag=0                    delta=0.0088681818        ldelta=1.3129091e-009
+ pscbe1=9.264e008          pscbe2=1e-020             fprout=100
+ pdits=0                   pditsd=0                  pditsl=0
+ rdsw=140+drdswn_lvt       prwg=0                    prwb=0
+ wr=1                      alpha0=0                  agidl=1.685e-007
+ bgidl=2.069e009           cgidl=0.375               egidl=0.779
+ aigbacc=0.01256           bigbacc=0.004998          cigbacc=0.07068
+ nigbacc=3.567             aigbinv=0.35              bigbinv=0.03
+ cigbinv=0.006             eigbinv=1.1               nigbinv=1
+ aigc=0.0102               bigc=0.001561             cigc=0
+ aigsd=0.00852             bigsd=0.0004929           cigsd=0.001386
+ nigc=1                    poxedge=1                 pigcd=2.3
+ ntox=ntoxn_lvt            xrcrg1=12                 xrcrg2=1
+ cgso=cgon_lvt             cgdo=cgon_lvt             cgbo=0
+ cgdl=cgln_lvt             cgsl=cgln_lvt             clc=1e-007
+ cle=0.6                   cf=cfn_lvt                ckappas=0.6
+ kt1=-0.22542909           lkt1=-1.3654255e-008      kt1l=0
+ kt2=-0.046287727          lkt2=1.6411364e-008       ute=-1.7293409
+ lute=-6.5645455e-009      ua1=2.8173864e-009        lua1=-1.1094082e-015
+ ub1=-4.4473955e-018       lub1=2.0258187e-024       uc1=-2.8769818e-010
+ luc1=1.3444189e-016       prt=0                     at=276551.36
+ lat=-0.065251582          njs=1                     ijthsfwd=0.01
+ ijthsrev=0.01             bvs=10                    xjbvs=1
+ cjs=cjn_lvt               cjsws=cjswn_lvt           cjswgs=cjswgn_lvt
+ xtis=3                    dmcg=9.25e-008            dmci=9.25e-008
+ dmdg=0                    dmcgt=0                   dwj=0
+ xgw=0                     xgl=0                     rshg=0.1
+ gbmin=1e-012              rbpb=50                   rbpd=50
+ rbps=50                   rbdb=50                   rbsb=50
+ igbmod=1                  igcmod=1                  rsh=10.5
+ voffcv=-0.05472           noff=1.686                moin=12.6
+ acde=1.2                  dlc=1.25e-008             beta0=5.8
+ alpha1=0.01               jswgs=9e-12               jsws=3.4e-13
+ jss=1.93e-07              tpbswg=3.00e-03           tcjswg=2.26e-03
+ tpbsw=1.90e-03            tcjsw=3.7e-04             tpb=1.20e-03
+ tcj=7.60e-04              pbswgs=0.78               pbsws=0.8
+ pbs=0.5                   mjswgs=0.52               mjsws=0.01
+ mjs=0.25                  ngcon=1                   saref=0.63e-6
+ sbref=0.63e-6             kvsat=0.3                 wlod=0.8e-6
+ tku0=0.01                 ku0=-6.86e-8              llodku0=1
+ wlodku0=1                 lku0=3.227e-7             wku0=8e-7
+ pku0=-1.7e-13             kvth0=3.5e-9              stk2=1.35e-9
+ steta0=0                  lkvth0=-2.68e-11          wkvth0=1.5e-6
+ pkvth0=0                  llodvth=1                 wlodvth=1
+ lodk2=0.5                 lodeta0=1                 fnoimod=1
+ tnoimod=0                 noia=3.39e41              noib=2.01e24
+ noic=8.75                 wpemod=wpeflag_lvt        kvth0we=0.00323
+ lkvth0we=0                wkvth0we=0                pkvth0we=0
+ ku0we=-0.003              lku0we=3.00e-10           wku0we=0
+ pku0we=0                  k2we=0.0015               wk2we=0
+ web=-210                  wec=-3500                 scref=1.00e-06
+ ud=0                      em=2.92e06                ef=0.89
+ minr=1e-3

     3: type=n
+ lmin=5.0000e-07-dxln_lvt  lmax=1.2000e-06-dxln_lvt  wmin=1.0000e-05-dxwn_lvt
+ wmax=9.001e-04            version=4.5               binunit=2
+ paramchk=1                mobmod=0                  capmod=2
+ diomod=1                  rdsmod=0                  rbodymod=0
+ rgatemod=0                permod=1                  acnqsmod=0
+ trnqsmod=0                tnom=25                   toxe=toxn_lvt
+ toxm=toxn_lvt             dtox=3.8e-010             epsrox=3.9
+ wint=6e-009               lint=2.5e-009             ll=0
+ wl=0                      lln=1                     wln=1
+ lw=0                      ww=0                      lwn=1
+ wwn=1                     lwl=0                     wwl=0
+ llc=0                     wlc=0                     lwc=0
+ wwc=0                     lwlc=0                    wwlc=0
+ dwc=0                     xpart=1                   toxref=3e-009
+ dlcig=2.5e-009            xl=-3.5e-08+dxln_lvt      xw=1.5e-8+dxwn_lvt
+ vth0=0.23037143+dvthn_lvt lvth0=3.0491429e-009+dlvthn_lvt
+ wvth0=0+dwvthn_lvt        pvth0=0+dpvthn_lvt        k1=0.27
+ k2=0.032360857+dk2n_lvt   lk2=-5.8009943e-009       k3=-2.7
+ k3b=1.2                   w0=0                      dvt0=20
+ dvt1=1.5                  dvt2=0                    dvt0w=0
+ dvt1w=0                   dvt2w=0                   dsub=0.5+ddsubn_lvt
+ minv=0                    voffl=0                   dvtp0=2e-007
+ dvtp1=1                   lpe0=1.5e-008             lpeb=0
+ xj=1.5e-007               ngate=1.5e020             ndep=8.3687e017
+ nsd=1e020                 phin=0                    cdsc=0
+ cdscb=0                   cdscd=0                   lcdscd=0+dlcdscdn_lvt
+ cit=0                     voff=-0.10608             pvoff=0+dpvoffn_lvt
+ lvoff=-6.4032e-009+dlvoffn_lvt                      lcit=0+dlcitn_lvt
+ nfactor=0.4               eta0=0.29+deta0n_lvt      etab=-0.05
+ peta0=0+dpeta0n_lvt       u0=0.034911429            lu0=9.1474286e-010
+ ua=-7.0635429e-010        lua=-8.1717029e-017       ub=2.0567143e-018
+ lub=3.8114286e-027        uc=2.0742571e-010         luc=-8.6138286e-018
+ vsat=118000               lvsat=0+dlvsatn_lvt       pvsat=0+dpvsatn_lvt
+ a0=1.4158571              la0=-9.1474286e-008       ags=1.5731143
+ lags=-1.5093257e-007      a1=0                      a2=1
+ b0=0                      b1=0                      keta=-0.10771714
+ lketa=2.2639886e-008      dwg=0                     dwb=0
+ pclm=0.0014285714         lpclm=1.1434286e-007      pdiblc1=0
+ ppclm=0+dppclmn_lvt       pdiblc2=1e-005            pdiblcb=0
+ drout=0                   pvag=-0.32857143          lpvag=3.8114286e-007
+ delta=0.011642857         ldelta=-1.9057143e-009    pscbe1=9.264e008
+ pscbe2=1e-020             fprout=100                pdits=0
+ pditsd=0                  pditsl=0                  rdsw=140+drdswn_lvt
+ prwg=0                    prwb=0                    wr=1
+ alpha0=0                  agidl=1.685e-007          bgidl=2.069e009
+ cgidl=0.375               egidl=0.779               aigbacc=0.01256
+ bigbacc=0.004998          cigbacc=0.07068           nigbacc=3.567
+ aigbinv=0.35              bigbinv=0.03              cigbinv=0.006
+ eigbinv=1.1               nigbinv=1                 aigc=0.0102
+ bigc=0.001561             cigc=0                    aigsd=0.00852
+ bigsd=0.0004929           cigsd=0.001386            nigc=1
+ poxedge=1                 pigcd=2.3                 ntox=ntoxn_lvt
+ xrcrg1=12                 xrcrg2=1                  cgso=cgon_lvt
+ cgdo=cgon_lvt             cgbo=0                    cgdl=cgln_lvt
+ cgsl=cgln_lvt             clc=1e-007                cle=0.6
+ cf=cfn_lvt                ckappas=0.6               kt1=-0.2372
+ kt1l=0                    kt2=-0.029209143          lkt2=-3.3997943e-009
+ ute=-1.7382857            lute=3.8114286e-009       ua1=1.9109429e-009
+ lua1=-5.7933714e-017      ub1=-2.6175429e-018       lub1=-9.6810286e-026
+ uc1=-1.5346571e-010       luc1=-2.1267771e-017      prt=0
+ at=328400                 lat=-0.125396             njs=1
+ ijthsfwd=0.01             ijthsrev=0.01             bvs=10
+ xjbvs=1                   cjs=cjn_lvt               cjsws=cjswn_lvt
+ cjswgs=cjswgn_lvt         xtis=3                    dmcg=9.25e-008
+ dmci=9.25e-008            dmdg=0                    dmcgt=0
+ dwj=0                     xgw=0                     xgl=0
+ rshg=0.1                  gbmin=1e-012              rbpb=50
+ rbpd=50                   rbps=50                   rbdb=50
+ rbsb=50                   igbmod=1                  igcmod=1
+ rsh=10.5                  voffcv=-0.05472           noff=1.686
+ moin=12.6                 acde=1.2                  dlc=1.25e-008
+ beta0=5.8                 alpha1=0.01               jswgs=9e-12
+ jsws=3.4e-13              jss=1.93e-07              tpbswg=3.00e-03
+ tcjswg=2.26e-03           tpbsw=1.90e-03            tcjsw=3.7e-04
+ tpb=1.20e-03              tcj=7.60e-04              pbswgs=0.78
+ pbsws=0.8                 pbs=0.5                   mjswgs=0.52
+ mjsws=0.01                mjs=0.25                  ngcon=1
+ saref=0.63e-6             sbref=0.63e-6             kvsat=0.3
+ wlod=0.8e-6               tku0=0.01                 ku0=-6.86e-8
+ llodku0=1                 wlodku0=1                 lku0=3.227e-7
+ wku0=8e-7                 pku0=-1.7e-13             kvth0=3.5e-9
+ stk2=1.35e-9              steta0=0                  lkvth0=-2.68e-11
+ wkvth0=1.5e-6             pkvth0=0                  llodvth=1
+ wlodvth=1                 lodk2=0.5                 lodeta0=1
+ fnoimod=1                 tnoimod=0                 noia=3.39e41
+ noib=2.01e24              noic=8.75                 wpemod=wpeflag_lvt
+ kvth0we=0.00323           lkvth0we=0                wkvth0we=0
+ pkvth0we=0                ku0we=-0.003              lku0we=3.00e-10
+ wku0we=0                  pku0we=0                  k2we=0.0015
+ wk2we=0                   web=-210                  wec=-3500
+ scref=1.00e-06            ud=0                      em=2.92e06
+ ef=0.89                   minr=1e-3

     4: type=n
+ lmin=2.4000e-07-dxln_lvt  lmax=5.0000e-07-dxln_lvt  wmin=1.0000e-05-dxwn_lvt
+ wmax=9.001e-04            version=4.5               binunit=2
+ paramchk=1                mobmod=0                  capmod=2
+ diomod=1                  rdsmod=0                  rbodymod=0
+ rgatemod=0                permod=1                  acnqsmod=0
+ trnqsmod=0                tnom=25                   toxe=toxn_lvt
+ toxm=toxn_lvt             dtox=3.8e-010             epsrox=3.9
+ wint=6e-009               lint=2.5e-009             ll=0
+ wl=0                      lln=1                     wln=1
+ lw=0                      ww=0                      lwn=1
+ wwn=1                     lwl=0                     wwl=0
+ llc=0                     wlc=0                     lwc=0
+ wwc=0                     lwlc=0                    wwlc=0
+ dwc=0                     xpart=1                   toxref=3e-009
+ dlcig=2.5e-009            xl=-3.5e-08+dxln_lvt      xw=1.5e-8+dxwn_lvt
+ vth0=0.24315385+dvthn_lvt lvth0=-2.8307692e-009+dlvthn_lvt
+ wvth0=0+dwvthn_lvt        pvth0=0+dpvthn_lvt        k1=0.27
+ k2=0.02725+dk2n_lvt       lk2=-3.45e-009            k3=-2.7
+ k3b=1.2                   w0=0                      dvt0=20
+ dvt1=1.5                  dvt2=0                    dvt0w=0
+ dvt1w=0                   dvt2w=0                   dsub=0.5+ddsubn_lvt
+ minv=0                    voffl=0                   dvtp0=2e-007
+ dvtp1=1                   lpe0=1.5e-008             lpeb=0
+ xj=1.5e-007               ngate=1.5e020             ndep=8.3687e017
+ nsd=1e020                 phin=0                    cdsc=0
+ cdscb=0                   cdscd=0                   lcdscd=0+dlcdscdn_lvt
+ cit=0                     voff=-0.12153846          pvoff=0+dpvoffn_lvt
+ lvoff=7.0769231e-010+dlvoffn_lvt                    lcit=0+dlcitn_lvt
+ nfactor=0.24615385        lnfactor=7.0769231e-008   eta0=0.29+deta0n_lvt
+ peta0=0+dpeta0n_lvt       etab=-0.05                u0=0.035823077
+ lu0=4.9538462e-010        ua=-9.0476923e-010        lua=9.5538462e-018
+ ub=2.0588462e-018         lub=2.8307692e-027        uc=2.107e-010
+ luc=-1.012e-017           vsat=118000               a0=1.0216154
+ la0=8.9876923e-008        lvsat=0+dlvsatn_lvt       pvsat=0+dpvsatn_lvt
+ ags=2.1257692             lags=-4.0515385e-007      a1=0
+ a2=1                      b0=0                      b1=0
+ keta=-0.080423077         lketa=1.0084615e-008      dwg=0
+ dwb=0                     pclm=0.25                 pdiblc1=0
+ ppclm=0+dppclmn_lvt       pdiblc2=-0.00042230769    lpdiblc2=1.9886154e-010
+ pdiblcb=0                 drout=0                   pvag=0.5
+ delta=0.0075              pscbe1=9.264e008          pscbe2=1e-020
+ fprout=-53.846154         lfprout=7.0769231e-005    pdits=0
+ pditsd=0                  pditsl=0                  rdsw=140+drdswn_lvt
+ prwg=0                    prwb=0                    wr=1
+ alpha0=0                  agidl=1.685e-007          bgidl=2.069e009
+ cgidl=0.375               egidl=0.779               aigbacc=0.01256
+ bigbacc=0.004998          cigbacc=0.07068           nigbacc=3.567
+ aigbinv=0.35              bigbinv=0.03              cigbinv=0.006
+ eigbinv=1.1               nigbinv=1                 aigc=0.0102
+ bigc=0.001561             cigc=0                    aigsd=0.00852
+ bigsd=0.0004929           cigsd=0.001386            nigc=1
+ poxedge=1                 pigcd=2.3                 ntox=ntoxn_lvt
+ xrcrg1=12                 xrcrg2=1                  cgso=cgon_lvt
+ cgdo=cgon_lvt             cgbo=0                    cgdl=cgln_lvt
+ cgsl=cgln_lvt             clc=1e-007                cle=0.6
+ cf=cfn_lvt                ckappas=0.6               kt1=-0.22435385
+ lkt1=-5.9092308e-009      kt1l=0                    kt2=-0.030415385
+ lkt2=-2.8449231e-009      ute=-1.7692308            lute=1.8046154e-008
+ ua1=1.7180769e-009        lua1=3.0784615e-017       ub1=-2.8003077e-018
+ lub1=-1.2738462e-026      uc1=-3.0392308e-010       luc1=4.7942615e-017
+ prt=0                     at=76223.077              lat=-0.0093946154
+ njs=1                     ijthsfwd=0.01             ijthsrev=0.01
+ bvs=10                    xjbvs=1                   cjs=cjn_lvt
+ cjsws=cjswn_lvt           cjswgs=cjswgn_lvt         xtis=3
+ dmcg=9.25e-008            dmci=9.25e-008            dmdg=0
+ dmcgt=0                   dwj=0                     xgw=0
+ xgl=0                     rshg=0.1                  gbmin=1e-012
+ rbpb=50                   rbpd=50                   rbps=50
+ rbdb=50                   rbsb=50                   igbmod=1
+ igcmod=1                  rsh=10.5                  voffcv=-0.05472
+ noff=1.686                moin=12.6                 acde=1.2
+ dlc=1.25e-008             beta0=5.8                 alpha1=0.01
+ jswgs=9e-12               jsws=3.4e-13              jss=1.93e-07
+ tpbswg=3.00e-03           tcjswg=2.26e-03           tpbsw=1.90e-03
+ tcjsw=3.7e-04             tpb=1.20e-03              tcj=7.60e-04
+ pbswgs=0.78               pbsws=0.8                 pbs=0.5
+ mjswgs=0.52               mjsws=0.01                mjs=0.25
+ ngcon=1                   saref=0.63e-6             sbref=0.63e-6
+ kvsat=0.3                 wlod=0.8e-6               tku0=0.01
+ ku0=-6.86e-8              llodku0=1                 wlodku0=1
+ lku0=3.227e-7             wku0=8e-7                 pku0=-1.7e-13
+ kvth0=3.5e-9              stk2=1.35e-9              steta0=0
+ lkvth0=-2.68e-11          wkvth0=1.5e-6             pkvth0=0
+ llodvth=1                 wlodvth=1                 lodk2=0.5
+ lodeta0=1                 fnoimod=1                 tnoimod=0
+ noia=3.39e41              noib=2.01e24              noic=8.75
+ wpemod=wpeflag_lvt        kvth0we=0.00323           lkvth0we=0
+ wkvth0we=0                pkvth0we=0                ku0we=-0.003
+ lku0we=3.00e-10           wku0we=0                  pku0we=0
+ k2we=0.0015               wk2we=0                   web=-210
+ wec=-3500                 scref=1.00e-06            ud=0
+ em=2.92e06                ef=0.89                   minr=1e-3

     5: type=n
+ lmin=1.0e-07              lmax=2.4000e-07-dxln_lvt  wmin=1.0000e-05-dxwn_lvt
+ wmax=9.001e-04            version=4.5               binunit=2
+ paramchk=1                mobmod=0                  capmod=2
+ diomod=1                  rdsmod=0                  rbodymod=0
+ rgatemod=0                permod=1                  acnqsmod=0
+ trnqsmod=0                tnom=25                   toxe=toxn_lvt
+ toxm=toxn_lvt             dtox=3.8e-010             epsrox=3.9
+ wint=6e-009               lint=2.5e-009             ll=0
+ wl=0                      lln=1                     wln=1
+ lw=0                      ww=0                      lwn=1
+ wwn=1                     lwl=0                     wwl=0
+ llc=0                     wlc=0                     lwc=0
+ wwc=0                     lwlc=0                    wwlc=0
+ dwc=0                     xpart=1                   toxref=3e-009
+ dlcig=2.5e-009            xl=-3.5e-08+dxln_lvt      xw=1.5e-8+dxwn_lvt
+ vth0=0.23221429+dvthn_lvt lvth0=-6.4285714e-010+dlvthn_lvt
+ wvth0=0+dwvthn_lvt        pvth0=0+dpvthn_lvt        k1=0.27
+ k2=0.016428571+dk2n_lvt   lk2=-1.2857143e-009       k3=-2.7
+ k3b=1.2                   w0=0                      dvt0=20
+ dvt1=1.5                  dvt2=0                    dvt0w=0
+ dvt1w=0                   dvt2w=0                   dsub=0.5+ddsubn_lvt
+ minv=0                    voffl=0                   dvtp0=2e-007
+ dvtp1=1                   lpe0=1.5e-008             lpeb=0
+ xj=1.5e-007               ngate=1.5e020             ndep=8.3687e017
+ nsd=1e020                 phin=0                    cdsc=0
+ cdscb=0                   cdscd=0                   lcdscd=0+dlcdscdn_lvt
+ cit=0                     voff=-0.10792857          pvoff=0+dpvoffn_lvt
+ lvoff=-2.0142857e-009+dlvoffn_lvt                   lcit=0+dlcitn_lvt
+ nfactor=0.21428571        lnfactor=7.7142857e-008   eta0=0.29+deta0n_lvt
+ peta0=0+dpeta0n_lvt       etab=-0.05                u0=0.041857143
+ lu0=-7.1142857e-010       ua=-8.0359058e-010        lua=-1.0681884e-017
+ ub=2.0200327e-018         lub=1.0593454e-026        uc=1.9166e-010
+ luc=-6.312e-018           vsat=118000               a0=1.93
+ la0=-9.18e-008            lvsat=0+dlvsatn_lvt       pvsat=0+dpvsatn_lvt
+ ags=-0.5                  lags=1.2e-007             a1=0
+ a2=1                      b0=0                      b1=0
+ keta=-0.040218857         lketa=2.0437714e-009      dwg=0
+ dwb=0                     pclm=0.24571429           lpclm=8.5714286e-010
+ ppclm=0+dppclmn_lvt       pdiblc1=0                 pdiblc2=-0.0034685714
+ lpdiblc2=8.0811429e-010   pdiblcb=0                 drout=0
+ pvag=0.5                  delta=0.0075              pscbe1=9.264e008
+ pscbe2=1e-020             fprout=300                pdits=0
+ pditsd=0                  pditsl=0                  rdsw=140+drdswn_lvt
+ prwg=0                    prwb=0                    wr=1
+ alpha0=0                  agidl=1.685e-007          bgidl=2.069e009
+ cgidl=0.375               egidl=0.779               aigbacc=0.01256
+ bigbacc=0.004998          cigbacc=0.07068           nigbacc=3.567
+ aigbinv=0.35              bigbinv=0.03              cigbinv=0.006
+ eigbinv=1.1               nigbinv=1                 aigc=0.0102
+ bigc=0.001561             cigc=0                    aigsd=0.00852
+ bigsd=0.0004929           cigsd=0.001386            nigc=1
+ poxedge=1                 pigcd=2.3                 ntox=ntoxn_lvt
+ xrcrg1=12                 xrcrg2=1                  cgso=cgon_lvt
+ cgdo=cgon_lvt             cgbo=0                    cgdl=cgln_lvt
+ cgsl=cgln_lvt             clc=1e-007                cle=0.6
+ cf=cfn_lvt                ckappas=0.6               kt1=-0.23607143
+ lkt1=-3.5657143e-009      kt1l=0                    kt2=-0.04464
+ ute=-1.6575714            lute=-4.2857143e-009      ua1=2.0991429e-009
+ lua1=-4.5428571e-017      ub1=-3.2415714e-018       lub1=7.5514286e-026
+ uc1=-9.5233429e-011       luc1=6.2046857e-018       prt=0
+ at=14785.714              lat=0.0028928571          njs=1
+ ijthsfwd=0.01             ijthsrev=0.01             bvs=10
+ xjbvs=1                   cjs=cjn_lvt               cjsws=cjswn_lvt
+ cjswgs=cjswgn_lvt         xtis=3                    dmcg=9.25e-008
+ dmci=9.25e-008            dmdg=0                    dmcgt=0
+ dwj=0                     xgw=0                     xgl=0
+ rshg=0.1                  gbmin=1e-012              rbpb=50
+ rbpd=50                   rbps=50                   rbdb=50
+ rbsb=50                   igbmod=1                  igcmod=1
+ rsh=10.5                  voffcv=-0.05472           noff=1.686
+ moin=12.6                 acde=1.2                  dlc=1.25e-008
+ beta0=5.8                 alpha1=0.01               jswgs=9e-12
+ jsws=3.4e-13              jss=1.93e-07              tpbswg=3.00e-03
+ tcjswg=2.26e-03           tpbsw=1.90e-03            tcjsw=3.7e-04
+ tpb=1.20e-03              tcj=7.60e-04              pbswgs=0.78
+ pbsws=0.8                 pbs=0.5                   mjswgs=0.52
+ mjsws=0.01                mjs=0.25                  ngcon=1
+ saref=0.63e-6             sbref=0.63e-6             kvsat=0.3
+ wlod=0.8e-6               tku0=0.01                 ku0=-6.86e-8
+ llodku0=1                 wlodku0=1                 lku0=3.227e-7
+ wku0=8e-7                 pku0=-1.7e-13             kvth0=3.5e-9
+ stk2=1.35e-9              steta0=0                  lkvth0=-2.68e-11
+ wkvth0=1.5e-6             pkvth0=0                  llodvth=1
+ wlodvth=1                 lodk2=0.5                 lodeta0=1
+ fnoimod=1                 tnoimod=0                 noia=3.39e41
+ noib=2.01e24              noic=8.75                 wpemod=wpeflag_lvt
+ kvth0we=0.00323           lkvth0we=0                wkvth0we=0
+ pkvth0we=0                ku0we=-0.003              lku0we=3.00e-10
+ wku0we=0                  pku0we=0                  k2we=0.0015
+ wk2we=0                   web=-210                  wec=-3500
+ scref=1.00e-06            ud=0                      em=2.92e06
+ ef=0.89                   minr=1e-3

     6: type=n
+ lmin=1.0000e-05-dxln_lvt  lmax=2.001e-05            wmin=1.0000e-06-dxwn_lvt
+ wmax=1.0000e-05-dxwn_lvt  version=4.5               binunit=2
+ paramchk=1                mobmod=0                  capmod=2
+ diomod=1                  rdsmod=0                  rbodymod=0
+ rgatemod=0                permod=1                  acnqsmod=0
+ trnqsmod=0                tnom=25                   toxe=toxn_lvt
+ toxm=toxn_lvt             dtox=3.8e-010             epsrox=3.9
+ wint=6e-009               lint=2.5e-009             ll=0
+ wl=0                      lln=1                     wln=1
+ lw=0                      ww=0                      lwn=1
+ wwn=1                     lwl=0                     wwl=0
+ llc=0                     wlc=0                     lwc=0
+ wwc=0                     lwlc=0                    wwlc=0
+ dwc=0                     xpart=1                   toxref=3e-009
+ dlcig=2.5e-009            xl=-3.5e-08+dxln_lvt      xw=1.5e-8+dxwn_lvt
+ vth0=0.22422289+dvthn_lvt wvth0=-2.2295576e-009+dwvthn_lvt
+ lvth0=0+dlvthn_lvt        pvth0=0+dpvthn_lvt        k1=0.27
+ k2=0.02448144+dk2n_lvt    wk2=-4.8158443e-009       k3=-2.7
+ k3b=1.2                   w0=0                      dvt0=20
+ dvt1=1.5                  dvt2=0                    dvt0w=0
+ dvt1w=0                   dvt2w=0                   dsub=0.5+ddsubn_lvt
+ minv=0                    voffl=0                   dvtp0=2e-007
+ dvtp1=1                   lpe0=1.5e-008             lpeb=0
+ xj=1.5e-007               ngate=1.5e020             ndep=8.3687e017
+ nsd=1e020                 phin=0                    cdsc=0
+ cdscb=0                   cdscd=0                   lcdscd=0+dlcdscdn_lvt
+ cit=0                     voff=-0.1077147           wvoff=2.3153955e-008
+ pvoff=0+dpvoffn_lvt       lvoff=0+dlvoffn_lvt       lcit=0+dlcitn_lvt
+ nfactor=0.35932278        wnfactor=4.0689425e-007   eta0=0.29+deta0n_lvt
+ peta0=0+dpeta0n_lvt       etab=-0.051337333         wetab=1.3377345e-008
+ u0=0.03574222             wu0=-7.4244267e-009       ua=-8.0802773e-010
+ wua=-1.8728283e-017       ub=2.0368611e-018         wub=-2.7869469e-025
+ uc=1.6466952e-010         wuc=-4.6709231e-017       vsat=118000
+ a0=2.0811659              lvsat=0+dlvsatn_lvt       pvsat=0+dpvsatn_lvt
+ wa0=1.8839761e-007        ags=1.0432023             wags=-8.2047718e-008
+ a1=0                      a2=1                      b0=0
+ b1=0                      keta=-0.062145306         wketa=2.1459491e-008
+ dwg=0                     dwb=0                     pclm=0.077711111
+ ppclm=0+dppclmn_lvt       wpclm=2.2295576e-007      pdiblc1=0
+ pdiblc2=1e-005            pdiblcb=0                 drout=0
+ pvag=-0.055722222         wpvag=5.5738939e-007      delta=0.0088885556
+ wdelta=1.1147788e-009     pscbe1=9.264e008          pscbe2=1e-020
+ fprout=94.427778          wfprout=5.5738939e-005    pdits=0
+ pditsd=0                  pditsl=0                  rdsw=140+drdswn_lvt
+ prwg=0                    prwb=0                    wr=1
+ alpha0=0                  agidl=1.685e-007          bgidl=2.069e009
+ cgidl=0.375               egidl=0.779               aigbacc=0.01256
+ bigbacc=0.004998          cigbacc=0.07068           nigbacc=3.567
+ aigbinv=0.35              bigbinv=0.03              cigbinv=0.006
+ eigbinv=1.1               nigbinv=1                 aigc=0.0102
+ bigc=0.001561             cigc=0                    aigsd=0.00852
+ bigsd=0.0004929           cigsd=0.001386            nigc=1
+ poxedge=1                 pigcd=2.3                 ntox=ntoxn_lvt
+ xrcrg1=12                 xrcrg2=1                  cgso=cgon_lvt
+ cgdo=cgon_lvt             cgbo=0                    cgdl=cgln_lvt
+ cgsl=cgln_lvt             clc=1e-007                cle=0.6
+ cf=cfn_lvt                ckappas=0.6               kt1=-0.22564098
+ wkt1=-1.1593699e-008      kt1l=0                    kt2=-0.04464
+ ute=-1.7423703            wute=1.2374044e-007       ua1=2.7562614e-009
+ wua1=-5.0276523e-016      ub1=-4.3188907e-018       wub1=7.4913134e-025
+ uc1=-2.8042974e-010       wuc1=6.2316134e-017       prt=0
+ at=270000                 njs=1                     ijthsfwd=0.01
+ ijthsrev=0.01             bvs=10                    xjbvs=1
+ cjs=cjn_lvt               cjsws=cjswn_lvt           cjswgs=cjswgn_lvt
+ xtis=3                    dmcg=9.25e-008            dmci=9.25e-008
+ dmdg=0                    dmcgt=0                   dwj=0
+ xgw=0                     xgl=0                     rshg=0.1
+ gbmin=1e-012              rbpb=50                   rbpd=50
+ rbps=50                   rbdb=50                   rbsb=50
+ igbmod=1                  igcmod=1                  rsh=10.5
+ voffcv=-0.05472           noff=1.686                moin=12.6
+ acde=1.2                  dlc=1.25e-008             beta0=5.8
+ alpha1=0.01               jswgs=9e-12               jsws=3.4e-13
+ jss=1.93e-07              tpbswg=3.00e-03           tcjswg=2.26e-03
+ tpbsw=1.90e-03            tcjsw=3.7e-04             tpb=1.20e-03
+ tcj=7.60e-04              pbswgs=0.78               pbsws=0.8
+ pbs=0.5                   mjswgs=0.52               mjsws=0.01
+ mjs=0.25                  ngcon=1                   saref=0.63e-6
+ sbref=0.63e-6             kvsat=0.3                 wlod=0.8e-6
+ tku0=0.01                 ku0=-6.86e-8              llodku0=1
+ wlodku0=1                 lku0=3.227e-7             wku0=8e-7
+ pku0=-1.7e-13             kvth0=3.5e-9              stk2=1.35e-9
+ steta0=0                  lkvth0=-2.68e-11          wkvth0=1.5e-6
+ pkvth0=0                  llodvth=1                 wlodvth=1
+ lodk2=0.5                 lodeta0=1                 fnoimod=1
+ tnoimod=0                 noia=3.39e41              noib=2.01e24
+ noic=8.75                 wpemod=wpeflag_lvt        kvth0we=0.00323
+ lkvth0we=0                wkvth0we=0                pkvth0we=0
+ ku0we=-0.003              lku0we=3.00e-10           wku0we=0
+ pku0we=0                  k2we=0.0015               wk2we=0
+ web=-210                  wec=-3500                 scref=1.00e-06
+ ud=0                      em=2.92e06                ef=0.89
+ minr=1e-3

     7: type=n
+ lmin=1.2000e-06-dxln_lvt  lmax=1.0000e-05-dxln_lvt  wmin=1.0000e-06-dxwn_lvt
+ wmax=1.0000e-05-dxwn_lvt  version=4.5               binunit=2
+ paramchk=1                mobmod=0                  capmod=2
+ diomod=1                  rdsmod=0                  rbodymod=0
+ rgatemod=0                permod=1                  acnqsmod=0
+ trnqsmod=0                tnom=25                   toxe=toxn_lvt
+ toxm=toxn_lvt             dtox=3.8e-010             epsrox=3.9
+ wint=6e-009               lint=2.5e-009             ll=0
+ wl=0                      lln=1                     wln=1
+ lw=0                      ww=0                      lwn=1
+ wwn=1                     lwl=0                     wwl=0
+ llc=0                     wlc=0                     lwc=0
+ wwc=0                     lwlc=0                    wwlc=0
+ dwc=0                     xpart=1                   toxref=3e-009
+ dlcig=2.5e-009            xl=-3.5e-08+dxln_lvt      xw=1.5e-8+dxwn_lvt
+ vth0=0.22299245+dvthn_lvt lvth0=1.2255131e-008+dlvthn_lvt
+ wvth0=-1.7887132e-009+dwvthn_lvt                    pvth0=-4.3908096e-015+dpvthn_lvt
+ k1=0.27                   k2=0.023989171+dk2n_lvt   lk2=4.9029977e-009
+ wk2=-4.3220987e-009       pk2=-4.9177067e-015       k3=-2.7
+ k3b=1.2                   w0=0                      dvt0=20
+ dvt1=1.5                  dvt2=0                    dvt0w=0
+ dvt1w=0                   dvt2w=0                   dsub=0.5+ddsubn_lvt
+ minv=0                    voffl=0                   dvtp0=2e-007
+ dvtp1=1                   lpe0=1.5e-008             lpeb=0
+ xj=1.5e-007               ngate=1.5e020             ndep=8.3687e017
+ nsd=1e020                 phin=0                    cdsc=0
+ cdscb=0                   cdscd=0                   lcdscd=0+dlcdscdn_lvt
+ cit=0                     voff=-0.10712322          lvoff=-5.8911529e-009+dlvoffn_lvt
+ lcit=0+dlcitn_lvt         wvoff=2.5412548e-008      pvoff=-2.2495581e-014+dpvoffn_lvt
+ nfactor=0.35932278        wnfactor=4.0689425e-007   eta0=0.29+deta0n_lvt
+ etab=-0.051337333         peta0=0+dpeta0n_lvt       wetab=1.3377345e-008
+ u0=0.035643924            lu0=9.790261e-010         wu0=-7.3641779e-009
+ pu0=-6.0007731e-016       ua=-8.1525407e-010        lua=7.1974362e-017
+ wua=9.9119035e-018        pua=-2.8525626e-022       ub=2.0323419e-018
+ lub=4.50109e-026          wub=-3.0073691e-025       pub=2.1954048e-031
+ uc=1.5893845e-010         luc=5.7081436e-017        wuc=-4.212445e-017
+ puc=-4.566442e-023        vsat=118000               lvsat=0+dlvsatn_lvt
+ pvsat=0+dpvsatn_lvt       a0=2.1952877              la0=-1.1366534e-006
+ wa0=5.2911455e-008        pa0=1.3494421e-012        ags=0.98737265
+ lags=5.5606342e-007       wags=-6.1563151e-008      pags=-2.0402628e-013
+ a1=0                      a2=1                      b0=0
+ b1=0                      keta=-0.058603877         lketa=-3.5272629e-008
+ wketa=2.321846e-008       pketa=-1.751933e-014      dwg=0
+ dwb=0                     pclm=0.077711111          wpclm=2.2295576e-007
+ pdiblc1=0                 ppclm=0+dppclmn_lvt       pdiblc2=1e-005
+ pdiblcb=0                 drout=0                   pvag=-0.055722222
+ wpvag=5.5738939e-007      delta=0.008815499         ldelta=7.2764339e-010
+ wdelta=5.2698633e-010     pdelta=5.8544128e-015     pscbe1=9.264e008
+ pscbe2=1e-020             fprout=95.162298          lfprout=-7.3158212e-006
+ wfprout=4.8391533e-005    pfprout=7.318016e-011     pdits=0
+ pditsd=0                  pditsl=0                  rdsw=140+drdswn_lvt
+ prwg=0                    prwb=0                    wr=1
+ alpha0=0                  agidl=1.685e-007          bgidl=2.069e009
+ cgidl=0.375               egidl=0.779               aigbacc=0.01256
+ bigbacc=0.004998          cigbacc=0.07068           nigbacc=3.567
+ aigbinv=0.35              bigbinv=0.03              cigbinv=0.006
+ eigbinv=1.1               nigbinv=1                 aigc=0.0102
+ bigc=0.001561             cigc=0                    aigsd=0.00852
+ bigsd=0.0004929           cigsd=0.001386            nigc=1
+ poxedge=1                 pigcd=2.3                 ntox=ntoxn_lvt
+ xrcrg1=12                 xrcrg2=1                  cgso=cgon_lvt
+ cgdo=cgon_lvt             cgbo=0                    cgdl=cgln_lvt
+ cgsl=cgln_lvt             clc=1e-007                cle=0.6
+ cf=cfn_lvt                ckappas=0.6               kt1=-0.22442285
+ lkt1=-1.2132564e-008      wkt1=-1.0065439e-008      pkt1=-1.5221473e-014
+ kt1l=0                    kt2=-0.046615617          lkt2=1.9677146e-008
+ wkt2=3.2798819e-009       pkt2=-3.2667623e-014      ute=-1.7424164
+ lute=4.5864291e-010       wute=1.3079395e-007       pute=-7.0252953e-014
+ ua1=2.8699101e-009        lua1=-1.1319409e-015      wua1=-5.2539524e-016
+ pua1=2.2539489e-022       ub1=-4.5257971e-018       lub1=2.0607884e-024
+ wub1=7.8425194e-025       pub1=-3.4980116e-031      uc1=-2.9316858e-010
+ luc1=1.2687879e-016       wuc1=5.4720386e-017       puc1=7.5653649e-023
+ prt=0                     at=276693.86              lat=-0.066670851
+ wat=-0.0014253967         pat=1.4196951e-008        njs=1
+ ijthsfwd=0.01             ijthsrev=0.01             bvs=10
+ xjbvs=1                   cjs=cjn_lvt               cjsws=cjswn_lvt
+ cjswgs=cjswgn_lvt         xtis=3                    dmcg=9.25e-008
+ dmci=9.25e-008            dmdg=0                    dmcgt=0
+ dwj=0                     xgw=0                     xgl=0
+ rshg=0.1                  gbmin=1e-012              rbpb=50
+ rbpd=50                   rbps=50                   rbdb=50
+ rbsb=50                   igbmod=1                  igcmod=1
+ rsh=10.5                  voffcv=-0.05472           noff=1.686
+ moin=12.6                 acde=1.2                  dlc=1.25e-008
+ beta0=5.8                 alpha1=0.01               jswgs=9e-12
+ jsws=3.4e-13              jss=1.93e-07              tpbswg=3.00e-03
+ tcjswg=2.26e-03           tpbsw=1.90e-03            tcjsw=3.7e-04
+ tpb=1.20e-03              tcj=7.60e-04              pbswgs=0.78
+ pbsws=0.8                 pbs=0.5                   mjswgs=0.52
+ mjsws=0.01                mjs=0.25                  ngcon=1
+ saref=0.63e-6             sbref=0.63e-6             kvsat=0.3
+ wlod=0.8e-6               tku0=0.01                 ku0=-6.86e-8
+ llodku0=1                 wlodku0=1                 lku0=3.227e-7
+ wku0=8e-7                 pku0=-1.7e-13             kvth0=3.5e-9
+ stk2=1.35e-9              steta0=0                  lkvth0=-2.68e-11
+ wkvth0=1.5e-6             pkvth0=0                  llodvth=1
+ wlodvth=1                 lodk2=0.5                 lodeta0=1
+ fnoimod=1                 tnoimod=0                 noia=3.39e41
+ noib=2.01e24              noic=8.75                 wpemod=wpeflag_lvt
+ kvth0we=0.00323           lkvth0we=0                wkvth0we=0
+ pkvth0we=0                ku0we=-0.003              lku0we=3.00e-10
+ wku0we=0                  pku0we=0                  k2we=0.0015
+ wk2we=0                   web=-210                  wec=-3500
+ scref=1.00e-06            ud=0                      em=2.92e06
+ ef=0.89                   minr=1e-3

     8: type=n
+ lmin=5.0000e-07-dxln_lvt  lmax=1.2000e-06-dxln_lvt  wmin=1.0000e-06-dxwn_lvt
+ wmax=1.0000e-05-dxwn_lvt  version=4.5               binunit=2
+ paramchk=1                mobmod=0                  capmod=2
+ diomod=1                  rdsmod=0                  rbodymod=0
+ rgatemod=0                permod=1                  acnqsmod=0
+ trnqsmod=0                tnom=25                   toxe=toxn_lvt
+ toxm=toxn_lvt             dtox=3.8e-010             epsrox=3.9
+ wint=6e-009               lint=2.5e-009             ll=0
+ wl=0                      lln=1                     wln=1
+ lw=0                      ww=0                      lwn=1
+ wwn=1                     lwl=0                     wwl=0
+ llc=0                     wlc=0                     lwc=0
+ wwc=0                     lwlc=0                    wwlc=0
+ dwc=0                     xpart=1                   toxref=3e-009
+ dlcig=2.5e-009            xl=-3.5e-08+dxln_lvt      xw=1.5e-8+dxwn_lvt
+ vth0=0.23107512+dvthn_lvt lvth0=2.8792378e-009+dlvthn_lvt
+ wvth0=-7.0390317e-009+dwvthn_lvt                    pvth0=1.6995599e-015+dpvthn_lvt
+ k1=0.27                   k2=0.033495043+dk2n_lvt   lk2=-6.1238138e-009
+ wk2=-1.1345263e-008       pk2=3.2291638e-015        k3=-2.7
+ k3b=1.2                   w0=0                      dvt0=20
+ dvt1=1.5                  dvt2=0                    dvt0w=0
+ dvt1w=0                   dvt2w=0                   dsub=0.5+ddsubn_lvt
+ minv=0                    voffl=0                   dvtp0=2e-007
+ dvtp1=1                   lpe0=1.5e-008             lpeb=0
+ xj=1.5e-007               ngate=1.5e020             ndep=8.3687e017
+ nsd=1e020                 phin=0                    cdsc=0
+ cdscb=0                   cdscd=0                   lcdscd=0+dlcdscdn_lvt
+ cit=0                     voff=-0.10663054          lvoff=-6.4626668e-009+dlvoffn_lvt
+ lcit=0+dlcitn_lvt         wvoff=5.5070072e-009      pvoff=5.9484596e-016+dpvoffn_lvt
+ nfactor=0.35932278        wnfactor=4.0689425e-007   eta0=0.29+deta0n_lvt
+ etab=-0.051337333         peta0=0+dpeta0n_lvt       wetab=1.3377345e-008
+ u0=0.03568982             lu0=9.2578668e-010        wu0=-7.786252e-009
+ pu0=-1.1047139e-016       ua=-6.7826865e-010        lua=-8.6928729e-017
+ wua=-2.809406e-016        pua=5.2132639e-023        ub=2.0595875e-018
+ lub=1.3406041e-026        wub=-2.8740886e-026       pub=-9.5974911e-032
+ uc=2.1412152e-010         luc=-6.9309194e-018       wuc=-6.6978139e-017
+ puc=-1.6834141e-023       vsat=118000               lvsat=0+dlvsatn_lvt
+ pvsat=0+dpvsatn_lvt       a0=1.2405168              la0=-2.9119145e-008
+ wa0=1.7539292e-006        pa0=-6.2373847e-013       ags=1.5984631
+ lags=-1.5280153e-007      wags=-2.535644e-007       pags=1.8695159e-014
+ a1=0                      a2=1                      b0=0
+ b1=0                      keta=-0.10885802          lketa=2.3022172e-008
+ wketa=1.141215e-008       pketa=-3.8240097e-015     dwg=0
+ dwb=0                     pclm=-0.031845556         lpclm=1.2708573e-007
+ wpclm=3.3284109e-007      ppclm=-1.2746699e-013+dppclmn_lvt
+ pdiblc1=0                 pdiblc2=1e-005            pdiblcb=0
+ drout=0                   pvag=-0.42091111          lpvag=4.2361911e-007
+ wpvag=9.2367384e-007      ppvag=-4.2488997e-013     delta=0.011268722
+ ldelta=-2.1180956e-009    wdelta=3.7424716e-009     pdelta=2.1244498e-015
+ pscbe1=9.264e008          pscbe2=1e-020             fprout=81.532063
+ lfprout=8.4952508e-006    wfprout=0.00018473477     pfprout=-8.4977994e-011
+ pdits=0                   pditsd=0                  pditsl=0
+ rdsw=140+drdswn_lvt       prwg=0                    prwb=0
+ wr=1                      alpha0=0                  agidl=1.685e-007
+ bgidl=2.069e009           cgidl=0.375               egidl=0.779
+ aigbacc=0.01256           bigbacc=0.004998          cigbacc=0.07068
+ nigbacc=3.567             aigbinv=0.35              bigbinv=0.03
+ cigbinv=0.006             eigbinv=1.1               nigbinv=1
+ aigc=0.0102               bigc=0.001561             cigc=0
+ aigsd=0.00852             bigsd=0.0004929           cigsd=0.001386
+ nigc=1                    poxedge=1                 pigcd=2.3
+ ntox=ntoxn_lvt            xrcrg1=12                 xrcrg2=1
+ cgso=cgon_lvt             cgdo=cgon_lvt             cgbo=0
+ cgdl=cgln_lvt             cgsl=cgln_lvt             clc=1e-007
+ cle=0.6                   cf=cfn_lvt                ckappas=0.6
+ kt1=-0.23458169           lkt1=-3.4830528e-010      wkt1=-2.6190931e-008
+ pkt1=3.4840977e-015       kt1l=0                    kt2=-0.026721703
+ lkt2=-3.3997943e-009      wkt2=-2.4881862e-008      ute=-1.7469179
+ lute=5.6803837e-009       wute=8.6347579e-008       pute=-1.8695159e-014
+ ua1=1.9333496e-009        lua1=-4.5530648e-017      wua1=-2.2413424e-016
+ pua1=-1.2406787e-022      ub1=-2.6473431e-018       lub1=-1.1821832e-025
+ wub1=2.9809185e-025       pub1=2.1414454e-031       uc1=-1.5915379e-010
+ luc1=-2.8578359e-017      wuc1=5.6897831e-017       puc1=7.3127812e-023
+ prt=0                     at=331097.91              lat=-0.12977955
+ wat=-0.026987202          pat=4.3848645e-008        njs=1
+ ijthsfwd=0.01             ijthsrev=0.01             bvs=10
+ xjbvs=1                   cjs=cjn_lvt               cjsws=cjswn_lvt
+ cjswgs=cjswgn_lvt         xtis=3                    dmcg=9.25e-008
+ dmci=9.25e-008            dmdg=0                    dmcgt=0
+ dwj=0                     xgw=0                     xgl=0
+ rshg=0.1                  gbmin=1e-012              rbpb=50
+ rbpd=50                   rbps=50                   rbdb=50
+ rbsb=50                   igbmod=1                  igcmod=1
+ rsh=10.5                  voffcv=-0.05472           noff=1.686
+ moin=12.6                 acde=1.2                  dlc=1.25e-008
+ beta0=5.8                 alpha1=0.01               jswgs=9e-12
+ jsws=3.4e-13              jss=1.93e-07              tpbswg=3.00e-03
+ tcjswg=2.26e-03           tpbsw=1.90e-03            tcjsw=3.7e-04
+ tpb=1.20e-03              tcj=7.60e-04              pbswgs=0.78
+ pbsws=0.8                 pbs=0.5                   mjswgs=0.52
+ mjsws=0.01                mjs=0.25                  ngcon=1
+ saref=0.63e-6             sbref=0.63e-6             kvsat=0.3
+ wlod=0.8e-6               tku0=0.01                 ku0=-6.86e-8
+ llodku0=1                 wlodku0=1                 lku0=3.227e-7
+ wku0=8e-7                 pku0=-1.7e-13             kvth0=3.5e-9
+ stk2=1.35e-9              steta0=0                  lkvth0=-2.68e-11
+ wkvth0=1.5e-6             pkvth0=0                  llodvth=1
+ wlodvth=1                 lodk2=0.5                 lodeta0=1
+ fnoimod=1                 tnoimod=0                 noia=3.39e41
+ noib=2.01e24              noic=8.75                 wpemod=wpeflag_lvt
+ kvth0we=0.00323           lkvth0we=0                wkvth0we=0
+ pkvth0we=0                ku0we=-0.003              lku0we=3.00e-10
+ wku0we=0                  pku0we=0                  k2we=0.0015
+ wk2we=0                   web=-210                  wec=-3500
+ scref=1.00e-06            ud=0                      em=2.92e06
+ ef=0.89                   minr=1e-3

     9: type=n
+ lmin=2.4000e-07-dxln_lvt  lmax=5.0000e-07-dxln_lvt  wmin=1.0000e-06-dxwn_lvt
+ wmax=1.0000e-05-dxwn_lvt  version=4.5               binunit=2
+ paramchk=1                mobmod=0                  capmod=2
+ diomod=1                  rdsmod=0                  rbodymod=0
+ rgatemod=0                permod=1                  acnqsmod=0
+ trnqsmod=0                tnom=25                   toxe=toxn_lvt
+ toxm=toxn_lvt             dtox=3.8e-010             epsrox=3.9
+ wint=6e-009               lint=2.5e-009             ll=0
+ wl=0                      lln=1                     wln=1
+ lw=0                      ww=0                      lwn=1
+ wwn=1                     lwl=0                     wwl=0
+ llc=0                     wlc=0                     lwc=0
+ wwc=0                     lwlc=0                    wwlc=0
+ dwc=0                     xpart=1                   toxref=3e-009
+ dlcig=2.5e-009            xl=-3.5e-08+dxln_lvt      xw=1.5e-8+dxwn_lvt
+ vth0=0.24391681+dvthn_lvt lvth0=-3.0279402e-009+dlvthn_lvt
+ wvth0=-7.631947e-009+dwvthn_lvt                     pvth0=1.9723009e-015+dpvthn_lvt
+ k1=0.27                   k2=0.027157758+dk2n_lvt   lk2=-3.2086628e-009
+ wk2=9.2269382e-010        pk2=-2.4140963e-015       k3=-2.7
+ k3b=1.2                   w0=0                      dvt0=20
+ dvt1=1.5                  dvt2=0                    dvt0w=0
+ dvt1w=0                   dvt2w=0                   dsub=0.5+ddsubn_lvt
+ minv=0                    voffl=0                   dvtp0=2e-007
+ dvtp1=1                   lpe0=1.5e-008             lpeb=0
+ xj=1.5e-007               ngate=1.5e020             ndep=8.3687e017
+ nsd=1e020                 phin=0                    cdsc=0
+ cdscb=0                   cdscd=0                   lcdscd=0+dlcdscdn_lvt
+ cit=0                     voff=-0.12314412          lvoff=1.1335815e-009+dlvoffn_lvt
+ lcit=0+dlcitn_lvt         wvoff=1.606139e-008       pvoff=-4.26017e-015+dpvoffn_lvt
+ nfactor=0.18833132        lnfactor=7.8656068e-008   wnfactor=5.7839868e-007
+ pnfactor=-7.8892037e-014  eta0=0.29+deta0n_lvt      etab=-0.051337333
+ wetab=1.3377345e-008      peta0=0+dpeta0n_lvt       u0=0.036746351
+ lu0=4.3978241e-010        wu0=-9.2355134e-009       pu0=5.5618886e-016
+ ua=-8.7819691e-010        lua=5.0382704e-018        wua=-2.6580291e-016
+ pua=4.5169304e-023        ub=2.0603816e-018         lub=1.3040762e-026
+ wub=-1.5359053e-026       pub=-1.0213055e-031       uc=2.2132863e-010
+ luc=-1.0246189e-017       wuc=-1.0631817e-016       puc=1.2622726e-024
+ vsat=118000               a0=1.0241786              lvsat=0+dlvsatn_lvt
+ pvsat=0+dpvsatn_lvt       la0=7.0396434e-008        wa0=-2.5639912e-008
+ pa0=1.9486333e-013        ags=2.1634289             lags=-4.1268578e-007
+ wags=-3.7670947e-007      pags=7.5341895e-014       a1=0
+ a2=1                      b0=0                      b1=0
+ keta=-0.078363626         lketa=8.994753e-009       wketa=-2.0600683e-008
+ pketa=1.0901893e-014      dwg=0                     dwb=0
+ pclm=0.2487141            lpclm=-1.9717094e-009     wpclm=1.2862832e-008
+ ppclm=1.9723009e-014+dppclmn_lvt                    pdiblc1=0
+ pdiblc2=-0.0004627706     lpdiblc2=2.1747448e-010   wpdiblc2=4.0475045e-010
+ ppdiblc2=-1.8618521e-016  pdiblcb=0                 drout=0
+ pvag=0.5                  delta=0.0066641667        wdelta=8.3608408e-009
+ pscbe1=9.264e008          pscbe2=1e-020             fprout=-62.418803
+ lfprout=7.471265e-005     wfprout=8.5752214e-005    pfprout=-3.9446018e-011
+ pdits=0                   pditsd=0                  pditsl=0
+ rdsw=140+drdswn_lvt       prwg=0                    prwb=0
+ wr=1                      alpha0=0                  agidl=1.685e-007
+ bgidl=2.069e009           cgidl=0.375               egidl=0.779
+ aigbacc=0.01256           bigbacc=0.004998          cigbacc=0.07068
+ nigbacc=3.567             aigbinv=0.35              bigbinv=0.03
+ cigbinv=0.006             eigbinv=1.1               nigbinv=1
+ aigc=0.0102               bigc=0.001561             cigc=0
+ aigsd=0.00852             bigsd=0.0004929           cigsd=0.001386
+ nigc=1                    poxedge=1                 pigcd=2.3
+ ntox=ntoxn_lvt            xrcrg1=12                 xrcrg2=1
+ cgso=cgon_lvt             cgdo=cgon_lvt             cgbo=0
+ cgdl=cgln_lvt             cgsl=cgln_lvt             clc=1e-007
+ cle=0.6                   cf=cfn_lvt                ckappas=0.6
+ kt1=-0.22230413           lkt1=-5.995986e-009       wkt1=-2.0503354e-008
+ pkt1=8.678124e-016        kt1l=0                    kt2=-0.027851648
+ lkt2=-2.8800195e-009      wkt2=-2.5645057e-008      pkt2=3.5106956e-016
+ ute=-1.7974605            lute=2.892999e-008        wute=2.8238204e-007
+ pute=-1.0887101e-013      ua1=1.6760967e-009        lua1=7.2805686e-017
+ wua1=4.1992859e-016       pua1=-4.2033677e-022      ub1=-2.7760042e-018
+ lub1=-5.9034198e-026      wub1=-2.4310753e-025      pub1=4.6309625e-031
+ uc1=-3.3755217e-010       luc1=5.3484893e-017       wuc1=3.3639179e-016
+ puc1=-5.5439406e-023      prt=0                     at=64560.844
+ lat=-0.0071724989         wat=0.11665731            pat=-2.2227831e-008
+ njs=1                     ijthsfwd=0.01             ijthsrev=0.01
+ bvs=10                    xjbvs=1                   cjs=cjn_lvt
+ cjsws=cjswn_lvt           cjswgs=cjswgn_lvt         xtis=3
+ dmcg=9.25e-008            dmci=9.25e-008            dmdg=0
+ dmcgt=0                   dwj=0                     xgw=0
+ xgl=0                     rshg=0.1                  gbmin=1e-012
+ rbpb=50                   rbpd=50                   rbps=50
+ rbdb=50                   rbsb=50                   igbmod=1
+ igcmod=1                  rsh=10.5                  voffcv=-0.05472
+ noff=1.686                moin=12.6                 acde=1.2
+ dlc=1.25e-008             beta0=5.8                 alpha1=0.01
+ jswgs=9e-12               jsws=3.4e-13              jss=1.93e-07
+ tpbswg=3.00e-03           tcjswg=2.26e-03           tpbsw=1.90e-03
+ tcjsw=3.7e-04             tpb=1.20e-03              tcj=7.60e-04
+ pbswgs=0.78               pbsws=0.8                 pbs=0.5
+ mjswgs=0.52               mjsws=0.01                mjs=0.25
+ ngcon=1                   saref=0.63e-6             sbref=0.63e-6
+ kvsat=0.3                 wlod=0.8e-6               tku0=0.01
+ ku0=-6.86e-8              llodku0=1                 wlodku0=1
+ lku0=3.227e-7             wku0=8e-7                 pku0=-1.7e-13
+ kvth0=3.5e-9              stk2=1.35e-9              steta0=0
+ lkvth0=-2.68e-11          wkvth0=1.5e-6             pkvth0=0
+ llodvth=1                 wlodvth=1                 lodk2=0.5
+ lodeta0=1                 fnoimod=1                 tnoimod=0
+ noia=3.39e41              noib=2.01e24              noic=8.75
+ wpemod=wpeflag_lvt        kvth0we=0.00323           lkvth0we=0
+ wkvth0we=0                pkvth0we=0                ku0we=-0.003
+ lku0we=3.00e-10           wku0we=0                  pku0we=0
+ k2we=0.0015               wk2we=0                   web=-210
+ wec=-3500                 scref=1.00e-06            ud=0
+ em=2.92e06                ef=0.89                   minr=1e-3

     10: type=n
+ lmin=1.0e-07              lmax=2.4000e-07-dxln_lvt  wmin=1.0000e-06-dxwn_lvt
+ wmax=1.0000e-05-dxwn_lvt  version=4.5               binunit=2
+ paramchk=1                mobmod=0                  capmod=2
+ diomod=1                  rdsmod=0                  rbodymod=0
+ rgatemod=0                permod=1                  acnqsmod=0
+ trnqsmod=0                tnom=25                   toxe=toxn_lvt
+ toxm=toxn_lvt             dtox=3.8e-010             epsrox=3.9
+ wint=6e-009               lint=2.5e-009             ll=0
+ wl=0                      lln=1                     wln=1
+ lw=0                      ww=0                      lwn=1
+ wwn=1                     lwl=0                     wwl=0
+ llc=0                     wlc=0                     lwc=0
+ wwc=0                     lwlc=0                    wwlc=0
+ dwc=0                     xpart=1                   toxref=3e-009
+ dlcig=2.5e-009            xl=-3.5e-08+dxln_lvt      xw=1.5e-8+dxwn_lvt
+ vth0=0.23222543+dvthn_lvt lvth0=-6.8966381e-010+dlvthn_lvt
+ wvth0=-1.1147788e-010+dwvthn_lvt                    pvth0=4.6820709e-016+dpvthn_lvt
+ k1=0.27                   k2=0.018444379+dk2n_lvt   lk2=-1.4659868e-009
+ wk2=-2.0164119e-008       pk2=1.8032662e-015        k3=-2.7
+ k3b=1.2                   w0=0                      dvt0=20
+ dvt1=1.5                  dvt2=0                    dvt0w=0
+ dvt1w=0                   dvt2w=0                   dsub=0.5+ddsubn_lvt
+ minv=0                    voffl=0                   dvtp0=2e-007
+ dvtp1=1                   lpe0=1.5e-008             lpeb=0
+ xj=1.5e-007               ngate=1.5e020             ndep=8.3687e017
+ nsd=1e020                 phin=0                    cdsc=0
+ cdscb=0                   cdscd=0                   lcdscd=0+dlcdscdn_lvt
+ cit=0                     voff=-0.10739523          lvoff=-2.0161962e-009+dlvoffn_lvt
+ lcit=0+dlcitn_lvt         wvoff=-5.3350127e-009     pvoff=1.9110493e-017+dpvoffn_lvt
+ nfactor=0.18801667        lnfactor=7.8719e-008      wnfactor=2.6276928e-007
+ pnfactor=-1.5766157e-014  eta0=0.29+deta0n_lvt      etab=-0.051337333
+ wetab=1.3377345e-008      peta0=0+dpeta0n_lvt       u0=0.042201029
+ lu0=-6.5115305e-010       wu0=-3.4398888e-009       pu0=-6.0293606e-016
+ ua=-8.3500052e-010        lua=-3.601007e-018        wua=3.1419367e-016
+ pua=-7.0830013e-023       ub=2.0857014e-018         lub=7.9768088e-027
+ wub=-6.5688335e-025       pub=2.6174305e-032        uc=2.0392303e-010
+ luc=-6.7650694e-018       wuc=-1.2266707e-016       puc=4.5320535e-024
+ vsat=118000               a0=1.8470535              lvsat=0+dlvsatn_lvt
+ pvsat=0+dpvsatn_lvt       la0=-9.4178543e-008       wa0=8.2971392e-007
+ pa0=2.3792564e-014        ags=-0.5477619            lags=1.2955238e-007
+ wags=4.7776233e-007       pags=-9.5552467e-014      a1=0
+ a2=1                      b0=0                      b1=0
+ keta=-0.044696902         lketa=2.2614081e-009      wketa=4.4793882e-008
+ pketa=-2.1770196e-015     dwg=0                     dwb=0
+ pclm=0.22931603           lpclm=1.9079048e-009      wpclm=1.6403173e-007
+ ppclm=-1.0510771e-014+dppclmn_lvt                   pdiblc1=0
+ pdiblc2=-0.0036799975     lpdiblc2=8.6091985e-010   wpdiblc2=2.1148946e-009
+ ppdiblc2=-5.2821404e-016  pdiblcb=0                 drout=0
+ pvag=0.5                  delta=0.0066641667        wdelta=8.3608408e-009
+ pscbe1=9.264e008          pscbe2=1e-020             fprout=311.14444
+ wfprout=-0.00011147788    pdits=0                   pditsd=0
+ pditsl=0                  rdsw=140+drdswn_lvt       prwg=0
+ prwb=0                    wr=1                      alpha0=0
+ agidl=1.685e-007          bgidl=2.069e009           cgidl=0.375
+ egidl=0.779               aigbacc=0.01256           bigbacc=0.004998
+ cigbacc=0.07068           nigbacc=3.567             aigbinv=0.35
+ bigbinv=0.03              cigbinv=0.006             eigbinv=1.1
+ nigbinv=1                 aigc=0.0102               bigc=0.001561
+ cigc=0                    aigsd=0.00852             bigsd=0.0004929
+ cigsd=0.001386            nigc=1                    poxedge=1
+ pigcd=2.3                 ntox=ntoxn_lvt            xrcrg1=12
+ xrcrg2=1                  cgso=cgon_lvt             cgdo=cgon_lvt
+ cgbo=0                    cgdl=cgln_lvt             cgsl=cgln_lvt
+ clc=1e-007                cle=0.6                   cf=cfn_lvt
+ ckappas=0.6               kt1=-0.23507161           lkt1=-3.4424886e-009
+ wkt1=-1.0001158e-008      pkt1=-1.2326268e-015      kt1l=0
+ kt2=-0.042563153          lkt2=6.2281524e-011       wkt2=-2.0774699e-008
+ pkt2=-6.2300208e-016      ute=-1.6329104            lute=-3.9800381e-009
+ wute=-2.4668462e-007      pute=-3.0576789e-015      ua1=2.2855178e-009
+ lua1=-4.9078536e-017      wua1=-1.8643083e-015      pua1=3.6510598e-023
+ ub1=-3.4814015e-018       lub1=8.2045249e-026       wub1=2.3990199e-024
+ pub1=-6.5329221e-032      uc1=-1.0408385e-010       luc1=6.7912306e-018
+ wuc1=8.8530794e-017       puc1=-5.8672081e-024      prt=0
+ at=14212.571              lat=0.0028971557          wat=0.005733148
+ pat=-4.299861e-011        njs=1                     ijthsfwd=0.01
+ ijthsrev=0.01             bvs=10                    xjbvs=1
+ cjs=cjn_lvt               cjsws=cjswn_lvt           cjswgs=cjswgn_lvt
+ xtis=3                    dmcg=9.25e-008            dmci=9.25e-008
+ dmdg=0                    dmcgt=0                   dwj=0
+ xgw=0                     xgl=0                     rshg=0.1
+ gbmin=1e-012              rbpb=50                   rbpd=50
+ rbps=50                   rbdb=50                   rbsb=50
+ igbmod=1                  igcmod=1                  rsh=10.5
+ voffcv=-0.05472           noff=1.686                moin=12.6
+ acde=1.2                  dlc=1.25e-008             beta0=5.8
+ alpha1=0.01               jswgs=9e-12               jsws=3.4e-13
+ jss=1.93e-07              tpbswg=3.00e-03           tcjswg=2.26e-03
+ tpbsw=1.90e-03            tcjsw=3.7e-04             tpb=1.20e-03
+ tcj=7.60e-04              pbswgs=0.78               pbsws=0.8
+ pbs=0.5                   mjswgs=0.52               mjsws=0.01
+ mjs=0.25                  ngcon=1                   saref=0.63e-6
+ sbref=0.63e-6             kvsat=0.3                 wlod=0.8e-6
+ tku0=0.01                 ku0=-6.86e-8              llodku0=1
+ wlodku0=1                 lku0=3.227e-7             wku0=8e-7
+ pku0=-1.7e-13             kvth0=3.5e-9              stk2=1.35e-9
+ steta0=0                  lkvth0=-2.68e-11          wkvth0=1.5e-6
+ pkvth0=0                  llodvth=1                 wlodvth=1
+ lodk2=0.5                 lodeta0=1                 fnoimod=1
+ tnoimod=0                 noia=3.39e41              noib=2.01e24
+ noic=8.75                 wpemod=wpeflag_lvt        kvth0we=0.00323
+ lkvth0we=0                wkvth0we=0                pkvth0we=0
+ ku0we=-0.003              lku0we=3.00e-10           wku0we=0
+ pku0we=0                  k2we=0.0015               wk2we=0
+ web=-210                  wec=-3500                 scref=1.00e-06
+ ud=0                      em=2.92e06                ef=0.89
+ minr=1e-3

     11: type=n
+ lmin=1.0000e-05-dxln_lvt  lmax=2.001e-05            wmin=5.0000e-07-dxwn_lvt
+ wmax=1.0000e-06-dxwn_lvt  version=4.5               binunit=2
+ paramchk=1                mobmod=0                  capmod=2
+ diomod=1                  rdsmod=0                  rbodymod=0
+ rgatemod=0                permod=1                  acnqsmod=0
+ trnqsmod=0                tnom=25                   toxe=toxn_lvt
+ toxm=toxn_lvt             dtox=3.8e-010             epsrox=3.9
+ wint=6e-009               lint=2.5e-009             ll=0
+ wl=0                      lln=1                     wln=1
+ lw=0                      ww=0                      lwn=1
+ wwn=1                     lwl=0                     wwl=0
+ llc=0                     wlc=0                     lwc=0
+ wwc=0                     lwlc=0                    wwlc=0
+ dwc=0                     xpart=1                   toxref=3e-009
+ dlcig=2.5e-009            xl=-3.5e-08+dxln_lvt      xw=1.5e-8+dxwn_lvt
+ vth0=0.2112358+dvthn_lvt  wvth0=1.0796493e-008+dwvthn_lvt
+ lvth0=0+dlvthn_lvt        pvth0=0+dpvthn_lvt        k1=0.27
+ k2=0.02064576+dk2n_lvt    wk2=-9.6865728e-010       k3=-2.7
+ k3b=1.2                   w0=0                      dvt0=20
+ dvt1=1.5                  dvt2=0                    dvt0w=0
+ dvt1w=0                   dvt2w=0                   dsub=0.5+ddsubn_lvt
+ minv=0                    voffl=0                   dvtp0=2e-007
+ dvtp1=1                   lpe0=1.5e-008             lpeb=0
+ xj=1.5e-007               ngate=1.5e020             ndep=8.3687e017
+ nsd=1e020                 phin=0                    cdsc=0
+ cdscb=0                   cdscd=0                   lcdscd=0+dlcdscdn_lvt
+ cit=0                     voff=-0.04753878          wvoff=-3.7202494e-008
+ pvoff=0+dpvoffn_lvt       lvoff=0+dlvoffn_lvt       lcit=0+dlcitn_lvt
+ nfactor=1.43399           wnfactor=-6.7099697e-007  eta0=0.33024+deta0n_lvt
+ peta0=0+dpeta0n_lvt       weta0=-4.036072e-008      etab=-0.018886
+ wetab=-1.9171342e-008     u0=0.02705232             wu0=1.291543e-009
+ ua=-1.1174744e-009        wua=2.9164669e-016        ub=2.0951226e-018
+ wub=-3.3713098e-025       uc=1.295684e-010          wuc=-1.1502805e-017
+ vsat=118000               lvsat=0+dlvsatn_lvt       pvsat=0+dpvsatn_lvt
+ a0=2.594944               wa0=-3.2692183e-007       ags=1.0231684
+ wags=-6.1953705e-008      a1=0                      a2=1
+ b0=0                      b1=0                      keta=-0.03872794
+ wketa=-2.0281262e-009     dwg=0                     dwb=0
+ pclm=0.4006               wpclm=-1.009018e-007      pdiblc1=0
+ ppclm=0+dppclmn_lvt       pdiblc2=1e-005            pdiblcb=0
+ drout=0                   pvag=0.5                  delta=0.012515
+ wdelta=-2.522545e-009     pscbe1=9.264e008          pscbe2=1e-020
+ fprout=99.7               wfprout=5.04509e-005      pdits=0
+ pditsd=0                  pditsl=0                  rdsw=140+drdswn_lvt
+ prwg=0                    prwb=0                    wr=1
+ alpha0=0                  agidl=1.685e-007          bgidl=2.069e009
+ cgidl=0.375               egidl=0.779               aigbacc=0.01256
+ bigbacc=0.004998          cigbacc=0.07068           nigbacc=3.567
+ aigbinv=0.35              bigbinv=0.03              cigbinv=0.006
+ eigbinv=1.1               nigbinv=1                 aigc=0.0102
+ bigc=0.001561             cigc=0                    aigsd=0.00852
+ bigsd=0.0004929           cigsd=0.001386            nigc=1
+ poxedge=1                 pigcd=2.3                 ntox=ntoxn_lvt
+ xrcrg1=12                 xrcrg2=1                  cgso=cgon_lvt
+ cgdo=cgon_lvt             cgbo=0                    cgdl=cgln_lvt
+ cgsl=cgln_lvt             clc=1e-007                cle=0.6
+ cf=cfn_lvt                ckappas=0.6               kt1=-0.2664746
+ wkt1=2.9362424e-008       kt1l=0                    kt2=-0.04912676
+ wkt2=4.5002203e-009       ute=-1.358446             wute=-2.6133566e-007
+ ua1=3.672957e-009         wua1=-1.4222109e-015      ub1=-5.153432e-018
+ wub1=1.5861763e-024       uc1=-2.65079e-010         wuc1=4.6919337e-017
+ prt=0                     at=270000                 njs=1
+ ijthsfwd=0.01             ijthsrev=0.01             bvs=10
+ xjbvs=1                   cjs=cjn_lvt               cjsws=cjswn_lvt
+ cjswgs=cjswgn_lvt         xtis=3                    dmcg=9.25e-008
+ dmci=9.25e-008            dmdg=0                    dmcgt=0
+ dwj=0                     xgw=0                     xgl=0
+ rshg=0.1                  gbmin=1e-012              rbpb=50
+ rbpd=50                   rbps=50                   rbdb=50
+ rbsb=50                   igbmod=1                  igcmod=1
+ rsh=10.5                  voffcv=-0.05472           noff=1.686
+ moin=12.6                 acde=1.2                  dlc=1.25e-008
+ beta0=5.8                 alpha1=0.01               jswgs=9e-12
+ jsws=3.4e-13              jss=1.93e-07              tpbswg=3.00e-03
+ tcjswg=2.26e-03           tpbsw=1.90e-03            tcjsw=3.7e-04
+ tpb=1.20e-03              tcj=7.60e-04              pbswgs=0.78
+ pbsws=0.8                 pbs=0.5                   mjswgs=0.52
+ mjsws=0.01                mjs=0.25                  ngcon=1
+ saref=0.63e-6             sbref=0.63e-6             kvsat=0.3
+ wlod=0.8e-6               tku0=0.01                 ku0=-6.86e-8
+ llodku0=1                 wlodku0=1                 lku0=3.227e-7
+ wku0=8e-7                 pku0=-1.7e-13             kvth0=3.5e-9
+ stk2=1.35e-9              steta0=0                  lkvth0=-2.68e-11
+ wkvth0=1.5e-6             pkvth0=0                  llodvth=1
+ wlodvth=1                 lodk2=0.5                 lodeta0=1
+ fnoimod=1                 tnoimod=0                 noia=3.39e41
+ noib=2.01e24              noic=8.75                 wpemod=wpeflag_lvt
+ kvth0we=0.00323           lkvth0we=0                wkvth0we=0
+ pkvth0we=0                ku0we=-0.003              lku0we=3.00e-10
+ wku0we=0                  pku0we=0                  k2we=0.0015
+ wk2we=0                   web=-210                  wec=-3500
+ scref=1.00e-06            ud=0                      em=2.92e06
+ ef=0.89                   minr=1e-3

     12: type=n
+ lmin=1.2000e-06-dxln_lvt  lmax=1.0000e-05-dxln_lvt  wmin=5.0000e-07-dxwn_lvt
+ wmax=1.0000e-06-dxwn_lvt  version=4.5               binunit=2
+ paramchk=1                mobmod=0                  capmod=2
+ diomod=1                  rdsmod=0                  rbodymod=0
+ rgatemod=0                permod=1                  acnqsmod=0
+ trnqsmod=0                tnom=25                   toxe=toxn_lvt
+ toxm=toxn_lvt             dtox=3.8e-010             epsrox=3.9
+ wint=6e-009               lint=2.5e-009             ll=0
+ wl=0                      lln=1                     wln=1
+ lw=0                      ww=0                      lwn=1
+ wwn=1                     lwl=0                     wwl=0
+ llc=0                     wlc=0                     lwc=0
+ wwc=0                     lwlc=0                    wwlc=0
+ dwc=0                     xpart=1                   toxref=3e-009
+ dlcig=2.5e-009            xl=-3.5e-08+dxln_lvt      xw=1.5e-8+dxwn_lvt
+ vth0=0.20915858+dvthn_lvt lvth0=2.0689084e-008+dlvthn_lvt
+ wvth0=1.208666e-008+dwvthn_lvt                      pvth0=-1.2850064e-014+dpvthn_lvt
+ k1=0.27                   k2=0.01968567+dk2n_lvt    lk2=9.5624946e-009
+ wk2=-5.6871924e-012       pk2=-9.5911821e-015       k3=-2.7
+ k3b=1.2                   w0=0                      dvt0=20
+ dvt1=1.5                  dvt2=0                    dvt0w=0
+ dvt1w=0                   dvt2w=0                   dsub=0.5+ddsubn_lvt
+ minv=0                    voffl=0                   dvtp0=2e-007
+ dvtp1=1                   lpe0=1.5e-008             lpeb=0
+ xj=1.5e-007               ngate=1.5e020             ndep=8.3687e017
+ nsd=1e020                 phin=0                    cdsc=0
+ cdscb=0                   cdscd=0                   lcdscd=0+dlcdscdn_lvt
+ cit=0                     voff=-0.04105269          lvoff=-6.4601455e-008+dlvoffn_lvt
+ lcit=0+dlcitn_lvt         wvoff=-4.0856194e-008     pvoff=3.6390852e-014+dpvoffn_lvt
+ nfactor=1.5114337         lnfactor=-7.7133934e-007  wnfactor=-7.4867301e-007
+ pnfactor=7.7365336e-013   eta0=0.33024+deta0n_lvt   peta0=0+dpeta0n_lvt
+ weta0=-4.036072e-008      etab=-0.018886            wetab=-1.9171342e-008
+ u0=0.026827114            lu0=2.2430527e-009        wu0=1.4790828e-009
+ pu0=-1.867896e-015        ua=-1.1130243e-009        lua=-4.4322955e-017
+ wua=3.0857541e-016        pua=-1.6861005e-022       ub=2.0886962e-018
+ lub=6.4007024e-026        wub=-3.5726023e-025       pub=2.0048737e-031
+ uc=1.2426834e-010         luc=5.2788556e-017        wuc=-7.3503292e-018
+ puc=-4.1358661e-023       vsat=118000               a0=2.5999763
+ lvsat=0+dlvsatn_lvt       pvsat=0+dpvsatn_lvt       la0=-5.0121617e-008
+ wa0=-3.5299119e-007       pa0=2.5965079e-013        ags=0.99457814
+ lags=2.8475895e-007       wags=-6.8790261e-008      pags=6.8092094e-014
+ a1=0                      a2=1                      b0=0
+ b1=0                      keta=-0.031102862         lketa=-7.5945778e-008
+ wketa=-4.3650577e-009     pketa=2.3275838e-014      dwg=0
+ dwb=0                     pclm=0.4006               ppclm=0+dppclmn_lvt
+ wpclm=-1.009018e-007      pdiblc1=0                 pdiblc2=2.1934818e-005
+ lpdiblc2=-1.1887079e-010  wpdiblc2=-1.1970623e-011  ppdiblc2=1.192274e-016
+ pdiblcb=0                 drout=0                   pvag=0.5
+ delta=0.012187432         ldelta=3.2625791e-009     wdelta=-2.8550623e-009
+ pdelta=3.3118723e-015     pscbe1=9.264e008          pscbe2=1e-020
+ fprout=86.478636          lfprout=0.00013168478     wfprout=5.7101246e-005
+ pfprout=-6.6237445e-011   pdits=0                   pditsd=0
+ pditsl=0                  rdsw=140+drdswn_lvt       prwg=0
+ prwb=0                    wr=1                      alpha0=0
+ agidl=1.685e-007          bgidl=2.069e009           cgidl=0.375
+ egidl=0.779               aigbacc=0.01256           bigbacc=0.004998
+ cigbacc=0.07068           nigbacc=3.567             aigbinv=0.35
+ bigbinv=0.03              cigbinv=0.006             eigbinv=1.1
+ nigbinv=1                 aigc=0.0102               bigc=0.001561
+ cigc=0                    aigsd=0.00852             bigsd=0.0004929
+ cigsd=0.001386            nigc=1                    poxedge=1
+ pigcd=2.3                 ntox=ntoxn_lvt            xrcrg1=12
+ xrcrg2=1                  cgso=cgon_lvt             cgdo=cgon_lvt
+ cgbo=0                    cgdl=cgln_lvt             cgsl=cgln_lvt
+ clc=1e-007                cle=0.6                   cf=cfn_lvt
+ ckappas=0.6               kt1=-0.26566887           lkt1=-8.0250255e-009
+ wkt1=3.1304325e-008       pkt1=-1.9341334e-014      kt1l=0
+ kt2=-0.050081356          lkt2=9.5077725e-009       wkt2=6.7560176e-009
+ pkt2=-2.2467741e-014      ute=-1.3474814            lute=-1.0920778e-007
+ wute=-2.6532587e-007      pute=3.9742467e-014       ua1=3.832536e-009
+ lua1=-1.5894064e-015      wua1=-1.4909089e-015      pua1=6.8423281e-022
+ ub1=-5.4394993e-018       lub1=2.8492307e-024       wub1=1.7006953e-024
+ pub1=-1.1406088e-030      uc1=-2.83962e-010         luc1=1.8807469e-016
+ wuc1=4.5486187e-017       puc1=1.4274169e-023       prt=0
+ at=273363.16              lat=-0.033497037          wat=0.0019152996
+ pat=-1.9076384e-008       njs=1                     ijthsfwd=0.01
+ ijthsrev=0.01             bvs=10                    xjbvs=1
+ cjs=cjn_lvt               cjsws=cjswn_lvt           cjswgs=cjswgn_lvt
+ xtis=3                    dmcg=9.25e-008            dmci=9.25e-008
+ dmdg=0                    dmcgt=0                   dwj=0
+ xgw=0                     xgl=0                     rshg=0.1
+ gbmin=1e-012              rbpb=50                   rbpd=50
+ rbps=50                   rbdb=50                   rbsb=50
+ igbmod=1                  igcmod=1                  rsh=10.5
+ voffcv=-0.05472           noff=1.686                moin=12.6
+ acde=1.2                  dlc=1.25e-008             beta0=5.8
+ alpha1=0.01               jswgs=9e-12               jsws=3.4e-13
+ jss=1.93e-07              tpbswg=3.00e-03           tcjswg=2.26e-03
+ tpbsw=1.90e-03            tcjsw=3.7e-04             tpb=1.20e-03
+ tcj=7.60e-04              pbswgs=0.78               pbsws=0.8
+ pbs=0.5                   mjswgs=0.52               mjsws=0.01
+ mjs=0.25                  ngcon=1                   saref=0.63e-6
+ sbref=0.63e-6             kvsat=0.3                 wlod=0.8e-6
+ tku0=0.01                 ku0=-6.86e-8              llodku0=1
+ wlodku0=1                 lku0=3.227e-7             wku0=8e-7
+ pku0=-1.7e-13             kvth0=3.5e-9              stk2=1.35e-9
+ steta0=0                  lkvth0=-2.68e-11          wkvth0=1.5e-6
+ pkvth0=0                  llodvth=1                 wlodvth=1
+ lodk2=0.5                 lodeta0=1                 fnoimod=1
+ tnoimod=0                 noia=3.39e41              noib=2.01e24
+ noic=8.75                 wpemod=wpeflag_lvt        kvth0we=0.00323
+ lkvth0we=0                wkvth0we=0                pkvth0we=0
+ ku0we=-0.003              lku0we=3.00e-10           wku0we=0
+ pku0we=0                  k2we=0.0015               wk2we=0
+ web=-210                  wec=-3500                 scref=1.00e-06
+ ud=0                      em=2.92e06                ef=0.89
+ minr=1e-3

     13: type=n
+ lmin=5.0000e-07-dxln_lvt  lmax=1.2000e-06-dxln_lvt  wmin=5.0000e-07-dxwn_lvt
+ wmax=1.0000e-06-dxwn_lvt  version=4.5               binunit=2
+ paramchk=1                mobmod=0                  capmod=2
+ diomod=1                  rdsmod=0                  rbodymod=0
+ rgatemod=0                permod=1                  acnqsmod=0
+ trnqsmod=0                tnom=25                   toxe=toxn_lvt
+ toxm=toxn_lvt             dtox=3.8e-010             epsrox=3.9
+ wint=6e-009               lint=2.5e-009             ll=0
+ wl=0                      lln=1                     wln=1
+ lw=0                      ww=0                      lwn=1
+ wwn=1                     lwl=0                     wwl=0
+ llc=0                     wlc=0                     lwc=0
+ wwc=0                     lwlc=0                    wwlc=0
+ dwc=0                     xpart=1                   toxref=3e-009
+ dlcig=2.5e-009            xl=-3.5e-08+dxln_lvt      xw=1.5e-8+dxwn_lvt
+ vth0=0.22510051+dvthn_lvt lvth0=2.1964501e-009+dlvthn_lvt
+ wvth0=-1.0464958e-009+dwvthn_lvt                    pvth0=2.384396e-015+dpvthn_lvt
+ k1=0.27                   k2=0.029128592+dk2n_lvt   lk2=-1.3912949e-009
+ wk2=-6.9657125e-009       pk2=-1.5175527e-015       k3=-2.7
+ k3b=1.2                   w0=0                      dvt0=20
+ dvt1=1.5                  dvt2=0                    dvt0w=0
+ dvt1w=0                   dvt2w=0                   dsub=0.5+ddsubn_lvt
+ minv=0                    voffl=0                   dvtp0=2e-007
+ dvtp1=1                   lpe0=1.5e-008             lpeb=0
+ xj=1.5e-007               ngate=1.5e020             ndep=8.3687e017
+ nsd=1e020                 phin=0                    cdsc=0
+ cdscb=0                   cdscd=0                   lcdscd=0+dlcdscdn_lvt
+ cit=0                     voff=-0.092807446         lvoff=-4.565939e-009+dlvoffn_lvt
+ lcit=0+dlcitn_lvt         wvoff=-8.3575519e-009     pvoff=-1.307572e-015+dpvoffn_lvt
+ nfactor=0.846486          wnfactor=-8.1730458e-008  eta0=0.33024+deta0n_lvt
+ peta0=0+dpeta0n_lvt       weta0=-4.036072e-008      etab=-0.018886
+ wetab=-1.9171342e-008     u0=0.027561823            lu0=1.3907903e-009
+ wu0=3.6612939e-010        pu0=-5.7687001e-016       ua=-1.1620749e-009
+ lua=1.2575827e-017        wua=2.0431712e-016        pua=-4.767043e-023
+ ub=2.2589905e-018         lub=-1.335344e-025        wub=-2.2874211e-025
+ pub=5.1406348e-032        uc=2.1715207e-010         luc=-5.4956562e-017
+ wuc=-7.0017777e-017       puc=3.1335579e-023        vsat=118000
+ a0=3.1206123              lvsat=0+dlvsatn_lvt       pvsat=0+dpvsatn_lvt
+ la0=-6.5405944e-007       wa0=-1.3180658e-007       pa0=3.07664e-015
+ ags=1.4720682             lags=-2.6912955e-007      wags=-1.2679032e-007
+ pags=1.3537216e-013       a1=0                      a2=1
+ b0=0                      b1=0                      keta=-0.10972216
+ lketa=1.5252605e-008      wketa=1.2278884e-008      pketa=3.9688656e-015
+ dwg=0                     dwb=0                     pclm=0.4006
+ ppclm=0+dppclmn_lvt       wpclm=-1.009018e-007      pdiblc1=0
+ pdiblc2=0.00051443714     lpdiblc2=-6.9017349e-010  wpdiblc2=-5.0595045e-010
+ ppdiblc2=6.9224401e-016   pdiblcb=0                 drout=0
+ pvag=0.5                  delta=0.011694571         ldelta=3.8342971e-009
+ wdelta=3.3153449e-009     pdelta=-3.8458e-015       pscbe1=9.264e008
+ pscbe2=1e-020             fprout=331.82286          lfprout=-0.00015291451
+ wfprout=-6.6306897e-005   pfprout=7.6916001e-011    pdits=0
+ pditsd=0                  pditsl=0                  rdsw=140+drdswn_lvt
+ prwg=0                    prwb=0                    wr=1
+ alpha0=0                  agidl=1.685e-007          bgidl=2.069e009
+ cgidl=0.375               egidl=0.779               aigbacc=0.01256
+ bigbacc=0.004998          cigbacc=0.07068           nigbacc=3.567
+ aigbinv=0.35              bigbinv=0.03              cigbinv=0.006
+ eigbinv=1.1               nigbinv=1                 aigc=0.0102
+ bigc=0.001561             cigc=0                    aigsd=0.00852
+ bigsd=0.0004929           cigsd=0.001386            nigc=1
+ poxedge=1                 pigcd=2.3                 ntox=ntoxn_lvt
+ xrcrg1=12                 xrcrg2=1                  cgso=cgon_lvt
+ cgdo=cgon_lvt             cgbo=0                    cgdl=cgln_lvt
+ cgsl=cgln_lvt             clc=1e-007                cle=0.6
+ cf=cfn_lvt                ckappas=0.6               kt1=-0.27938002
+ lkt1=7.8798999e-009       wkt1=1.8741789e-008       pkt1=-4.768792e-015
+ kt1l=0                    kt2=-0.021250267          lkt2=-2.393629e-008
+ wkt2=-3.0369712e-008      pkt2=2.0598105e-014       ute=-1.3841786
+ lute=-6.6639017e-008      wute=-2.7747995e-007      pute=5.38412e-014
+ ua1=2.7550047e-009        lua1=-3.3947022e-016      wua1=-1.0482544e-015
+ pua1=1.7075352e-022       ub1=-3.1335007e-018       lub1=1.7427224e-025
+ wub1=7.857079e-025        pub1=-7.9223481e-032      uc1=-2.8896973e-010
+ luc1=1.9388365e-016       wuc1=1.8710322e-016       puc1=-1.5000158e-022
+ prt=0                     at=312595.84              lat=-0.07900695
+ wat=-0.0084296247         pat=-7.0762721e-009       njs=1
+ ijthsfwd=0.01             ijthsrev=0.01             bvs=10
+ xjbvs=1                   cjs=cjn_lvt               cjsws=cjswn_lvt
+ cjswgs=cjswgn_lvt         xtis=3                    dmcg=9.25e-008
+ dmci=9.25e-008            dmdg=0                    dmcgt=0
+ dwj=0                     xgw=0                     xgl=0
+ rshg=0.1                  gbmin=1e-012              rbpb=50
+ rbpd=50                   rbps=50                   rbdb=50
+ rbsb=50                   igbmod=1                  igcmod=1
+ rsh=10.5                  voffcv=-0.05472           noff=1.686
+ moin=12.6                 acde=1.2                  dlc=1.25e-008
+ beta0=5.8                 alpha1=0.01               jswgs=9e-12
+ jsws=3.4e-13              jss=1.93e-07              tpbswg=3.00e-03
+ tcjswg=2.26e-03           tpbsw=1.90e-03            tcjsw=3.7e-04
+ tpb=1.20e-03              tcj=7.60e-04              pbswgs=0.78
+ pbsws=0.8                 pbs=0.5                   mjswgs=0.52
+ mjsws=0.01                mjs=0.25                  ngcon=1
+ saref=0.63e-6             sbref=0.63e-6             kvsat=0.3
+ wlod=0.8e-6               tku0=0.01                 ku0=-6.86e-8
+ llodku0=1                 wlodku0=1                 lku0=3.227e-7
+ wku0=8e-7                 pku0=-1.7e-13             kvth0=3.5e-9
+ stk2=1.35e-9              steta0=0                  lkvth0=-2.68e-11
+ wkvth0=1.5e-6             pkvth0=0                  llodvth=1
+ wlodvth=1                 lodk2=0.5                 lodeta0=1
+ fnoimod=1                 tnoimod=0                 noia=3.39e41
+ noib=2.01e24              noic=8.75                 wpemod=wpeflag_lvt
+ kvth0we=0.00323           lkvth0we=0                wkvth0we=0
+ pkvth0we=0                ku0we=-0.003              lku0we=3.00e-10
+ wku0we=0                  pku0we=0                  k2we=0.0015
+ wk2we=0                   web=-210                  wec=-3500
+ scref=1.00e-06            ud=0                      em=2.92e06
+ ef=0.89                   minr=1e-3

     14: type=n
+ lmin=2.4000e-07-dxln_lvt  lmax=5.0000e-07-dxln_lvt  wmin=5.0000e-07-dxwn_lvt
+ wmax=1.0000e-06-dxwn_lvt  version=4.5               binunit=2
+ paramchk=1                mobmod=0                  capmod=2
+ diomod=1                  rdsmod=0                  rbodymod=0
+ rgatemod=0                permod=1                  acnqsmod=0
+ trnqsmod=0                tnom=25                   toxe=toxn_lvt
+ toxm=toxn_lvt             dtox=3.8e-010             epsrox=3.9
+ wint=6e-009               lint=2.5e-009             ll=0
+ wl=0                      lln=1                     wln=1
+ lw=0                      ww=0                      lwn=1
+ wwn=1                     lwl=0                     wwl=0
+ llc=0                     wlc=0                     lwc=0
+ wwc=0                     lwlc=0                    wwlc=0
+ dwc=0                     xpart=1                   toxref=3e-009
+ dlcig=2.5e-009            xl=-3.5e-08+dxln_lvt      xw=1.5e-8+dxwn_lvt
+ vth0=0.23055802+dvthn_lvt lvth0=-3.1400308e-010+dlvthn_lvt
+ wvth0=5.766926e-009+dwvthn_lvt                      pvth0=-7.4977799e-016+dpvthn_lvt
+ k1=0.27                   k2=0.050592669+dk2n_lvt   lk2=-1.126477e-008
+ wk2=-2.2582521e-008       pk2=5.6661794e-015        k3=-2.7
+ k3b=1.2                   w0=0                      dvt0=20
+ dvt1=1.5                  dvt2=0                    dvt0w=0
+ dvt1w=0                   dvt2w=0                   dsub=0.5+ddsubn_lvt
+ minv=0                    voffl=0                   dvtp0=2e-007
+ dvtp1=1                   lpe0=1.5e-008             lpeb=0
+ xj=1.5e-007               ngate=1.5e020             ndep=8.3687e017
+ nsd=1e020                 phin=0                    cdsc=0
+ cdscb=0                   cdscd=0                   lcdscd=0+dlcdscdn_lvt
+ cit=0                     voff=-0.094571246         lvoff=-3.7545908e-009+dlvoffn_lvt
+ lcit=0+dlcitn_lvt         wvoff=-1.2597202e-008     pvoff=6.4266685e-016+dpvoffn_lvt
+ nfactor=0.78148292        lnfactor=2.9901415e-008   wnfactor=-1.6532372e-008
+ pnfactor=-2.999112e-014   eta0=0.33024+deta0n_lvt   peta0=0+dpeta0n_lvt
+ weta0=-4.036072e-008      etab=-0.018886            wetab=-1.9171342e-008
+ u0=0.028377311            lu0=1.0156658e-009        wu0=-8.4136578e-010
+ pu0=-2.1422228e-017       ua=-1.4122441e-009        lua=1.2765363e-016
+ wua=2.6984641e-016        pua=-7.7813902e-023       ub=2.4509689e-018
+ lub=-2.2184444e-025       wub=-4.071181e-025        pub=1.334593e-031
+ uc=1.5071954e-010         luc=-2.43976e-017         wuc=-3.5497253e-017
+ puc=1.5456138e-023        vsat=118000               a0=0.88501477
+ lvsat=0+dlvsatn_lvt       pvsat=0+dpvsatn_lvt       la0=3.7431545e-007
+ wa0=1.1394142e-007        pa0=-1.0996744e-013       ags=1.6471609
+ lags=-3.4967218e-007      wags=1.4110729e-007       pags=1.2139263e-014
+ a1=0                      a2=1                      b0=0
+ b1=0                      keta=-0.14384265          lketa=3.094803e-008
+ wketa=4.5074774e-008      pketa=-1.1117244e-014     dwg=0
+ dwb=0                     pclm=0.36213846           ppclm=0+dppclmn_lvt
+ lpclm=1.7692308e-008      wpclm=-1.009018e-007      pdiblc1=0
+ pdiblc2=0.00042287538     lpdiblc2=-6.4805508e-010  wpdiblc2=-4.8355247e-010
+ ppdiblc2=6.8194093e-016   pdiblcb=0                 drout=0
+ pvag=0.5                  delta=0.023899231         ldelta=-1.7798462e-009
+ wdelta=-8.9259285e-009    pdelta=1.7851857e-015     pscbe1=9.264e008
+ pscbe2=1e-020             fprout=-154.90769         lfprout=7.0981538e-005
+ wfprout=0.00017851857     pfprout=-3.5703714e-011   pdits=0
+ pditsd=0                  pditsl=0                  rdsw=140+drdswn_lvt
+ prwg=0                    prwb=0                    wr=1
+ alpha0=0                  agidl=1.685e-007          bgidl=2.069e009
+ cgidl=0.375               egidl=0.779               aigbacc=0.01256
+ bigbacc=0.004998          cigbacc=0.07068           nigbacc=3.567
+ aigbinv=0.35              bigbinv=0.03              cigbinv=0.006
+ eigbinv=1.1               nigbinv=1                 aigc=0.0102
+ bigc=0.001561             cigc=0                    aigsd=0.00852
+ bigsd=0.0004929           cigsd=0.001386            nigc=1
+ poxedge=1                 pigcd=2.3                 ntox=ntoxn_lvt
+ xrcrg1=12                 xrcrg2=1                  cgso=cgon_lvt
+ cgdo=cgon_lvt             cgbo=0                    cgdl=cgln_lvt
+ cgsl=cgln_lvt             clc=1e-007                cle=0.6
+ cf=cfn_lvt                ckappas=0.6               kt1=-0.25914395
+ lkt1=-1.4286892e-009      wkt1=1.6446993e-008       pkt1=-3.7131862e-015
+ kt1l=0                    kt2=-0.06225268           lkt2=-5.07518e-009
+ wkt2=8.859178e-009        pkt2=2.5528155e-015       ute=-1.1888183
+ lute=-1.5650474e-007      wute=-3.2808608e-007      pute=7.7120022e-014
+ ua1=3.5270811e-009        lua1=-6.9462534e-016      wua1=-1.4366088e-015
+ pua1=3.4939654e-022       ub1=-4.488228e-018        lub1=7.974468e-025
+ wub1=1.4742529e-024       pub1=-3.9595419e-031      uc1=2.0190714e-010
+ luc1=-3.1919708e-017      wuc1=-2.046859e-016       puc1=3.0221409e-023
+ prt=0                     at=231231.14              lat=-0.041579188
+ wat=-0.050512993          pat=1.2282078e-008        njs=1
+ ijthsfwd=0.01             ijthsrev=0.01             bvs=10
+ xjbvs=1                   cjs=cjn_lvt               cjsws=cjswn_lvt
+ cjswgs=cjswgn_lvt         xtis=3                    dmcg=9.25e-008
+ dmci=9.25e-008            dmdg=0                    dmcgt=0
+ dwj=0                     xgw=0                     xgl=0
+ rshg=0.1                  gbmin=1e-012              rbpb=50
+ rbpd=50                   rbps=50                   rbdb=50
+ rbsb=50                   igbmod=1                  igcmod=1
+ rsh=10.5                  voffcv=-0.05472           noff=1.686
+ moin=12.6                 acde=1.2                  dlc=1.25e-008
+ beta0=5.8                 alpha1=0.01               jswgs=9e-12
+ jsws=3.4e-13              jss=1.93e-07              tpbswg=3.00e-03
+ tcjswg=2.26e-03           tpbsw=1.90e-03            tcjsw=3.7e-04
+ tpb=1.20e-03              tcj=7.60e-04              pbswgs=0.78
+ pbsws=0.8                 pbs=0.5                   mjswgs=0.52
+ mjsws=0.01                mjs=0.25                  ngcon=1
+ saref=0.63e-6             sbref=0.63e-6             kvsat=0.3
+ wlod=0.8e-6               tku0=0.01                 ku0=-6.86e-8
+ llodku0=1                 wlodku0=1                 lku0=3.227e-7
+ wku0=8e-7                 pku0=-1.7e-13             kvth0=3.5e-9
+ stk2=1.35e-9              steta0=0                  lkvth0=-2.68e-11
+ wkvth0=1.5e-6             pkvth0=0                  llodvth=1
+ wlodvth=1                 lodk2=0.5                 lodeta0=1
+ fnoimod=1                 tnoimod=0                 noia=3.39e41
+ noib=2.01e24              noic=8.75                 wpemod=wpeflag_lvt
+ kvth0we=0.00323           lkvth0we=0                wkvth0we=0
+ pkvth0we=0                ku0we=-0.003              lku0we=3.00e-10
+ wku0we=0                  pku0we=0                  k2we=0.0015
+ wk2we=0                   web=-210                  wec=-3500
+ scref=1.00e-06            ud=0                      em=2.92e06
+ ef=0.89                   minr=1e-3

     15: type=n
+ lmin=1.0e-07              lmax=2.4000e-07-dxln_lvt  wmin=5.0000e-07-dxwn_lvt
+ wmax=1.0000e-06-dxwn_lvt  version=4.5               binunit=2
+ paramchk=1                mobmod=0                  capmod=2
+ diomod=1                  rdsmod=0                  rbodymod=0
+ rgatemod=0                permod=1                  acnqsmod=0
+ trnqsmod=0                tnom=25                   toxe=toxn_lvt
+ toxm=toxn_lvt             dtox=3.8e-010             epsrox=3.9
+ wint=6e-009               lint=2.5e-009             ll=0
+ wl=0                      lln=1                     wln=1
+ lw=0                      ww=0                      lwn=1
+ wwn=1                     lwl=0                     wwl=0
+ llc=0                     wlc=0                     lwc=0
+ wwc=0                     lwlc=0                    wwlc=0
+ dwc=0                     xpart=1                   toxref=3e-009
+ dlcig=2.5e-009            xl=-3.5e-08+dxln_lvt      xw=1.5e-8+dxwn_lvt
+ vth0=0.2370868+dvthn_lvt  lvth0=-1.61976e-009+dlvthn_lvt
+ wvth0=-4.9874318e-009+dwvthn_lvt                    pvth0=1.4010936e-015+dpvthn_lvt
+ k1=0.27                   k2=-0.0064244194+dk2n_lvt lk2=1.3864749e-010
+ wk2=4.7792858e-009        pk2=1.9381794e-016        k3=-2.7
+ k3b=1.2                   w0=0                      dvt0=20
+ dvt1=1.5                  dvt2=0                    dvt0w=0
+ dvt1w=0                   dvt2w=0                   dsub=0.5+ddsubn_lvt
+ minv=0                    voffl=0                   dvtp0=2e-007
+ dvtp1=1                   lpe0=1.5e-008             lpeb=0
+ xj=1.5e-007               ngate=1.5e020             ndep=8.3687e017
+ nsd=1e020                 phin=0                    cdsc=0
+ cdscb=0                   cdscd=0                   lcdscd=0+dlcdscdn_lvt
+ cit=0                     voff=-0.11029989          lvoff=-6.0886286e-010+dlvoffn_lvt
+ lcit=0+dlcitn_lvt         wvoff=-2.4216432e-009     pvoff=-1.3924448e-015+dpvoffn_lvt
+ nfactor=0.42844286        lnfactor=1.0050943e-007   wnfactor=2.1621814e-008
+ pnfactor=-3.7621957e-014  eta0=0.33024+deta0n_lvt   peta0=0+dpeta0n_lvt
+ weta0=-4.036072e-008      etab=-0.018886            wetab=-1.9171342e-008
+ u0=0.042295303            lu0=-1.7679326e-009       wu0=-3.5344459e-009
+ pu0=5.171938e-016         ua=-1.4682857e-010        lua=-1.2542947e-016
+ wua=-3.760428e-016        pua=5.136394e-023         ub=8.9177938e-019
+ lub=8.999346e-026         wub=5.406204e-025         pub=-5.6088396e-032
+ uc=3.3467074e-011         luc=-9.4710686e-019       wuc=4.830025e-017
+ puc=-1.303363e-024        vsat=118000               a0=3.0687814
+ lvsat=0+dlvsatn_lvt       pvsat=0+dpvsatn_lvt       la0=-6.2437886e-008
+ wa0=-3.956792e-007        pa0=-8.0433149e-015       ags=-0.14328571
+ lags=8.4171429e-009       wags=7.2072714e-008       pags=2.5946177e-014
+ a1=0                      a2=1                      b0=0
+ b1=0                      keta=0.018608635          lketa=-1.542226e-009
+ wketa=-1.8701572e-008     pketa=1.6380254e-015      dwg=0
+ dwb=0                     pclm=0.53657143           lpclm=-1.7194286e-008
+ wpclm=-1.4414543e-007     ppclm=8.6487257e-015+dppclmn_lvt
+ pdiblc1=0                 pdiblc2=-0.0044457143     lpdiblc2=3.2566286e-010
+ wpdiblc2=2.8829086e-009   ppdiblc2=8.6487257e-018   pdiblcb=0
+ drout=0                   pvag=0.5                  delta=0.015
+ pscbe1=9.264e008          pscbe2=1e-020             fprout=200
+ pdits=0                   pditsd=0                  pditsl=0
+ rdsw=140+drdswn_lvt       prwg=0                    prwb=0
+ wr=1                      alpha0=0                  agidl=1.685e-007
+ bgidl=2.069e009           cgidl=0.375               egidl=0.779
+ aigbacc=0.01256           bigbacc=0.004998          cigbacc=0.07068
+ nigbacc=3.567             aigbinv=0.35              bigbinv=0.03
+ cigbinv=0.006             eigbinv=1.1               nigbinv=1
+ aigc=0.0102               bigc=0.001561             cigc=0
+ aigsd=0.00852             bigsd=0.0004929           cigsd=0.001386
+ nigc=1                    poxedge=1                 pigcd=2.3
+ ntox=ntoxn_lvt            xrcrg1=12                 xrcrg2=1
+ cgso=cgon_lvt             cgdo=cgon_lvt             cgbo=0
+ cgdl=cgln_lvt             cgsl=cgln_lvt             clc=1e-007
+ cle=0.6                   cf=cfn_lvt                ckappas=0.6
+ kt1=-0.23111694           lkt1=-7.0340914e-009      wkt1=-1.3967692e-008
+ pkt1=2.3697508e-015       kt1l=0                    kt2=-0.077211689
+ lkt2=-2.0833783e-009      wkt2=1.3977782e-008       pkt2=1.5290947e-015
+ ute=-2.0056131            lute=6.8542286e-009       wute=1.2713627e-007
+ pute=-1.3924448e-014      ua1=-2.7521546e-010       lua1=6.5833971e-017
+ wua1=7.0410717e-016       pua1=-7.8746648e-023      ub1=-1.3526554e-019
+ lub1=-7.3145691e-026      wub1=-9.5715447e-025      pub1=9.0327291e-032
+ uc1=3.2864639e-011        luc1=1.8887923e-018       wuc1=-4.8828543e-017
+ puc1=-9.5006252e-025      prt=0                     at=333.12857
+ lat=0.0046004143          wat=0.019654229           pat=-1.751367e-009
+ njs=1                     ijthsfwd=0.01             ijthsrev=0.01
+ bvs=10                    xjbvs=1                   cjs=cjn_lvt
+ cjsws=cjswn_lvt           cjswgs=cjswgn_lvt         xtis=3
+ dmcg=9.25e-008            dmci=9.25e-008            dmdg=0
+ dmcgt=0                   dwj=0                     xgw=0
+ xgl=0                     rshg=0.1                  gbmin=1e-012
+ rbpb=50                   rbpd=50                   rbps=50
+ rbdb=50                   rbsb=50                   igbmod=1
+ igcmod=1                  rsh=10.5                  voffcv=-0.05472
+ noff=1.686                moin=12.6                 acde=1.2
+ dlc=1.25e-008             beta0=5.8                 alpha1=0.01
+ jswgs=9e-12               jsws=3.4e-13              jss=1.93e-07
+ tpbswg=3.00e-03           tcjswg=2.26e-03           tpbsw=1.90e-03
+ tcjsw=3.7e-04             tpb=1.20e-03              tcj=7.60e-04
+ pbswgs=0.78               pbsws=0.8                 pbs=0.5
+ mjswgs=0.52               mjsws=0.01                mjs=0.25
+ ngcon=1                   saref=0.63e-6             sbref=0.63e-6
+ kvsat=0.3                 wlod=0.8e-6               tku0=0.01
+ ku0=-6.86e-8              llodku0=1                 wlodku0=1
+ lku0=3.227e-7             wku0=8e-7                 pku0=-1.7e-13
+ kvth0=3.5e-9              stk2=1.35e-9              steta0=0
+ lkvth0=-2.68e-11          wkvth0=1.5e-6             pkvth0=0
+ llodvth=1                 wlodvth=1                 lodk2=0.5
+ lodeta0=1                 fnoimod=1                 tnoimod=0
+ noia=3.39e41              noib=2.01e24              noic=8.75
+ wpemod=wpeflag_lvt        kvth0we=0.00323           lkvth0we=0
+ wkvth0we=0                pkvth0we=0                ku0we=-0.003
+ lku0we=3.00e-10           wku0we=0                  pku0we=0
+ k2we=0.0015               wk2we=0                   web=-210
+ wec=-3500                 scref=1.00e-06            ud=0
+ em=2.92e06                ef=0.89                   minr=1e-3

     16: type=n
+ lmin=1.0000e-05-dxln_lvt  lmax=2.001e-05            wmin=2.4000e-07-dxwn_lvt
+ wmax=5.0000e-07-dxwn_lvt  version=4.5               binunit=2
+ paramchk=1                mobmod=0                  capmod=2
+ diomod=1                  rdsmod=0                  rbodymod=0
+ rgatemod=0                permod=1                  acnqsmod=0
+ trnqsmod=0                tnom=25                   toxe=toxn_lvt
+ toxm=toxn_lvt             dtox=3.8e-010             epsrox=3.9
+ wint=6e-009               lint=2.5e-009             ll=0
+ wl=0                      lln=1                     wln=1
+ lw=0                      ww=0                      lwn=1
+ wwn=1                     lwl=0                     wwl=0
+ llc=0                     wlc=0                     lwc=0
+ wwc=0                     lwlc=0                    wwlc=0
+ dwc=0                     xpart=1                   toxref=3e-009
+ dlcig=2.5e-009            xl=-3.5e-08+dxln_lvt      xw=1.5e-8+dxwn_lvt
+ vth0=0.24933615+dvthn_lvt wvth0=-8.3679854e-009+dwvthn_lvt
+ lvth0=0+dlvthn_lvt        pvth0=0+dpvthn_lvt        k1=0.27
+ k2=0.023411769+dk2n_lvt   wk2=-2.3599599e-009       k3=-2.7
+ k3b=1.2                   w0=0                      dvt0=20
+ dvt1=1.5                  dvt2=0                    dvt0w=0
+ dvt1w=0                   dvt2w=0                   dsub=0.5+ddsubn_lvt
+ minv=0                    voffl=0                   dvtp0=2e-007
+ dvtp1=1                   lpe0=1.5e-008             lpeb=0
+ xj=1.5e-007               ngate=1.5e020             ndep=8.3687e017
+ nsd=1e020                 phin=0                    cdsc=0
+ cdscb=0                   cdscd=0                   lcdscd=0+dlcdscdn_lvt
+ cit=0                     voff=-0.12813577          wvoff=3.3377919e-009
+ pvoff=0+dpvoffn_lvt       lvoff=0+dlvoffn_lvt       lcit=0+dlcitn_lvt
+ nfactor=0.0065384615      wnfactor=4.7011154e-008   eta0=0.25934615+deta0n_lvt
+ peta0=0+dpeta0n_lvt       weta0=-4.7011154e-009     etab=-0.007185
+ wetab=-2.5056945e-008     u0=0.032629462            wu0=-1.5137592e-009
+ ua=-3.8039854e-010        wua=-7.9102448e-017       ub=1.3014027e-018
+ wub=6.2110149e-026        uc=1.1796212e-010         wuc=-5.664844e-018
+ vsat=118000               lvsat=0+dlvsatn_lvt       pvsat=0+dpvsatn_lvt
+ a0=1.4403077              wa0=2.5386023e-007        ags=0.89943923
+ wags=2.8206692e-010       a1=0                      a2=1
+ b0=0                      b1=0                      keta=-0.044900269
+ wketa=1.0765554e-009      dwg=0                     dwb=0
+ pclm=0.15326923           wpclm=2.3505577e-008      pdiblc1=0
+ ppclm=0+dppclmn_lvt       pdiblc2=1e-005            pdiblcb=0
+ drout=0                   pvag=0.5                  delta=0.0051634615
+ wdelta=1.1752788e-009     pscbe1=9.264e008          pscbe2=1e-020
+ fprout=293.46154          wfprout=-4.7011154e-005   pdits=0
+ pditsd=0                  pditsl=0                  rdsw=140+drdswn_lvt
+ prwg=0                    prwb=0                    wr=1
+ alpha0=0                  agidl=1.685e-007          bgidl=2.069e009
+ cgidl=0.375               egidl=0.779               aigbacc=0.01256
+ bigbacc=0.004998          cigbacc=0.07068           nigbacc=3.567
+ aigbinv=0.35              bigbinv=0.03              cigbinv=0.006
+ eigbinv=1.1               nigbinv=1                 aigc=0.0102
+ bigc=0.001561             cigc=0                    aigsd=0.00852
+ bigsd=0.0004929           cigsd=0.001386            nigc=1
+ poxedge=1                 pigcd=2.3                 ntox=ntoxn_lvt
+ xrcrg1=12                 xrcrg2=1                  cgso=cgon_lvt
+ cgdo=cgon_lvt             cgbo=0                    cgdl=cgln_lvt
+ cgsl=cgln_lvt             clc=1e-007                cle=0.6
+ cf=cfn_lvt                ckappas=0.6               kt1=-0.19641731
+ wkt1=-5.8763942e-009      kt1l=0                    kt2=-0.036011615
+ wkt2=-2.0966975e-009      ute=-1.8957577            wute=8.9321192e-009
+ ua1=6.45025e-010          wua1=1.0083893e-016       ub1=-1.3925e-018
+ wub1=-3.055725e-025       uc1=-1.6310808e-010       wuc1=-4.3720373e-018
+ prt=0                     at=270000                 njs=1
+ ijthsfwd=0.01             ijthsrev=0.01             bvs=10
+ xjbvs=1                   cjs=cjn_lvt               cjsws=cjswn_lvt
+ cjswgs=cjswgn_lvt         xtis=3                    dmcg=9.25e-008
+ dmci=9.25e-008            dmdg=0                    dmcgt=0
+ dwj=0                     xgw=0                     xgl=0
+ rshg=0.1                  gbmin=1e-012              rbpb=50
+ rbpd=50                   rbps=50                   rbdb=50
+ rbsb=50                   igbmod=1                  igcmod=1
+ rsh=10.5                  voffcv=-0.05472           noff=1.686
+ moin=12.6                 acde=1.2                  dlc=1.25e-008
+ beta0=5.8                 alpha1=0.01               jswgs=9e-12
+ jsws=3.4e-13              jss=1.93e-07              tpbswg=3.00e-03
+ tcjswg=2.26e-03           tpbsw=1.90e-03            tcjsw=3.7e-04
+ tpb=1.20e-03              tcj=7.60e-04              pbswgs=0.78
+ pbsws=0.8                 pbs=0.5                   mjswgs=0.52
+ mjsws=0.01                mjs=0.25                  ngcon=1
+ saref=0.63e-6             sbref=0.63e-6             kvsat=0.3
+ wlod=0.8e-6               tku0=0.01                 ku0=-6.86e-8
+ llodku0=1                 wlodku0=1                 lku0=3.227e-7
+ wku0=8e-7                 pku0=-1.7e-13             kvth0=3.5e-9
+ stk2=1.35e-9              steta0=0                  lkvth0=-2.68e-11
+ wkvth0=1.5e-6             pkvth0=0                  llodvth=1
+ wlodvth=1                 lodk2=0.5                 lodeta0=1
+ fnoimod=1                 tnoimod=0                 noia=3.39e41
+ noib=2.01e24              noic=8.75                 wpemod=wpeflag_lvt
+ kvth0we=0.00323           lkvth0we=0                wkvth0we=0
+ pkvth0we=0                ku0we=-0.003              lku0we=3.00e-10
+ wku0we=0                  pku0we=0                  k2we=0.0015
+ wk2we=0                   web=-210                  wec=-3500
+ scref=1.00e-06            ud=0                      em=2.92e06
+ ef=0.89                   minr=1e-3

     17: type=n
+ lmin=1.2000e-06-dxln_lvt  lmax=1.0000e-05-dxln_lvt  wmin=2.4000e-07-dxwn_lvt
+ wmax=5.0000e-07-dxwn_lvt  version=4.5               binunit=2
+ paramchk=1                mobmod=0                  capmod=2
+ diomod=1                  rdsmod=0                  rbodymod=0
+ rgatemod=0                permod=1                  acnqsmod=0
+ trnqsmod=0                tnom=25                   toxe=toxn_lvt
+ toxm=toxn_lvt             dtox=3.8e-010             epsrox=3.9
+ wint=6e-009               lint=2.5e-009             ll=0
+ wl=0                      lln=1                     wln=1
+ lw=0                      ww=0                      lwn=1
+ wwn=1                     lwl=0                     wwl=0
+ llc=0                     wlc=0                     lwc=0
+ wwc=0                     lwlc=0                    wwlc=0
+ dwc=0                     xpart=1                   toxref=3e-009
+ dlcig=2.5e-009            xl=-3.5e-08+dxln_lvt      xw=1.5e-8+dxwn_lvt
+ vth0=0.25078484+dvthn_lvt lvth0=-1.4428871e-008+dlvthn_lvt
+ wvth0=-8.8513455e-009+dwvthn_lvt                    pvth0=4.814267e-015+dpvthn_lvt
+ k1=0.27                   k2=0.024802258+dk2n_lvt   lk2=-1.3849272e-008
+ wk2=-2.5793311e-009       pk2=2.1849365e-015        k3=-2.7
+ k3b=1.2                   w0=0                      dvt0=20
+ dvt1=1.5                  dvt2=0                    dvt0w=0
+ dvt1w=0                   dvt2w=0                   dsub=0.5+ddsubn_lvt
+ minv=0                    voffl=0                   dvtp0=2e-007
+ dvtp1=1                   lpe0=1.5e-008             lpeb=0
+ xj=1.5e-007               ngate=1.5e020             ndep=8.3687e017
+ nsd=1e020                 phin=0                    cdsc=0
+ cdscb=0                   cdscd=0                   lcdscd=0+dlcdscdn_lvt
+ cit=0                     voff=-0.13119268          lvoff=3.0446867e-008+dlvoffn_lvt
+ lcit=0+dlcitn_lvt         wvoff=4.484223e-009       pvoff=-1.1418454e-014+dpvoffn_lvt
+ nfactor=-0.1333982        lnfactor=1.3937691e-006   wnfactor=7.867744e-008
+ pnfactor=-3.1539621e-013  eta0=0.25934615+deta0n_lvt
+ peta0=0+dpeta0n_lvt       weta0=-4.7011154e-009     etab=-0.0028360647
+ letab=-4.3315396e-008     wetab=-2.7244459e-008     petab=2.1787644e-014
+ u0=0.032719194            lu0=-8.9373762e-010       wu0=-1.4846336e-009
+ pu0=-2.9009044e-016       ua=-3.5301128e-010        lua=-2.7277716e-016
+ wua=-7.3711124e-017       pua=-5.3697587e-023       ub=1.2708087e-018
+ lub=3.0471595e-025        wub=5.413718e-026         pub=7.9410778e-032
+ uc=1.245728e-010          luc=-6.5842441e-017       wuc=-7.5034716e-018
+ puc=1.8312731e-023        vsat=118000               a0=1.3559365
+ la0=8.4033756e-007        lvsat=0+dlvsatn_lvt       pvsat=0+dpvsatn_lvt
+ wa0=2.7276085e-007        pa0=-1.8825018e-013       ags=0.87073542
+ lags=2.8588999e-007       wags=-6.4973688e-009      pags=6.752318e-014
+ a1=0                      a2=1                      b0=0
+ b1=0                      keta=-0.042774949         lketa=-2.1168185e-008
+ wketa=1.5060023e-009      pketa=-4.277291e-015      dwg=0
+ dwb=0                     pclm=0.15326923           wpclm=2.3505577e-008
+ ppclm=0+dppclmn_lvt       pdiblc1=0                 pdiblc2=-1.2951573e-005
+ lpdiblc2=2.2859767e-010   wpdiblc2=5.5772323e-012   ppdiblc2=-5.5549234e-017
+ pdiblcb=0                 drout=0                   pvag=0.5
+ delta=0.0038668269        ldelta=1.2914481e-008     wdelta=1.330202e-009
+ pdelta=-1.5430343e-015    pscbe1=9.264e008          pscbe2=1e-020
+ fprout=305.78147          lfprout=-0.0001227065     wfprout=-5.3208079e-005
+ pfprout=6.1721371e-011    pdits=0                   pditsd=0
+ pditsl=0                  rdsw=140+drdswn_lvt       prwg=0
+ prwb=0                    wr=1                      alpha0=0
+ agidl=1.685e-007          bgidl=2.069e009           cgidl=0.375
+ egidl=0.779               aigbacc=0.01256           bigbacc=0.004998
+ cigbacc=0.07068           nigbacc=3.567             aigbinv=0.35
+ bigbinv=0.03              cigbinv=0.006             eigbinv=1.1
+ nigbinv=1                 aigc=0.0102               bigc=0.001561
+ cigc=0                    aigsd=0.00852             bigsd=0.0004929
+ cigsd=0.001386            nigc=1                    poxedge=1
+ pigcd=2.3                 ntox=ntoxn_lvt            xrcrg1=12
+ xrcrg2=1                  cgso=cgon_lvt             cgdo=cgon_lvt
+ cgbo=0                    cgdl=cgln_lvt             cgsl=cgln_lvt
+ clc=1e-007                cle=0.6                   cf=cfn_lvt
+ ckappas=0.6               kt1=-0.18815352           lkt1=-8.2307281e-008
+ wkt1=-7.6858963e-009      pkt1=1.802264e-014        kt1l=0
+ kt2=-0.029182247          lkt2=-6.8020507e-008      wkt2=-3.7562339e-009
+ pkt2=1.6528983e-014       ute=-1.8700572            lute=-2.5597688e-007
+ wute=-2.4702224e-009      pute=1.1356732e-013       ua1=6.6930855e-010
+ lua1=-2.4186411e-016      wua1=1.0019444e-016       pua1=6.4190226e-024
+ ub1=-1.4007533e-018       lub1=8.2203258e-026       wub1=-3.3079398e-025
+ pub1=2.5120598e-031       uc1=-1.9431123e-010       luc1=3.1078338e-016
+ wuc1=3.9184865e-019       puc1=-4.7448304e-023      prt=0
+ at=277774.59              lat=-0.077434873          wat=-0.00030364932
+ pat=3.0243472e-009        njs=1                     ijthsfwd=0.01
+ ijthsrev=0.01             bvs=10                    xjbvs=1
+ cjs=cjn_lvt               cjsws=cjswn_lvt           cjswgs=cjswgn_lvt
+ xtis=3                    dmcg=9.25e-008            dmci=9.25e-008
+ dmdg=0                    dmcgt=0                   dwj=0
+ xgw=0                     xgl=0                     rshg=0.1
+ gbmin=1e-012              rbpb=50                   rbpd=50
+ rbps=50                   rbdb=50                   rbsb=50
+ igbmod=1                  igcmod=1                  rsh=10.5
+ voffcv=-0.05472           noff=1.686                moin=12.6
+ acde=1.2                  dlc=1.25e-008             beta0=5.8
+ alpha1=0.01               jswgs=9e-12               jsws=3.4e-13
+ jss=1.93e-07              tpbswg=3.00e-03           tcjswg=2.26e-03
+ tpbsw=1.90e-03            tcjsw=3.7e-04             tpb=1.20e-03
+ tcj=7.60e-04              pbswgs=0.78               pbsws=0.8
+ pbs=0.5                   mjswgs=0.52               mjsws=0.01
+ mjs=0.25                  ngcon=1                   saref=0.63e-6
+ sbref=0.63e-6             kvsat=0.3                 wlod=0.8e-6
+ tku0=0.01                 ku0=-6.86e-8              llodku0=1
+ wlodku0=1                 lku0=3.227e-7             wku0=8e-7
+ pku0=-1.7e-13             kvth0=3.5e-9              stk2=1.35e-9
+ steta0=0                  lkvth0=-2.68e-11          wkvth0=1.5e-6
+ pkvth0=0                  llodvth=1                 wlodvth=1
+ lodk2=0.5                 lodeta0=1                 fnoimod=1
+ tnoimod=0                 noia=3.39e41              noib=2.01e24
+ noic=8.75                 wpemod=wpeflag_lvt        kvth0we=0.00323
+ lkvth0we=0                wkvth0we=0                pkvth0we=0
+ ku0we=-0.003              lku0we=3.00e-10           wku0we=0
+ pku0we=0                  k2we=0.0015               wk2we=0
+ web=-210                  wec=-3500                 scref=1.00e-06
+ ud=0                      em=2.92e06                ef=0.89
+ minr=1e-3

     18: type=n
+ lmin=5.0000e-07-dxln_lvt  lmax=1.2000e-06-dxln_lvt  wmin=2.4000e-07-dxwn_lvt
+ wmax=5.0000e-07-dxwn_lvt  version=4.5               binunit=2
+ paramchk=1                mobmod=0                  capmod=2
+ diomod=1                  rdsmod=0                  rbodymod=0
+ rgatemod=0                permod=1                  acnqsmod=0
+ trnqsmod=0                tnom=25                   toxe=toxn_lvt
+ toxm=toxn_lvt             dtox=3.8e-010             epsrox=3.9
+ wint=6e-009               lint=2.5e-009             ll=0
+ wl=0                      lln=1                     wln=1
+ lw=0                      ww=0                      lwn=1
+ wwn=1                     lwl=0                     wwl=0
+ llc=0                     wlc=0                     lwc=0
+ wwc=0                     lwlc=0                    wwlc=0
+ dwc=0                     xpart=1                   toxref=3e-009
+ dlcig=2.5e-009            xl=-3.5e-08+dxln_lvt      xw=1.5e-8+dxwn_lvt
+ vth0=0.22806692+dvthn_lvt lvth0=1.1923908e-008+dlvthn_lvt
+ wvth0=-2.5386023e-009+dwvthn_lvt                    pvth0=-2.5085152e-015+dpvthn_lvt
+ k1=0.27                   k2=0.020215267+dk2n_lvt   lk2=-8.5283617e-009
+ wk2=-2.4823098e-009       pk2=2.0723919e-015        k3=-2.7
+ k3b=1.2                   w0=0                      dvt0=20
+ dvt1=1.5                  dvt2=0                    dvt0w=0
+ dvt1w=0                   dvt2w=0                   dsub=0.5+ddsubn_lvt
+ minv=0                    voffl=0                   dvtp0=2e-007
+ dvtp1=1                   lpe0=1.5e-008             lpeb=0
+ xj=1.5e-007               ngate=1.5e020             ndep=8.3687e017
+ nsd=1e020                 phin=0                    cdsc=0
+ cdscb=0                   cdscd=0                   lcdscd=0+dlcdscdn_lvt
+ cit=0                     voff=-0.096065868         lvoff=-1.0300239e-008+dlvoffn_lvt
+ lcit=0+dlcitn_lvt         wvoff=-6.7185655e-009     pvoff=1.576781e-015+dpvoffn_lvt
+ nfactor=1.0681269         wnfactor=-1.9321584e-007  eta0=0.25934615+deta0n_lvt
+ peta0=0+dpeta0n_lvt       weta0=-4.7011154e-009     etab=-0.040176923
+ wetab=-8.4620077e-009     u0=0.032377188            lu0=-4.9701029e-010
+ wu0=-2.0559992e-009       pu0=3.7269368e-016        ua=-4.8178795e-010
+ lua=-1.2339622e-016       wua=-1.3786724e-016       pua=2.072351e-023
+ ub=1.5353919e-018         lub=-2.2005708e-027       wub=1.3522799e-025
+ pub=-1.4654566e-032       uc=5.5569278e-011         luc=1.4201647e-017
+ wuc=1.1258365e-017        puc=-3.4510002e-024       vsat=118000
+ a0=2.9429538              lvsat=0+dlvsatn_lvt       pvsat=0+dpvsatn_lvt
+ la0=-1.0006026e-006       wa0=-4.2444356e-008       pa0=1.7738786e-013
+ ags=1.1171923             wags=5.1712269e-008       a1=0
+ a2=1                      b0=0                      b1=0
+ keta=-0.087337103         lketa=3.0523914e-008      wketa=1.0192018e-009
+ pketa=-3.7126025e-015     dwg=0                     dwb=0
+ pclm=0.15326923           wpclm=2.3505577e-008      pdiblc1=0
+ ppclm=0+dppclmn_lvt       pdiblc2=-0.00084337802    lpdiblc2=1.1918924e-009
+ wpdiblc2=1.7703057e-010   ppdiblc2=-2.5443511e-016  pdiblcb=0
+ drout=0                   pvag=0.5                  delta=0.021356593
+ ldelta=-7.3736484e-009    wdelta=-1.5446522e-009    pdelta=1.7917965e-015
+ pscbe1=9.264e008          pscbe2=1e-020             fprout=200
+ pdits=0                   pditsd=0                  pditsl=0
+ rdsw=140+drdswn_lvt       prwg=0                    prwb=0
+ wr=1                      alpha0=0                  agidl=1.685e-007
+ bgidl=2.069e009           cgidl=0.375               egidl=0.779
+ aigbacc=0.01256           bigbacc=0.004998          cigbacc=0.07068
+ nigbacc=3.567             aigbinv=0.35              bigbinv=0.03
+ cigbinv=0.006             eigbinv=1.1               nigbinv=1
+ aigc=0.0102               bigc=0.001561             cigc=0
+ aigsd=0.00852             bigsd=0.0004929           cigsd=0.001386
+ nigc=1                    poxedge=1                 pigcd=2.3
+ ntox=ntoxn_lvt            xrcrg1=12                 xrcrg2=1
+ cgso=cgon_lvt             cgdo=cgon_lvt             cgbo=0
+ cgdl=cgln_lvt             cgsl=cgln_lvt             clc=1e-007
+ cle=0.6                   cf=cfn_lvt                ckappas=0.6
+ kt1=-0.26282574           lkt1=4.3124848e-009       wkt1=1.0414985e-008
+ pkt1=-2.9743823e-015      kt1l=0                    kt2=-0.11619645
+ lkt2=3.2915966e-008       wkt2=1.7388217e-008       pkt2=-7.9985798e-015
+ ute=-2.0942325            lute=4.0665011e-009       wute=7.967719e-008
+ pute=1.8276325e-014       ua1=5.2903993e-010        lua1=-7.9152524e-017
+ wua1=7.1405913e-017       pua1=3.9813719e-023       ub1=-1.3216211e-018
+ lub1=-9.5901407e-027      wub1=-1.2566753e-025      pub1=1.3259294e-032
+ uc1=2.6535419e-010        luc1=-2.2242851e-016      wuc1=-9.1721716e-017
+ puc1=5.9403431e-023       prt=0                     at=292240.21
+ lat=-0.094214996          wat=0.0018092578          pat=5.733749e-010
+ njs=1                     ijthsfwd=0.01             ijthsrev=0.01
+ bvs=10                    xjbvs=1                   cjs=cjn_lvt
+ cjsws=cjswn_lvt           cjswgs=cjswgn_lvt         xtis=3
+ dmcg=9.25e-008            dmci=9.25e-008            dmdg=0
+ dmcgt=0                   dwj=0                     xgw=0
+ xgl=0                     rshg=0.1                  gbmin=1e-012
+ rbpb=50                   rbpd=50                   rbps=50
+ rbdb=50                   rbsb=50                   igbmod=1
+ igcmod=1                  rsh=10.5                  voffcv=-0.05472
+ noff=1.686                moin=12.6                 acde=1.2
+ dlc=1.25e-008             beta0=5.8                 alpha1=0.01
+ jswgs=9e-12               jsws=3.4e-13              jss=1.93e-07
+ tpbswg=3.00e-03           tcjswg=2.26e-03           tpbsw=1.90e-03
+ tcjsw=3.7e-04             tpb=1.20e-03              tcj=7.60e-04
+ pbswgs=0.78               pbsws=0.8                 pbs=0.5
+ mjswgs=0.52               mjsws=0.01                mjs=0.25
+ ngcon=1                   saref=0.63e-6             sbref=0.63e-6
+ kvsat=0.3                 wlod=0.8e-6               tku0=0.01
+ ku0=-6.86e-8              llodku0=1                 wlodku0=1
+ lku0=3.227e-7             wku0=8e-7                 pku0=-1.7e-13
+ kvth0=3.5e-9              stk2=1.35e-9              steta0=0
+ lkvth0=-2.68e-11          wkvth0=1.5e-6             pkvth0=0
+ llodvth=1                 wlodvth=1                 lodk2=0.5
+ lodeta0=1                 fnoimod=1                 tnoimod=0
+ noia=3.39e41              noib=2.01e24              noic=8.75
+ wpemod=wpeflag_lvt        kvth0we=0.00323           lkvth0we=0
+ wkvth0we=0                pkvth0we=0                ku0we=-0.003
+ lku0we=3.00e-10           wku0we=0                  pku0we=0
+ k2we=0.0015               wk2we=0                   web=-210
+ wec=-3500                 scref=1.00e-06            ud=0
+ em=2.92e06                ef=0.89                   minr=1e-3

     19: type=n
+ lmin=2.4000e-07-dxln_lvt  lmax=5.0000e-07-dxln_lvt  wmin=2.4000e-07-dxwn_lvt
+ wmax=5.0000e-07-dxwn_lvt  version=4.5               binunit=2
+ paramchk=1                mobmod=0                  capmod=2
+ diomod=1                  rdsmod=0                  rbodymod=0
+ rgatemod=0                permod=1                  acnqsmod=0
+ trnqsmod=0                tnom=25                   toxe=toxn_lvt
+ toxm=toxn_lvt             dtox=3.8e-010             epsrox=3.9
+ wint=6e-009               lint=2.5e-009             ll=0
+ wl=0                      lln=1                     wln=1
+ lw=0                      ww=0                      lwn=1
+ wwn=1                     lwl=0                     wwl=0
+ llc=0                     wlc=0                     lwc=0
+ wwc=0                     lwlc=0                    wwlc=0
+ dwc=0                     xpart=1                   toxref=3e-009
+ dlcig=2.5e-009            xl=-3.5e-08+dxln_lvt      xw=1.5e-8+dxwn_lvt
+ vth0=0.26510089+dvthn_lvt lvth0=-5.111716e-009+dlvthn_lvt
+ wvth0=-1.1608139e-008+dwvthn_lvt                    pvth0=1.6634716e-015+dpvthn_lvt
+ k1=0.27                   k2=-0.0054421056+dk2n_lvt lk2=3.2740296e-009
+ wk2=5.6029701e-009        pk2=-1.6468369e-015       k3=-2.7
+ k3b=1.2                   w0=0                      dvt0=20
+ dvt1=1.5                  dvt2=0                    dvt0w=0
+ dvt1w=0                   dvt2w=0                   dsub=0.5+ddsubn_lvt
+ minv=0                    voffl=0                   dvtp0=2e-007
+ dvtp1=1                   lpe0=1.5e-008             lpeb=0
+ xj=1.5e-007               ngate=1.5e020             ndep=8.3687e017
+ nsd=1e020                 phin=0                    cdsc=0
+ cdscb=0                   cdscd=0                   lcdscd=0+dlcdscdn_lvt
+ cit=0                     voff=-0.11328876          lvoff=-2.3777101e-009+dlvoffn_lvt
+ lcit=0+dlcitn_lvt         wvoff=-3.1822935e-009     pvoff=-4.9904148e-017+dpvoffn_lvt
+ nfactor=1.2484908         lnfactor=-8.2967396e-008  wnfactor=-2.5143735e-007
+ pnfactor=2.6781893e-014   eta0=0.25934615+deta0n_lvt
+ peta0=0+dpeta0n_lvt       weta0=-4.7011154e-009     etab=-0.040176923
+ wetab=-8.4620077e-009     u0=0.027441524            lu0=1.7733953e-009
+ wu0=-3.7066487e-010       pu0=-4.0256013e-016       ua=-6.1544462e-010
+ lua=-6.1914153e-017       wua=-1.3094373e-016       pua=1.7538693e-023
+ ub=1.3376705e-018         lub=8.8751289e-026        wub=1.52871e-025
+ pub=-2.2770348e-032       uc=5.1393222e-011         luc=1.6122633e-017
+ wuc=1.4463886e-017        puc=-4.9255394e-024       vsat=118000
+ a0=-0.50965976            lvsat=0+dlvsatn_lvt       pvsat=0+dpvsatn_lvt
+ la0=5.8759964e-007        wa0=8.1546271e-007        pa0=-2.1724939e-013
+ ags=1.6822479             lags=-2.5992559e-007      wags=1.2345852e-007
+ pags=-3.3003276e-014      a1=0                      a2=1
+ b0=0                      b1=0                      keta=-0.046897633
+ lketa=1.1921757e-008      wketa=-3.6885675e-009     pketa=-1.5470286e-015
+ dwg=0                     dwb=0                     pclm=0.078860947
+ lpclm=3.4227811e-008      wpclm=4.158679e-008       ppclm=-8.317358e-015+dppclmn_lvt
+ pdiblc1=0                 pdiblc2=-0.00065349112    lpdiblc2=1.1045444e-009
+ wpdiblc2=5.7859882e-011   ppdiblc2=-1.9961659e-016  pdiblcb=0
+ drout=0                   pvag=0.32026627           lpvag=8.2677515e-008
+ wpvag=9.0406065e-008      ppvag=-4.158679e-014      delta=-0.0021139053
+ ldelta=3.4227811e-009     wdelta=4.158679e-009      pdelta=-8.317358e-016
+ pscbe1=9.264e008          pscbe2=1e-020             fprout=200
+ pdits=0                   pditsd=0                  pditsl=0
+ rdsw=140+drdswn_lvt       prwg=0                    prwb=0
+ wr=1                      alpha0=0                  agidl=1.685e-007
+ bgidl=2.069e009           cgidl=0.375               egidl=0.779
+ aigbacc=0.01256           bigbacc=0.004998          cigbacc=0.07068
+ nigbacc=3.567             aigbinv=0.35              bigbinv=0.03
+ cigbinv=0.006             eigbinv=1.1               nigbinv=1
+ aigc=0.0102               bigc=0.001561             cigc=0
+ aigsd=0.00852             bigsd=0.0004929           cigsd=0.001386
+ nigc=1                    poxedge=1                 pigcd=2.3
+ ntox=ntoxn_lvt            xrcrg1=12                 xrcrg2=1
+ cgso=cgon_lvt             cgdo=cgon_lvt             cgbo=0
+ cgdl=cgln_lvt             cgsl=cgln_lvt             clc=1e-007
+ cle=0.6                   cf=cfn_lvt                ckappas=0.6
+ kt1=-0.22840166           lkt1=-1.1522592e-008      wkt1=9.8361799e-010
+ pkt1=1.3640467e-015       kt1l=0                    kt2=-0.04464
+ ute=-2.323626             lute=1.0958751e-007       wute=2.427222e-007
+ pute=-5.6724381e-014      ua1=-2.4636095e-010       lua1=2.7753188e-016
+ wua1=4.6143256e-016       pua1=-1.3959854e-022      ub1=-9.8086568e-019
+ lub1=-1.6633763e-025      wub1=-2.8995033e-025      pub1=8.8829383e-032
+ uc1=-3.4170483e-010       luc1=5.6818642e-017       wuc1=6.875092e-017
+ puc1=-1.4413981e-023      prt=0                     at=120059.62
+ lat=-0.015011923          wat=0.0054062827          pat=-1.0812565e-009
+ njs=1                     ijthsfwd=0.01             ijthsrev=0.01
+ bvs=10                    xjbvs=1                   cjs=cjn_lvt
+ cjsws=cjswn_lvt           cjswgs=cjswgn_lvt         xtis=3
+ dmcg=9.25e-008            dmci=9.25e-008            dmdg=0
+ dmcgt=0                   dwj=0                     xgw=0
+ xgl=0                     rshg=0.1                  gbmin=1e-012
+ rbpb=50                   rbpd=50                   rbps=50
+ rbdb=50                   rbsb=50                   igbmod=1
+ igcmod=1                  rsh=10.5                  voffcv=-0.05472
+ noff=1.686                moin=12.6                 acde=1.2
+ dlc=1.25e-008             beta0=5.8                 alpha1=0.01
+ jswgs=9e-12               jsws=3.4e-13              jss=1.93e-07
+ tpbswg=3.00e-03           tcjswg=2.26e-03           tpbsw=1.90e-03
+ tcjsw=3.7e-04             tpb=1.20e-03              tcj=7.60e-04
+ pbswgs=0.78               pbsws=0.8                 pbs=0.5
+ mjswgs=0.52               mjsws=0.01                mjs=0.25
+ ngcon=1                   saref=0.63e-6             sbref=0.63e-6
+ kvsat=0.3                 wlod=0.8e-6               tku0=0.01
+ ku0=-6.86e-8              llodku0=1                 wlodku0=1
+ lku0=3.227e-7             wku0=8e-7                 pku0=-1.7e-13
+ kvth0=3.5e-9              stk2=1.35e-9              steta0=0
+ lkvth0=-2.68e-11          wkvth0=1.5e-6             pkvth0=0
+ llodvth=1                 wlodvth=1                 lodk2=0.5
+ lodeta0=1                 fnoimod=1                 tnoimod=0
+ noia=3.39e41              noib=2.01e24              noic=8.75
+ wpemod=wpeflag_lvt        kvth0we=0.00323           lkvth0we=0
+ wkvth0we=0                pkvth0we=0                ku0we=-0.003
+ lku0we=3.00e-10           wku0we=0                  pku0we=0
+ k2we=0.0015               wk2we=0                   web=-210
+ wec=-3500                 scref=1.00e-06            ud=0
+ em=2.92e06                ef=0.89                   minr=1e-3

     20: type=n
+ lmin=1.0e-07              lmax=2.4000e-07-dxln_lvt  wmin=2.4000e-07-dxwn_lvt
+ wmax=5.0000e-07-dxwn_lvt  version=4.5               binunit=2
+ paramchk=1                mobmod=0                  capmod=2
+ diomod=1                  rdsmod=0                  rbodymod=0
+ rgatemod=0                permod=1                  acnqsmod=0
+ trnqsmod=0                tnom=25                   toxe=toxn_lvt
+ toxm=toxn_lvt             dtox=3.8e-010             epsrox=3.9
+ wint=6e-009               lint=2.5e-009             ll=0
+ wl=0                      lln=1                     wln=1
+ lw=0                      ww=0                      lwn=1
+ wwn=1                     lwl=0                     wwl=0
+ llc=0                     wlc=0                     lwc=0
+ wwc=0                     lwlc=0                    wwlc=0
+ dwc=0                     xpart=1                   toxref=3e-009
+ dlcig=2.5e-009            xl=-3.5e-08+dxln_lvt      xw=1.5e-8+dxwn_lvt
+ vth0=0.22970824+dvthn_lvt lvth0=1.9668132e-009+dlvthn_lvt
+ wvth0=-1.276017e-009+dwvthn_lvt                     pvth0=-4.0295275e-016+dpvthn_lvt
+ k1=0.27                   k2=0.0073584824+dk2n_lvt  lk2=7.1391198e-010
+ wk2=-2.1535138e-009       pk2=-9.5540096e-017       k3=-2.7
+ k3b=1.2                   w0=0                      dvt0=20
+ dvt1=1.5                  dvt2=0                    dvt0w=0
+ dvt1w=0                   dvt2w=0                   dsub=0.5+ddsubn_lvt
+ minv=0                    voffl=0                   dvtp0=2e-007
+ dvtp1=1                   lpe0=1.5e-008             lpeb=0
+ xj=1.5e-007               ngate=1.5e020             ndep=8.3687e017
+ nsd=1e020                 phin=0                    cdsc=0
+ cdscb=0                   cdscd=0                   lcdscd=0+dlcdscdn_lvt
+ cit=0                     voff=-0.10320462          lvoff=-4.3945385e-009+dlvoffn_lvt
+ lcit=0+dlcitn_lvt         wvoff=-5.9905642e-009     pvoff=5.1174999e-016+dpvoffn_lvt
+ nfactor=0.56489011        lnfactor=5.3752747e-008   wnfactor=-4.7011154e-008
+ pnfactor=-1.4103346e-014  eta0=0.25934615+deta0n_lvt
+ peta0=0+dpeta0n_lvt       weta0=-4.7011154e-009     etab=-0.040176923
+ wetab=-8.4620077e-009     u0=0.040539802            lu0=-8.4626044e-010
+ wu0=-2.6514291e-009       pu0=5.3592715e-017        ua=-9.4222747e-010
+ lua=3.4424176e-018        wua=2.4042847e-017        pua=-1.3458622e-023
+ ub=1.9895363e-018         lub=-4.1621868e-026       wub=-1.1551312e-026
+ pub=1.0114114e-032        uc=1.4968179e-010         luc=-3.5350813e-018
+ wuc=-1.0155752e-017       puc=-1.611811e-027        vsat=118000
+ a0=4.9105484              lvsat=0+dlvsatn_lvt       pvsat=0+dpvsatn_lvt
+ la0=-4.9644198e-007       wa0=-1.322088e-006        pa0=2.1026074e-013
+ ags=1.231556              lags=-1.6978721e-007      wags=-6.1947269e-007
+ pags=1.1558297e-013       a1=0                      a2=1
+ b0=0                      b1=0                      keta=0.025949643
+ lketa=-2.6476978e-009     wketa=-2.2394099e-008     pketa=2.1940777e-015
+ dwg=0                     dwb=0                     pclm=0.25
+ ppclm=0+dppclmn_lvt       pdiblc1=0                 pdiblc2=0.0035554945
+ lpdiblc2=2.6274725e-010   wpdiblc2=-1.1416995e-009  ppdiblc2=4.0295275e-017
+ pdiblcb=0                 drout=0                   pvag=0.83379121
+ lpvag=-2.0027473e-008     wpvag=-1.6789698e-007     ppvag=1.0073819e-014
+ delta=0.015               pscbe1=9.264e008          pscbe2=1e-020
+ fprout=200                pdits=0                   pditsd=0
+ pditsl=0                  rdsw=140+drdswn_lvt       prwg=0
+ prwb=0                    wr=1                      alpha0=0
+ agidl=1.685e-007          bgidl=2.069e009           cgidl=0.375
+ egidl=0.779               aigbacc=0.01256           bigbacc=0.004998
+ cigbacc=0.07068           nigbacc=3.567             aigbinv=0.35
+ bigbinv=0.03              cigbinv=0.006             eigbinv=1.1
+ nigbinv=1                 aigc=0.0102               bigc=0.001561
+ cigc=0                    aigsd=0.00852             bigsd=0.0004929
+ cigsd=0.001386            nigc=1                    poxedge=1
+ pigcd=2.3                 ntox=ntoxn_lvt            xrcrg1=12
+ xrcrg2=1                  cgso=cgon_lvt             cgdo=cgon_lvt
+ cgbo=0                    cgdl=cgln_lvt             cgsl=cgln_lvt
+ clc=1e-007                cle=0.6                   cf=cfn_lvt
+ ckappas=0.6               kt1=-0.27688374           lkt1=-1.8261758e-009
+ wkt1=9.0530051e-009       pkt1=-2.498307e-016       kt1l=0
+ kt2=-0.053356253          lkt2=1.7432505e-009       wkt2=1.978498e-009
+ pkt2=-3.956996e-016       ute=-1.6110626            lute=-3.2925165e-008
+ wute=-7.1322636e-008      pute=6.0845865e-015       ua1=1.8174037e-009
+ lua1=-1.3522104e-016      wua1=-3.4848025e-016      pua1=2.2384025e-023
+ ub1=-2.3879823e-018       lub1=1.150857e-025        wub1=1.7596208e-025
+ pub1=-4.3530985e-033      uc1=-5.4783736e-011       luc1=-5.6557582e-019
+ wuc1=-4.7414107e-018      puc1=2.8448464e-025       prt=0
+ at=37784.918              lat=0.0014430165          wat=0.00081597931
+ pat=-1.6319586e-010       njs=1                     ijthsfwd=0.01
+ ijthsrev=0.01             bvs=10                    xjbvs=1
+ cjs=cjn_lvt               cjsws=cjswn_lvt           cjswgs=cjswgn_lvt
+ xtis=3                    dmcg=9.25e-008            dmci=9.25e-008
+ dmdg=0                    dmcgt=0                   dwj=0
+ xgw=0                     xgl=0                     rshg=0.1
+ gbmin=1e-012              rbpb=50                   rbpd=50
+ rbps=50                   rbdb=50                   rbsb=50
+ igbmod=1                  igcmod=1                  rsh=10.5
+ voffcv=-0.05472           noff=1.686                moin=12.6
+ acde=1.2                  dlc=1.25e-008             beta0=5.8
+ alpha1=0.01               jswgs=9e-12               jsws=3.4e-13
+ jss=1.93e-07              tpbswg=3.00e-03           tcjswg=2.26e-03
+ tpbsw=1.90e-03            tcjsw=3.7e-04             tpb=1.20e-03
+ tcj=7.60e-04              pbswgs=0.78               pbsws=0.8
+ pbs=0.5                   mjswgs=0.52               mjsws=0.01
+ mjs=0.25                  ngcon=1                   saref=0.63e-6
+ sbref=0.63e-6             kvsat=0.3                 wlod=0.8e-6
+ tku0=0.01                 ku0=-6.86e-8              llodku0=1
+ wlodku0=1                 lku0=3.227e-7             wku0=8e-7
+ pku0=-1.7e-13             kvth0=3.5e-9              stk2=1.35e-9
+ steta0=0                  lkvth0=-2.68e-11          wkvth0=1.5e-6
+ pkvth0=0                  llodvth=1                 wlodvth=1
+ lodk2=0.5                 lodeta0=1                 fnoimod=1
+ tnoimod=0                 noia=3.39e41              noib=2.01e24
+ noic=8.75                 wpemod=wpeflag_lvt        kvth0we=0.00323
+ lkvth0we=0                wkvth0we=0                pkvth0we=0
+ ku0we=-0.003              lku0we=3.00e-10           wku0we=0
+ pku0we=0                  k2we=0.0015               wk2we=0
+ web=-210                  wec=-3500                 scref=1.00e-06
+ ud=0                      em=2.92e06                ef=0.89
+ minr=1e-3

     21: type=n
+ lmin=1.0000e-05-dxln_lvt  lmax=2.001e-05            wmin=1.2e-07
+ wmax=2.4000e-07-dxwn_lvt  version=4.5               binunit=2
+ paramchk=1                mobmod=0                  capmod=2
+ diomod=1                  rdsmod=0                  rbodymod=0
+ rgatemod=0                permod=1                  acnqsmod=0
+ trnqsmod=0                tnom=25                   toxe=toxn_lvt
+ toxm=toxn_lvt             dtox=3.8e-010             epsrox=3.9
+ wint=6e-009               lint=2.5e-009             ll=0
+ wl=0                      lln=1                     wln=1
+ lw=0                      ww=0                      lwn=1
+ wwn=1                     lwl=0                     wwl=0
+ llc=0                     wlc=0                     lwc=0
+ wwc=0                     lwlc=0                    wwlc=0
+ dwc=0                     xpart=1                   toxref=3e-009
+ dlcig=2.5e-009            xl=-3.5e-08+dxln_lvt      xw=1.5e-8+dxwn_lvt
+ vth0=0.2424725+dvthn_lvt  wvth0=-6.7001175e-009+dwvthn_lvt
+ lvth0=0+dlvthn_lvt        pvth0=0+dpvthn_lvt        k1=0.27
+ k2=0.0210349+dk2n_lvt     wk2=-1.7823807e-009       k3=-2.7
+ k3b=1.2                   w0=0                      dvt0=20
+ dvt1=1.5                  dvt2=0                    dvt0w=0
+ dvt1w=0                   dvt2w=0                   dsub=0.5+ddsubn_lvt
+ minv=0                    voffl=0                   dvtp0=2e-007
+ dvtp1=1                   lpe0=1.5e-008             lpeb=0
+ xj=1.5e-007               ngate=1.5e020             ndep=8.3687e017
+ nsd=1e020                 phin=0                    cdsc=0
+ cdscb=0                   cdscd=0                   lcdscd=0+dlcdscdn_lvt
+ cit=0                     voff=-0.13736             wvoff=5.57928e-009
+ pvoff=0+dpvoffn_lvt       lvoff=0+dlvoffn_lvt       lcit=0+dlcitn_lvt
+ nfactor=0.0975            wnfactor=2.49075e-008     eta0=0.363+deta0n_lvt
+ peta0=0+dpeta0n_lvt       weta0=-2.9889e-008        etab=-0.14571375
+ wetab=8.6055412e-009      u0=0.0307255              wu0=-1.0510965e-009
+ ua=-6.3709137e-010        wua=-1.6726091e-017       ub=1.7393526e-018
+ wub=-4.4311688e-026       uc=1.117265e-010          wuc=-4.1495895e-018
+ vsat=118000               lvsat=0+dlvsatn_lvt       pvsat=0+dpvsatn_lvt
+ a0=2.676675               wa0=-4.6577025e-008       ags=1.054965
+ wags=-3.7510695e-008      a1=0                      a2=1
+ b0=0                      b1=0                      keta=-0.04646625
+ wketa=1.4570888e-009      dwg=0                     dwb=0
+ pclm=0.25                 pdiblc1=0                 pdiblc2=1e-005
+ ppclm=0+dppclmn_lvt       pdiblcb=0                 drout=0
+ pvag=0.5                  delta=0.01                pscbe1=9.264e008
+ pscbe2=1e-020             fprout=-2.5               wfprout=2.49075e-005
+ pdits=0                   pditsd=0                  pditsl=0
+ rdsw=140+drdswn_lvt       prwg=0                    prwb=0
+ wr=1                      alpha0=0                  agidl=1.685e-007
+ bgidl=2.069e009           cgidl=0.375               egidl=0.779
+ aigbacc=0.01256           bigbacc=0.004998          cigbacc=0.07068
+ nigbacc=3.567             aigbinv=0.35              bigbinv=0.03
+ cigbinv=0.006             eigbinv=1.1               nigbinv=1
+ aigc=0.0102               bigc=0.001561             cigc=0
+ aigsd=0.00852             bigsd=0.0004929           cigsd=0.001386
+ nigc=1                    poxedge=1                 pigcd=2.3
+ ntox=ntoxn_lvt            xrcrg1=12                 xrcrg2=1
+ cgso=cgon_lvt             cgdo=cgon_lvt             cgbo=0
+ cgdl=cgln_lvt             cgsl=cgln_lvt             clc=1e-007
+ cle=0.6                   cf=cfn_lvt                ckappas=0.6
+ kt1=-0.20994              wkt1=-2.59038e-009        kt1l=0
+ kt2=-0.04464              ute=-1.97995              wute=2.939085e-008
+ ua1=1.3762125e-009        wua1=-7.6839638e-017      ub1=-3.00875e-018
+ wub1=8.717625e-026        uc1=-2.8313875e-010       wuc1=2.4795416e-017
+ prt=0                     at=270000                 njs=1
+ ijthsfwd=0.01             ijthsrev=0.01             bvs=10
+ xjbvs=1                   cjs=cjn_lvt               cjsws=cjswn_lvt
+ cjswgs=cjswgn_lvt         xtis=3                    dmcg=9.25e-008
+ dmci=9.25e-008            dmdg=0                    dmcgt=0
+ dwj=0                     xgw=0                     xgl=0
+ rshg=0.1                  gbmin=1e-012              rbpb=50
+ rbpd=50                   rbps=50                   rbdb=50
+ rbsb=50                   igbmod=1                  igcmod=1
+ rsh=10.5                  voffcv=-0.05472           noff=1.686
+ moin=12.6                 acde=1.2                  dlc=1.25e-008
+ beta0=5.8                 alpha1=0.01               jswgs=9e-12
+ jsws=3.4e-13              jss=1.93e-07              tpbswg=3.00e-03
+ tcjswg=2.26e-03           tpbsw=1.90e-03            tcjsw=3.7e-04
+ tpb=1.20e-03              tcj=7.60e-04              pbswgs=0.78
+ pbsws=0.8                 pbs=0.5                   mjswgs=0.52
+ mjsws=0.01                mjs=0.25                  ngcon=1
+ saref=0.63e-6             sbref=0.63e-6             kvsat=0.3
+ wlod=0.8e-6               tku0=0.01                 ku0=-6.86e-8
+ llodku0=1                 wlodku0=1                 lku0=3.227e-7
+ wku0=8e-7                 pku0=-1.7e-13             kvth0=3.5e-9
+ stk2=1.35e-9              steta0=0                  lkvth0=-2.68e-11
+ wkvth0=1.5e-6             pkvth0=0                  llodvth=1
+ wlodvth=1                 lodk2=0.5                 lodeta0=1
+ fnoimod=1                 tnoimod=0                 noia=3.39e41
+ noib=2.01e24              noic=8.75                 wpemod=wpeflag_lvt
+ kvth0we=0.00323           lkvth0we=0                wkvth0we=0
+ pkvth0we=0                ku0we=-0.003              lku0we=3.00e-10
+ wku0we=0                  pku0we=0                  k2we=0.0015
+ wk2we=0                   web=-210                  wec=-3500
+ scref=1.00e-06            ud=0                      em=2.92e06
+ ef=0.89                   minr=1e-3

     22: type=n
+ lmin=1.2000e-06-dxln_lvt  lmax=1.0000e-05-dxln_lvt  wmin=1.2e-07
+ wmax=2.4000e-07-dxwn_lvt  version=4.5               binunit=2
+ paramchk=1                mobmod=0                  capmod=2
+ diomod=1                  rdsmod=0                  rbodymod=0
+ rgatemod=0                permod=1                  acnqsmod=0
+ trnqsmod=0                tnom=25                   toxe=toxn_lvt
+ toxm=toxn_lvt             dtox=3.8e-010             epsrox=3.9
+ wint=6e-009               lint=2.5e-009             ll=0
+ wl=0                      lln=1                     wln=1
+ lw=0                      ww=0                      lwn=1
+ wwn=1                     lwl=0                     wwl=0
+ llc=0                     wlc=0                     lwc=0
+ wwc=0                     lwlc=0                    wwlc=0
+ dwc=0                     xpart=1                   toxref=3e-009
+ dlcig=2.5e-009            xl=-3.5e-08+dxln_lvt      xw=1.5e-8+dxwn_lvt
+ vth0=0.24113488+dvthn_lvt lvth0=1.3322745e-008+dlvthn_lvt
+ wvth0=-6.5064051e-009+dwvthn_lvt                    pvth0=-1.9293757e-015+dpvthn_lvt
+ k1=0.27                   k2=0.021779073+dk2n_lvt   lk2=-7.4119626e-009
+ wk2=-1.844697e-009        pk2=6.2067035e-016        k3=-2.7
+ k3b=1.2                   w0=0                      dvt0=20
+ dvt1=1.5                  dvt2=0                    dvt0w=0
+ dvt1w=0                   dvt2w=0                   dsub=0.5+ddsubn_lvt
+ minv=0                    voffl=0                   dvtp0=2e-007
+ dvtp1=1                   lpe0=1.5e-008             lpeb=0
+ xj=1.5e-007               ngate=1.5e020             ndep=8.3687e017
+ nsd=1e020                 phin=0                    cdsc=0
+ cdscb=0                   cdscd=0                   lcdscd=0+dlcdscdn_lvt
+ cit=0                     voff=-0.13521268          lvoff=-2.1387289e-008+dlvoffn_lvt
+ lcit=0+dlcitn_lvt         wvoff=5.4610826e-009      pvoff=1.1772462e-015+dpvoffn_lvt
+ nfactor=0.078013977       lnfactor=1.9408079e-007   wnfactor=2.7304281e-008
+ pnfactor=-2.3871937e-014  eta0=0.363+deta0n_lvt     weta0=-2.9889e-008
+ etab=-0.15513644          peta0=0+dpeta0n_lvt       letab=9.3850024e-008
+ wetab=9.7645325e-009      petab=-1.1543553e-014     u0=0.031098578
+ lu0=-3.715861e-009        wu0=-1.090824e-009        pu0=3.9568553e-016
+ ua=-5.8438932e-010        lua=-5.2491239e-016       wua=-1.7486259e-017
+ pua=7.5712725e-024        ub=1.7087679e-018         lub=3.0462429e-025
+ wub=-5.2286894e-026       pub=7.9433052e-032        uc=1.1319746e-010
+ luc=-1.4650753e-017       wuc=-4.7392632e-018       puc=5.8731505e-024
+ vsat=118000               a0=2.7476393              lvsat=0+dlvsatn_lvt
+ pvsat=0+dpvsatn_lvt       la0=-7.0680461e-007       wa0=-6.5422945e-008
+ pa0=1.8770537e-013        ags=1.0160081             lags=3.8801059e-007
+ wags=-4.1798634e-008      pags=4.2707876e-014       a1=0
+ a2=1                      b0=0                      b1=0
+ keta=-0.047016195         lketa=5.4774567e-009      wketa=2.5366251e-009
+ pketa=-1.0752182e-014     dwg=0                     dwb=0
+ pclm=0.25                 ppclm=0+dppclmn_lvt       pdiblc1=0
+ pdiblc2=1e-005            pdiblcb=0                 drout=0
+ pvag=0.5                  delta=0.0093409091        ldelta=6.5645455e-009
+ pscbe1=9.264e008          pscbe2=1e-020             fprout=-29.193182
+ lfprout=0.00026586409     wfprout=2.8190761e-005    pfprout=-3.2701283e-011
+ pdits=0                   pditsd=0                  pditsl=0
+ rdsw=140+drdswn_lvt       prwg=0                    prwb=0
+ wr=1                      alpha0=0                  agidl=1.685e-007
+ bgidl=2.069e009           cgidl=0.375               egidl=0.779
+ aigbacc=0.01256           bigbacc=0.004998          cigbacc=0.07068
+ nigbacc=3.567             aigbinv=0.35              bigbinv=0.03
+ cigbinv=0.006             eigbinv=1.1               nigbinv=1
+ aigc=0.0102               bigc=0.001561             cigc=0
+ aigsd=0.00852             bigsd=0.0004929           cigsd=0.001386
+ nigc=1                    poxedge=1                 pigcd=2.3
+ ntox=ntoxn_lvt            xrcrg1=12                 xrcrg2=1
+ cgso=cgon_lvt             cgdo=cgon_lvt             cgbo=0
+ cgdl=cgln_lvt             cgsl=cgln_lvt             clc=1e-007
+ cle=0.6                   cf=cfn_lvt                ckappas=0.6
+ kt1=-0.20800128           lkt1=-1.930961e-008       wkt1=-2.8628907e-009
+ pkt1=2.7142065e-015       kt1l=0                    kt2=-0.043011881
+ lkt2=-1.6216068e-008      wkt2=-3.9563299e-010      pkt2=3.9405046e-015
+ ute=-1.9892827            lute=9.2953964e-008       wute=2.650158e-008
+ pute=2.8777129e-014       ua1=1.5176356e-009        lua1=-1.4085742e-015
+ wua1=-1.0594903e-016      pua1=2.8992958e-022       ub1=-3.2780677e-018
+ lub1=2.6824046e-024       wub1=1.2539341e-025       pub1=-3.8064294e-031
+ uc1=-3.0567218e-010       luc1=2.2443295e-016       wuc1=2.745256e-017
+ puc1=-2.6465148e-023      prt=0                     at=275187.38
+ lat=-0.051666255          wat=0.00032504288         pat=-3.237427e-009
+ njs=1                     ijthsfwd=0.01             ijthsrev=0.01
+ bvs=10                    xjbvs=1                   cjs=cjn_lvt
+ cjsws=cjswn_lvt           cjswgs=cjswgn_lvt         xtis=3
+ dmcg=9.25e-008            dmci=9.25e-008            dmdg=0
+ dmcgt=0                   dwj=0                     xgw=0
+ xgl=0                     rshg=0.1                  gbmin=1e-012
+ rbpb=50                   rbpd=50                   rbps=50
+ rbdb=50                   rbsb=50                   igbmod=1
+ igcmod=1                  rsh=10.5                  voffcv=-0.05472
+ noff=1.686                moin=12.6                 acde=1.2
+ dlc=1.25e-008             beta0=5.8                 alpha1=0.01
+ jswgs=9e-12               jsws=3.4e-13              jss=1.93e-07
+ tpbswg=3.00e-03           tcjswg=2.26e-03           tpbsw=1.90e-03
+ tcjsw=3.7e-04             tpb=1.20e-03              tcj=7.60e-04
+ pbswgs=0.78               pbsws=0.8                 pbs=0.5
+ mjswgs=0.52               mjsws=0.01                mjs=0.25
+ ngcon=1                   saref=0.63e-6             sbref=0.63e-6
+ kvsat=0.3                 wlod=0.8e-6               tku0=0.01
+ ku0=-6.86e-8              llodku0=1                 wlodku0=1
+ lku0=3.227e-7             wku0=8e-7                 pku0=-1.7e-13
+ kvth0=3.5e-9              stk2=1.35e-9              steta0=0
+ lkvth0=-2.68e-11          wkvth0=1.5e-6             pkvth0=0
+ llodvth=1                 wlodvth=1                 lodk2=0.5
+ lodeta0=1                 fnoimod=1                 tnoimod=0
+ noia=3.39e41              noib=2.01e24              noic=8.75
+ wpemod=wpeflag_lvt        kvth0we=0.00323           lkvth0we=0
+ wkvth0we=0                pkvth0we=0                ku0we=-0.003
+ lku0we=3.00e-10           wku0we=0                  pku0we=0
+ k2we=0.0015               wk2we=0                   web=-210
+ wec=-3500                 scref=1.00e-06            ud=0
+ em=2.92e06                ef=0.89                   minr=1e-3

     23: type=n
+ lmin=5.0000e-07-dxln_lvt  lmax=1.2000e-06-dxln_lvt  wmin=1.2e-07
+ wmax=2.4000e-07-dxwn_lvt  version=4.5               binunit=2
+ paramchk=1                mobmod=0                  capmod=2
+ diomod=1                  rdsmod=0                  rbodymod=0
+ rgatemod=0                permod=1                  acnqsmod=0
+ trnqsmod=0                tnom=25                   toxe=toxn_lvt
+ toxm=toxn_lvt             dtox=3.8e-010             epsrox=3.9
+ wint=6e-009               lint=2.5e-009             ll=0
+ wl=0                      lln=1                     wln=1
+ lw=0                      ww=0                      lwn=1
+ wwn=1                     lwl=0                     wwl=0
+ llc=0                     wlc=0                     lwc=0
+ wwc=0                     lwlc=0                    wwlc=0
+ dwc=0                     xpart=1                   toxref=3e-009
+ dlcig=2.5e-009            xl=-3.5e-08+dxln_lvt      xw=1.5e-8+dxwn_lvt
+ vth0=0.25440579+dvthn_lvt lvth0=-2.0715114e-009+dlvthn_lvt
+ wvth0=-8.9389459e-009+dwvthn_lvt                    pvth0=8.9237168e-016+dpvthn_lvt
+ k1=0.27                   k2=0.013856401+dk2n_lvt   lk2=1.7783363e-009
+ wk2=-9.3710555e-010       pk2=-4.3213573e-016       k3=-2.7
+ k3b=1.2                   w0=0                      dvt0=20
+ dvt1=1.5                  dvt2=0                    dvt0w=0
+ dvt1w=0                   dvt2w=0                   dsub=0.5+ddsubn_lvt
+ minv=0                    voffl=0                   dvtp0=2e-007
+ dvtp1=1                   lpe0=1.5e-008             lpeb=0
+ xj=1.5e-007               ngate=1.5e020             ndep=8.3687e017
+ nsd=1e020                 phin=0                    cdsc=0
+ cdscb=0                   cdscd=0                   lcdscd=0+dlcdscdn_lvt
+ cit=0                     voff=-0.15211557          lvoff=-1.7799371e-009+dlvoffn_lvt
+ lcit=0+dlcitn_lvt         wvoff=6.9015124e-009      pvoff=-4.9365242e-016+dpvoffn_lvt
+ nfactor=0.11061071        lnfactor=1.5626857e-007   wnfactor=3.9460596e-008
+ pnfactor=-3.7973263e-014  eta0=0.36636786+deta0n_lvt
+ leta0=-3.9067143e-009     weta0=-3.0707389e-008     peta0=9.4933157e-016+dpeta0n_lvt
+ etab=-0.07423125          wetab=-1.8680625e-010     u0=0.026556979
+ lu0=1.5523949e-009        wu0=-6.4168836e-010       pu0=-1.2531177e-016
+ ua=-1.1786896e-009        lua=1.6447588e-016        wua=3.1479848e-017
+ pua=-4.9229411e-023       ub=2.2375194e-018         lub=-3.0872755e-025
+ wub=-3.5388995e-026       pub=5.9831489e-032        uc=9.9422429e-011
+ luc=1.3282829e-018        wuc=6.0204986e-019        puc=-3.2277273e-025
+ vsat=118000               a0=2.7952871              la0=-7.6207609e-007
+ lvsat=0+dlvsatn_lvt       pvsat=0+dpvsatn_lvt       wa0=-6.5613471e-009
+ pa0=1.1942591e-013        ags=1.4798257             lags=-1.5001783e-007
+ wags=-3.6407649e-008      pags=3.6454332e-014       a1=0
+ a2=1                      b0=0                      b1=0
+ keta=-0.054797214         lketa=1.4503439e-008      wketa=-6.8879912e-009
+ pketa=1.80373e-016        dwg=0                     dwb=0
+ pclm=0.25                 pdiblc1=0                 ppclm=0+dppclmn_lvt
+ pdiblc2=0.0024447143      lpdiblc2=-2.8242686e-009  wpdiblc2=-6.2197586e-010
+ ppdiblc2=7.2149199e-016   pdiblcb=0                 drout=0
+ pvag=1.5103571            lpvag=-1.1720143e-006     wpvag=-2.4551679e-007
+ ppvag=2.8479947e-013      delta=0.015               pscbe1=9.264e008
+ pscbe2=1e-020             fprout=200                pdits=0
+ pditsd=0                  pditsl=0                  rdsw=140+drdswn_lvt
+ prwg=0                    prwb=0                    wr=1
+ alpha0=0                  agidl=1.685e-007          bgidl=2.069e009
+ cgidl=0.375               egidl=0.779               aigbacc=0.01256
+ bigbacc=0.004998          cigbacc=0.07068           nigbacc=3.567
+ aigbinv=0.35              bigbinv=0.03              cigbinv=0.006
+ eigbinv=1.1               nigbinv=1                 aigc=0.0102
+ bigc=0.001561             cigc=0                    aigsd=0.00852
+ bigsd=0.0004929           cigsd=0.001386            nigc=1
+ poxedge=1                 pigcd=2.3                 ntox=ntoxn_lvt
+ xrcrg1=12                 xrcrg2=1                  cgso=cgon_lvt
+ cgdo=cgon_lvt             cgbo=0                    cgdl=cgln_lvt
+ cgsl=cgln_lvt             clc=1e-007                cle=0.6
+ cf=cfn_lvt                ckappas=0.6               kt1=-0.22764736
+ lkt1=3.4798343e-009       wkt1=1.8666392e-009       pkt1=-2.7720482e-015
+ kt1l=0                    kt2=-0.063605721          lkt2=7.6727869e-009
+ wkt2=4.6086703e-009       pkt2=-1.8644872e-015      ute=-2.2105486
+ lute=3.4962234e-007       wute=1.0794199e-007       pute=-6.5693745e-014
+ ua1=-5.4588479e-010       lua1=9.8510945e-016       wua1=3.3261262e-016
+ pua1=-2.1880194e-022      ub1=-1.46965e-019         lub1=-9.496746e-025
+ wub1=-4.1110896e-025      pub1=2.4169982e-031       uc1=-1.2340718e-010
+ luc1=1.3005547e-017       wuc1=2.7472972e-018       puc1=2.1929559e-024
+ prt=0                     at=333677.64              lat=-0.11951497
+ wat=-0.0082600386         pat=6.7212675e-009        njs=1
+ ijthsfwd=0.01             ijthsrev=0.01             bvs=10
+ xjbvs=1                   cjs=cjn_lvt               cjsws=cjswn_lvt
+ cjswgs=cjswgn_lvt         xtis=3                    dmcg=9.25e-008
+ dmci=9.25e-008            dmdg=0                    dmcgt=0
+ dwj=0                     xgw=0                     xgl=0
+ rshg=0.1                  gbmin=1e-012              rbpb=50
+ rbpd=50                   rbps=50                   rbdb=50
+ rbsb=50                   igbmod=1                  igcmod=1
+ rsh=10.5                  voffcv=-0.05472           noff=1.686
+ moin=12.6                 acde=1.2                  dlc=1.25e-008
+ beta0=5.8                 alpha1=0.01               jswgs=9e-12
+ jsws=3.4e-13              jss=1.93e-07              tpbswg=3.00e-03
+ tcjswg=2.26e-03           tpbsw=1.90e-03            tcjsw=3.7e-04
+ tpb=1.20e-03              tcj=7.60e-04              pbswgs=0.78
+ pbsws=0.8                 pbs=0.5                   mjswgs=0.52
+ mjsws=0.01                mjs=0.25                  ngcon=1
+ saref=0.63e-6             sbref=0.63e-6             kvsat=0.3
+ wlod=0.8e-6               tku0=0.01                 ku0=-6.86e-8
+ llodku0=1                 wlodku0=1                 lku0=3.227e-7
+ wku0=8e-7                 pku0=-1.7e-13             kvth0=3.5e-9
+ stk2=1.35e-9              steta0=0                  lkvth0=-2.68e-11
+ wkvth0=1.5e-6             pkvth0=0                  llodvth=1
+ wlodvth=1                 lodk2=0.5                 lodeta0=1
+ fnoimod=1                 tnoimod=0                 noia=3.39e41
+ noib=2.01e24              noic=8.75                 wpemod=wpeflag_lvt
+ kvth0we=0.00323           lkvth0we=0                wkvth0we=0
+ pkvth0we=0                ku0we=-0.003              lku0we=3.00e-10
+ wku0we=0                  pku0we=0                  k2we=0.0015
+ wk2we=0                   web=-210                  wec=-3500
+ scref=1.00e-06            ud=0                      em=2.92e06
+ ef=0.89                   minr=1e-3

     24: type=n
+ lmin=2.4000e-07-dxln_lvt  lmax=5.0000e-07-dxln_lvt  wmin=1.2e-07
+ wmax=2.4000e-07-dxwn_lvt  version=4.5               binunit=2
+ paramchk=1                mobmod=0                  capmod=2
+ diomod=1                  rdsmod=0                  rbodymod=0
+ rgatemod=0                permod=1                  acnqsmod=0
+ trnqsmod=0                tnom=25                   toxe=toxn_lvt
+ toxm=toxn_lvt             dtox=3.8e-010             epsrox=3.9
+ wint=6e-009               lint=2.5e-009             ll=0
+ wl=0                      lln=1                     wln=1
+ lw=0                      ww=0                      lwn=1
+ wwn=1                     lwl=0                     wwl=0
+ llc=0                     wlc=0                     lwc=0
+ wwc=0                     lwlc=0                    wwlc=0
+ dwc=0                     xpart=1                   toxref=3e-009
+ dlcig=2.5e-009            xl=-3.5e-08+dxln_lvt      xw=1.5e-8+dxwn_lvt
+ vth0=0.2383275+dvthn_lvt  lvth0=5.3245e-009+dlvthn_lvt
+ wvth0=-5.1022056e-009+dwvthn_lvt                    pvth0=-8.7252888e-016+dpvthn_lvt
+ k1=0.27                   k2=0.0248891+dk2n_lvt     lk2=-3.296705e-009
+ wk2=-1.7675128e-009       pk2=-5.0148377e-017       k3=-2.7
+ k3b=1.2                   w0=0                      dvt0=20
+ dvt1=1.5                  dvt2=0                    dvt0w=0
+ dvt1w=0                   dvt2w=0                   dsub=0.5+ddsubn_lvt
+ minv=0                    voffl=0                   dvtp0=2e-007
+ dvtp1=1                   lpe0=1.5e-008             lpeb=0
+ xj=1.5e-007               ngate=1.5e020             ndep=8.3687e017
+ nsd=1e020                 phin=0                    cdsc=0
+ cdscb=0                   cdscd=0                   lcdscd=0+dlcdscdn_lvt
+ cit=0                     voff=-0.14532346          lvoff=-4.9043077e-009+dlvoffn_lvt
+ lcit=0+dlcitn_lvt         wvoff=4.6021396e-009      pvoff=5.6405908e-016+dpvoffn_lvt
+ nfactor=0.488075          lnfactor=-1.7365e-008     wnfactor=-6.6656302e-008
+ pnfactor=1.084051e-014    eta0=0.35393269+deta0n_lvt
+ leta0=1.8134615e-009      weta0=-2.7685644e-008     peta0=-4.4067115e-016+dpeta0n_lvt
+ etab=-0.07423125          wetab=-1.8680625e-010     u0=0.027446558
+ lu0=1.1431885e-009        wu0=-3.7188813e-010       pu0=-2.4941987e-016
+ ua=-1.0103704e-009        lua=8.7049085e-017        wua=-3.4976755e-017
+ pua=-1.8659374e-023       ub=1.5888707e-018         lub=-1.0349148e-026
+ wub=9.1829333e-026        pub=1.3110584e-033        uc=1.0290462e-010
+ luc=-2.7352308e-019       wuc=1.9466169e-018        puc=-9.4127358e-025
+ vsat=118000               a0=1.7156577              la0=-2.6544654e-007
+ lvsat=0+dlvsatn_lvt       pvsat=0+dpvsatn_lvt       wa0=2.7471057e-007
+ pa0=-9.9591681e-015       ags=2.5709769             lags=-6.5194738e-007
+ wags=-9.2502623e-008      pags=6.2258021e-014       a1=0
+ a2=1                      b0=0                      b1=0
+ keta=-0.030740308         lketa=3.4372615e-009      wketa=-7.6147975e-009
+ pketa=5.1470391e-016      dwg=0                     dwb=0
+ pclm=0.25                 pdiblc1=0                 ppclm=0+dppclmn_lvt
+ pdiblc2=-0.0049411538     lpdiblc2=5.7323077e-010   wpdiblc2=1.0997619e-009
+ ppdiblc2=-7.0507385e-017  pdiblcb=0                 drout=0
+ pvag=-1.8307692           lpvag=3.6490385e-007      wpvag=6.1310769e-007
+ ppvag=-1.1016779e-013     delta=0.015               pscbe1=9.264e008
+ pscbe2=1e-020             fprout=200                pdits=0
+ pditsd=0                  pditsl=0                  rdsw=140+drdswn_lvt
+ prwg=0                    prwb=0                    wr=1
+ alpha0=0                  agidl=1.685e-007          bgidl=2.069e009
+ cgidl=0.375               egidl=0.779               aigbacc=0.01256
+ bigbacc=0.004998          cigbacc=0.07068           nigbacc=3.567
+ aigbinv=0.35              bigbinv=0.03              cigbinv=0.006
+ eigbinv=1.1               nigbinv=1                 aigc=0.0102
+ bigc=0.001561             cigc=0                    aigsd=0.00852
+ bigsd=0.0004929           cigsd=0.001386            nigc=1
+ poxedge=1                 pigcd=2.3                 ntox=ntoxn_lvt
+ xrcrg1=12                 xrcrg2=1                  cgso=cgon_lvt
+ cgdo=cgon_lvt             cgbo=0                    cgdl=cgln_lvt
+ cgsl=cgln_lvt             clc=1e-007                cle=0.6
+ cf=cfn_lvt                ckappas=0.6               kt1=-0.1661575
+ lkt1=-2.48055e-008        wkt1=-1.4141712e-008      pkt1=4.5917934e-015
+ kt1l=0                    kt2=-0.044110942          lkt2=-1.2948115e-009
+ wkt2=-1.2856102e-010      pkt2=3.146392e-016        ute=-0.58834615
+ lute=-3.9659077e-007      wute=-1.7895081e-007      pute=6.6276942e-014
+ ua1=3.1382287e-009        lua1=-7.0958273e-016      wua1=-3.6102272e-016
+ pua1=1.0027031e-022       ub1=-2.7912058e-018       lub1=2.6667615e-025
+ wub1=1.4996231e-025       pub1=-1.6392967e-032      uc1=-6.6845981e-011
+ luc1=-1.3012604e-017      wuc1=1.9602203e-018       puc1=2.5550113e-024
+ prt=0                     at=91877.692              lat=-0.0082869885
+ wat=0.01225449            pat=-2.7154156e-009       njs=1
+ ijthsfwd=0.01             ijthsrev=0.01             bvs=10
+ xjbvs=1                   cjs=cjn_lvt               cjsws=cjswn_lvt
+ cjswgs=cjswgn_lvt         xtis=3                    dmcg=9.25e-008
+ dmci=9.25e-008            dmdg=0                    dmcgt=0
+ dwj=0                     xgw=0                     xgl=0
+ rshg=0.1                  gbmin=1e-012              rbpb=50
+ rbpd=50                   rbps=50                   rbdb=50
+ rbsb=50                   igbmod=1                  igcmod=1
+ rsh=10.5                  voffcv=-0.05472           noff=1.686
+ moin=12.6                 acde=1.2                  dlc=1.25e-008
+ beta0=5.8                 alpha1=0.01               jswgs=9e-12
+ jsws=3.4e-13              jss=1.93e-07              tpbswg=3.00e-03
+ tcjswg=2.26e-03           tpbsw=1.90e-03            tcjsw=3.7e-04
+ tpb=1.20e-03              tcj=7.60e-04              pbswgs=0.78
+ pbsws=0.8                 pbs=0.5                   mjswgs=0.52
+ mjsws=0.01                mjs=0.25                  ngcon=1
+ saref=0.63e-6             sbref=0.63e-6             kvsat=0.3
+ wlod=0.8e-6               tku0=0.01                 ku0=-6.86e-8
+ llodku0=1                 wlodku0=1                 lku0=3.227e-7
+ wku0=8e-7                 pku0=-1.7e-13             kvth0=3.5e-9
+ stk2=1.35e-9              steta0=0                  lkvth0=-2.68e-11
+ wkvth0=1.5e-6             pkvth0=0                  llodvth=1
+ wlodvth=1                 lodk2=0.5                 lodeta0=1
+ fnoimod=1                 tnoimod=0                 noia=3.39e41
+ noib=2.01e24              noic=8.75                 wpemod=wpeflag_lvt
+ kvth0we=0.00323           lkvth0we=0                wkvth0we=0
+ pkvth0we=0                ku0we=-0.003              lku0we=3.00e-10
+ wku0we=0                  pku0we=0                  k2we=0.0015
+ wk2we=0                   web=-210                  wec=-3500
+ scref=1.00e-06            ud=0                      em=2.92e06
+ ef=0.89                   minr=1e-3

     25: type=n
+ lmin=1.0e-07              lmax=2.4000e-07-dxln_lvt  wmin=1.2e-07
+ wmax=2.4000e-07-dxwn_lvt  version=4.5               binunit=2
+ paramchk=1                mobmod=0                  capmod=2
+ diomod=1                  rdsmod=0                  rbodymod=0
+ rgatemod=0                permod=1                  acnqsmod=0
+ trnqsmod=0                tnom=25                   toxe=toxn_lvt
+ toxm=toxn_lvt             dtox=3.8e-010             epsrox=3.9
+ wint=6e-009               lint=2.5e-009             ll=0
+ wl=0                      lln=1                     wln=1
+ lw=0                      ww=0                      lwn=1
+ wwn=1                     lwl=0                     wwl=0
+ llc=0                     wlc=0                     lwc=0
+ wwc=0                     lwlc=0                    wwlc=0
+ dwc=0                     xpart=1                   toxref=3e-009
+ dlcig=2.5e-009            xl=-3.5e-08+dxln_lvt      xw=1.5e-8+dxwn_lvt
+ vth0=0.26885429+dvthn_lvt lvth0=-7.8085714e-010+dlvthn_lvt
+ wvth0=-1.0788506e-008+dwvthn_lvt                    pvth0=2.6473114e-016+dpvthn_lvt
+ k1=0.27                   k2=0.010361393+dk2n_lvt   lk2=-3.9116357e-010
+ wk2=-2.883221e-009        pk2=1.7299326e-016        k3=-2.7
+ k3b=1.2                   w0=0                      dvt0=20
+ dvt1=1.5                  dvt2=0                    dvt0w=0
+ dvt1w=0                   dvt2w=0                   dsub=0.5+ddsubn_lvt
+ minv=0                    voffl=0                   dvtp0=2e-007
+ dvtp1=1                   lpe0=1.5e-008             lpeb=0
+ xj=1.5e-007               ngate=1.5e020             ndep=8.3687e017
+ nsd=1e020                 phin=0                    cdsc=0
+ cdscb=0                   cdscd=0                   lcdscd=0+dlcdscdn_lvt
+ cit=0                     voff=-0.16534286          lvoff=-9.0042857e-010+dlvoffn_lvt
+ lcit=0+dlcitn_lvt         wvoff=9.1090286e-009      pvoff=-3.3731871e-016+dpvoffn_lvt
+ nfactor=0.5325            lnfactor=-2.625e-008      wnfactor=-3.9140357e-008
+ pnfactor=5.3373214e-015   eta0=0.363+deta0n_lvt     weta0=-2.9889e-008
+ etab=-0.07423125          peta0=0+dpeta0n_lvt       wetab=-1.8680625e-010
+ u0=0.0384875              lu0=-1.065e-009           wu0=-2.1527196e-009
+ pu0=1.0674643e-016        ua=-6.37e-011             lua=-1.02285e-016
+ wua=-1.8943933e-016       pua=1.2233141e-023        ub=1.4299393e-018
+ lub=2.1437143e-026        wub=1.2443075e-025        pub=-5.2092257e-033
+ uc=1.2325625e-010         luc=-4.34385e-018         wuc=-3.7343459e-018
+ puc=1.9491898e-025        vsat=118000               lvsat=0+dlvsatn_lvt
+ pvsat=0+dpvsatn_lvt       a0=-3.480825              la0=7.7385e-007
+ wa0=7.1701576e-007        pa0=-9.8420207e-014       ags=-1.8466143
+ lags=2.3157086e-007       wags=1.285227e-007        pags=1.8052956e-014
+ a1=0                      a2=1                      b0=0
+ b1=0                      keta=-0.049814464         lketa=7.2520929e-009
+ wketa=-3.9834209e-009     pketa=-2.1157142e-016     dwg=0
+ dwb=0                     pclm=0.25                 pdiblc1=0
+ pdiblc2=-0.0037785714     ppclm=0+dppclmn_lvt       lpdiblc2=3.4071429e-010
+ wpdiblc2=6.4047857e-010   ppdiblc2=2.1349286e-017   pdiblcb=0
+ drout=0                   pvag=-0.22321429          lpvag=4.3392857e-008
+ wpvag=8.8955357e-008      ppvag=-5.3373214e-015     delta=0.015
+ pscbe1=9.264e008          pscbe2=1e-020             fprout=200
+ pdits=0                   pditsd=0                  pditsl=0
+ rdsw=140+drdswn_lvt       prwg=0                    prwb=0
+ wr=1                      alpha0=0                  agidl=1.685e-007
+ bgidl=2.069e009           cgidl=0.375               egidl=0.779
+ aigbacc=0.01256           bigbacc=0.004998          cigbacc=0.07068
+ nigbacc=3.567             aigbinv=0.35              bigbinv=0.03
+ cigbinv=0.006             eigbinv=1.1               nigbinv=1
+ aigc=0.0102               bigc=0.001561             cigc=0
+ aigsd=0.00852             bigsd=0.0004929           cigsd=0.001386
+ nigc=1                    poxedge=1                 pigcd=2.3
+ ntox=ntoxn_lvt            xrcrg1=12                 xrcrg2=1
+ cgso=cgon_lvt             cgdo=cgon_lvt             cgbo=0
+ cgdl=cgln_lvt             cgsl=cgln_lvt             clc=1e-007
+ cle=0.6                   cf=cfn_lvt                ckappas=0.6
+ kt1=-0.28869679           lkt1=-2.9764286e-010      wkt1=1.1923576e-008
+ pkt1=-6.2126421e-016      kt1l=0                    kt2=-0.054295786
+ lkt2=7.4215714e-010       wkt2=2.2068045e-009       pkt2=-1.524339e-016
+ ute=-2.7255964            lute=3.0859286e-008       wute=1.9950907e-007
+ pute=-9.415035e-015       ua1=-2.7602611e-010       lua1=-2.6731779e-017
+ wua1=1.6022319e-016       pua1=-3.9788664e-024      ub1=-2.3416633e-018
+ lub1=1.7676765e-025       wub1=1.6470654e-025       pub1=-1.9341812e-032
+ uc1=-1.5189993e-010       luc1=3.9981857e-018       wuc1=1.8857824e-017
+ puc1=-8.2450941e-025      prt=0                     at=48522.857
+ lat=0.00038397857         wat=-0.00179334           pat=9.415035e-011
+ njs=1                     ijthsfwd=0.01             ijthsrev=0.01
+ bvs=10                    xjbvs=1                   cjs=cjn_lvt
+ cjsws=cjswn_lvt           cjswgs=cjswgn_lvt         xtis=3
+ dmcg=9.25e-008            dmci=9.25e-008            dmdg=0
+ dmcgt=0                   dwj=0                     xgw=0
+ xgl=0                     rshg=0.1                  gbmin=1e-012
+ rbpb=50                   rbpd=50                   rbps=50
+ rbdb=50                   rbsb=50                   igbmod=1
+ igcmod=1                  rsh=10.5                  voffcv=-0.05472
+ noff=1.686                moin=12.6                 acde=1.2
+ dlc=1.25e-008             beta0=5.8                 alpha1=0.01
+ jswgs=9e-12               jsws=3.4e-13              jss=1.93e-07
+ tpbswg=3.00e-03           tcjswg=2.26e-03           tpbsw=1.90e-03
+ tcjsw=3.7e-04             tpb=1.20e-03              tcj=7.60e-04
+ pbswgs=0.78               pbsws=0.8                 pbs=0.5
+ mjswgs=0.52               mjsws=0.01                mjs=0.25
+ ngcon=1                   saref=0.63e-6             sbref=0.63e-6
+ kvsat=0.3                 wlod=0.8e-6               tku0=0.01
+ ku0=-6.86e-8              llodku0=1                 wlodku0=1
+ lku0=3.227e-7             wku0=8e-7                 pku0=-1.7e-13
+ kvth0=3.5e-9              stk2=1.35e-9              steta0=0
+ lkvth0=-2.68e-11          wkvth0=1.5e-6             pkvth0=0
+ llodvth=1                 wlodvth=1                 lodk2=0.5
+ lodeta0=1                 fnoimod=1                 tnoimod=0
+ noia=3.39e41              noib=2.01e24              noic=8.75
+ wpemod=wpeflag_lvt        kvth0we=0.00323           lkvth0we=0
+ wkvth0we=0                pkvth0we=0                ku0we=-0.003
+ lku0we=3.00e-10           wku0we=0                  pku0we=0
+ k2we=0.0015               wk2we=0                   web=-210
+ wec=-3500                 scref=1.00e-06            ud=0
+ em=2.92e06                ef=0.89                   minr=1e-3

//  *****************************************************************************************
//
//             *
//                                1.0V LOW VT PMOS DEVICE MODELS
//             *
//
//             *
//  *****************************************************************************************

     }
model pch_lvt bsim4  {
     1: type=p
+ lmin=1.0000e-05-dxlp_lvt  lmax=2.001e-05            wmin=1.0000e-05-dxwp_lvt
+ wmax=9.001e-04            version=4.5               binunit=2
+ paramchk=1                mobmod=0                  capmod=2
+ igcmod=1                  igbmod=1                  diomod=1
+ rdsmod=0                  rbodymod=0                rgatemod=0
+ permod=1                  acnqsmod=0                trnqsmod=0
+ tnom=25                   toxe=toxp_lvt             toxm=toxp_lvt
+ dtox=5e-010               epsrox=3.9                wint=5e-009
+ lint=2.5e-009             ll=0                      wl=0
+ lln=1                     wln=1                     lw=0
+ ww=0                      lwn=1                     wwn=1
+ lwl=0                     wwl=0                     llc=0
+ wlc=0                     lwc=0                     wwc=0
+ lwlc=0                    wwlc=0                    dwc=0
+ xpart=1                   toxref=3e-009             dlcig=2.5e-009
+ xl=-3.5e-8+dxlp_lvt       xw=1.5e-8+dxwp_lvt        vth0=-0.169+dvthp_lvt
+ lvth0=0+dlvthp_lvt        wvth0=0+dwvthp_lvt        pvth0=0+dpvthp_lvt
+ k1=0.15                   k2=0.0104+dk2p_lvt        k3=-0.58
+ k3b=0.8                   w0=0                      dvt0=20
+ dvt1=1.8                  dvt2=-0.032               dvt0w=0
+ dvt1w=0                   dvt2w=0                   dsub=0.5
+ minv=0                    voffl=0                   dvtp0=5.5e-007
+ dvtp1=5                   lpe0=0                    lpeb=4.5e-007
+ xj=1.7000001e-007         ngate=8e019               ndep=1.7200001e017
+ nsd=1e020                 phin=0                    cdsc=0
+ cdscb=0                   cdscd=0                   cit=0
+ voff=-0.09969             lvoff=0+dlvoffp_lvt       pvoff=0+dpvoffp_lvt
+ nfactor=0.5               eta0=0.085+deta0p_lvt     etab=-0.02
+ u0=0.0086                 peta0=0+dpeta0p_lvt       ua=-2.764e-010
+ ub=2.003e-018             uc=3.136e-011             vsat=120000
+ a0=3.52                   ags=1.24                  lvsat=0+dlvsatp_lvt
+ pvsat=0+dpvsatp_lvt       a1=0                      a2=1
+ b0=0                      b1=0                      keta=-0.06
+ dwg=0                     dwb=0                     pclm=0.5
+ pdiblc1=0                 pdiblc2=0.0005            pdiblcb=0
+ drout=0                   pvag=0                    delta=0.01
+ pscbe1=9.264e008          pscbe2=1e-020             fprout=1000
+ pdits=0                   pditsd=0                  pditsl=0
+ rdsw=210                  prwg=0                    prwb=0
+ wr=1                      alpha0=0                  agidl=9e-008
+ bgidl=2.3e009             cgidl=0.5                 egidl=0.53
+ aigbacc=0.0117            bigbacc=0.0049            cigbacc=0.1498
+ nigbacc=2.025             aigbinv=0.35              bigbinv=0.03
+ cigbinv=0.006             eigbinv=1.1               nigbinv=1
+ aigc=0.005997             bigc=0.0007088            cigc=5e-011
+ aigsd=0.00469             bigsd=9.291e-005          cigsd=0.001372
+ nigc=1                    poxedge=1                 pigcd=2.3
+ ntox=ntoxp_lvt            xrcrg1=12                 xrcrg2=1
+ cgso=cgop_lvt             cgdo=cgop_lvt             cgbo=0
+ cgdl=cglp_lvt             cgsl=cglp_lvt             clc=1e-007
+ cle=0.6                   cf=cfp_lvt                ckappas=0.6
+ moin=11.09                noff=2.175                voffcv=-0.03885
+ kt1=-0.24                 kt1l=0                    kt2=-0.03875
+ ute=-1.384                ua1=2.5e-009              ub1=-5.861e-018
+ uc1=-1e-011               prt=0                     at=230000
+ njs=1                     ijthsfwd=0.01             ijthsrev=0.01
+ bvs=10                    xjbvs=1                   cjs=cjp_lvt
+ cjsws=cjswp_lvt           cjswgs=cjswgp_lvt         xtis=3
+ dmcg=9.25e-008            dmci=9.25e-008            dmdg=0
+ dmcgt=0                   dwj=0                     xgw=0
+ xgl=0                     rshg=0.1                  gbmin=1e-012
+ rbpb=50                   rbpd=50                   rbps=50
+ rbdb=50                   rbsb=50                   rsh=9.68
+ acde=1.2                  dlc=1.53e-008             beta0=8
+ alpha1=0.003              jswgs=3.00e-12            jsws=3.47e-13
+ jss=1.56e-07              tpbswg=1.9e-03            tcjswg=4.01e-03
+ tpbsw=1.9e-03             tcjsw=1.9e-04             tpb=1.9e-03
+ tcj=8.55e-04              pbswgs=0.7                pbsws=0.8
+ pbs=0.8                   mjswgs=0.98               mjsws=0.01
+ mjs=0.36                  ngcon=1                   saref=0.63e-6
+ sbref=0.63e-6             kvsat=-0.5                wlod=0.8e-6
+ tku0=0.1                  ku0=1.3249e-7             llodku0=1
+ wlodku0=1                 lku0=1.33e-7              wku0=6.5e-7
+ pku0=0                    kvth0=-1.5e-9             stk2=4e-10
+ steta0=0                  lkvth0=-1.68e-15          wkvth0=0.5e-6
+ pkvth0=0                  llodvth=2                 wlodvth=1
+ lodk2=2                   lodeta0=1                 fnoimod=1
+ tnoimod=0                 noia=1.40e42              noib=8.00e26
+ noic=8.75                 wpemod=wpeflag_lvt        kvth0we=-0.0028
+ lkvth0we=0                wkvth0we=0                pkvth0we=0
+ ku0we=-0.0045             lku0we=2.60e-10           wku0we=0
+ pku0we=0                  k2we=0.00045              wk2we=0
+ web=-180                  wec=-3000                 scref=1.00e-06
+ ud=0                      em=1.00e07                ef=1.17
+ minr=1e-3

     2: type=p
+ lmin=1.2000e-06-dxlp_lvt  lmax=1.0000e-05-dxlp_lvt  wmin=1.0000e-05-dxwp_lvt
+ wmax=9.001e-04            version=4.5               binunit=2
+ paramchk=1                mobmod=0                  capmod=2
+ igcmod=1                  igbmod=1                  diomod=1
+ rdsmod=0                  rbodymod=0                rgatemod=0
+ permod=1                  acnqsmod=0                trnqsmod=0
+ tnom=25                   toxe=toxp_lvt             toxm=toxp_lvt
+ dtox=5e-010               epsrox=3.9                wint=5e-009
+ lint=2.5e-009             ll=0                      wl=0
+ lln=1                     wln=1                     lw=0
+ ww=0                      lwn=1                     wwn=1
+ lwl=0                     wwl=0                     llc=0
+ wlc=0                     lwc=0                     wwc=0
+ lwlc=0                    wwlc=0                    dwc=0
+ xpart=1                   toxref=3e-009             dlcig=2.5e-009
+ xl=-3.5e-8+dxlp_lvt       xw=1.5e-8+dxwp_lvt        vth0=-0.16960636+dvthp_lvt
+ lvth0=6.0393818e-009+dlvthp_lvt                     wvth0=0+dwvthp_lvt
+ pvth0=0+dpvthp_lvt        k1=0.15                   k2=0.0092452727+dk2p_lvt
+ lk2=1.1501084e-008        k3=-0.58                  k3b=0.8
+ w0=0                      dvt0=20                   dvt1=1.8
+ dvt2=-0.032               dvt0w=0                   dvt1w=0
+ dvt2w=0                   dsub=0.5                  minv=0
+ voffl=0                   dvtp0=5.5e-007            dvtp1=5
+ lpe0=0                    lpeb=4.5e-007             xj=1.7000001e-007
+ ngate=8e019               ndep=1.7200001e017        nsd=1e020
+ phin=0                    cdsc=0                    cdscb=0
+ cdscd=0                   cit=0                     voff=-0.098990045
+ lvoff=-6.9715473e-009+dlvoffp_lvt                   pvoff=0+dpvoffp_lvt
+ nfactor=0.5               eta0=0.076431818+deta0p_lvt
+ peta0=0+dpeta0p_lvt       leta0=8.5339091e-008      etab=-0.014727273
+ letab=-5.2516364e-008     u0=0.0087397273           lu0=-1.3916836e-009
+ ua=-1.5992545e-010        lua=-1.1600865e-015       ub=1.8986e-018
+ lub=1.039824e-024         uc=2.4948364e-011         luc=6.3859898e-017
+ vsat=122636.36            pvsat=0+dpvsatp_lvt       lvsat=-0.026258182+dlvsatp_lvt
+ a0=3.4759727              la0=4.3851164e-007        ags=1.1709273
+ lags=6.8796436e-007       a1=0                      a2=1
+ b0=0                      b1=0                      keta=-0.044181818
+ lketa=-1.5754909e-007     dwg=0                     dwb=0
+ pclm=0.40772727           lpclm=9.1903636e-007      pdiblc1=0
+ pdiblc2=3.8636364e-005    lpdiblc2=4.5951818e-009   pdiblcb=0
+ drout=0                   pvag=-0.26363636          lpvag=2.6258182e-006
+ delta=0.01                pscbe1=9.264e008          pscbe2=1e-020
+ fprout=1000               pdits=0                   pditsd=0
+ pditsl=0                  rdsw=210                  prwg=0
+ prwb=0                    wr=1                      alpha0=0
+ agidl=9e-008              bgidl=2.3e009             cgidl=0.5
+ egidl=0.53                aigbacc=0.0117            bigbacc=0.0049
+ cigbacc=0.1498            nigbacc=2.025             aigbinv=0.35
+ bigbinv=0.03              cigbinv=0.006             eigbinv=1.1
+ nigbinv=1                 aigc=0.005997             bigc=0.0007088
+ cigc=5e-011               aigsd=0.00469             bigsd=9.291e-005
+ cigsd=0.001372            nigc=1                    poxedge=1
+ pigcd=2.3                 ntox=ntoxp_lvt            xrcrg1=12
+ xrcrg2=1                  cgso=cgop_lvt             cgdo=cgop_lvt
+ cgbo=0                    cgdl=cglp_lvt             cgsl=cglp_lvt
+ clc=1e-007                cle=0.6                   cf=cfp_lvt
+ ckappas=0.6               moin=11.09                noff=2.175
+ voffcv=-0.03885           kt1=-0.23736364           lkt1=-2.6258182e-008
+ kt1l=0                    kt2=-0.03875              ute=-1.4083864
+ lute=2.4288818e-007       ua1=2.5e-009              ub1=-5.9905773e-018
+ lub1=1.2905896e-024       uc1=-3.4090909e-012       luc1=-6.5645455e-017
+ prt=0                     at=230000                 njs=1
+ ijthsfwd=0.01             ijthsrev=0.01             bvs=10
+ xjbvs=1                   cjs=cjp_lvt               cjsws=cjswp_lvt
+ cjswgs=cjswgp_lvt         xtis=3                    dmcg=9.25e-008
+ dmci=9.25e-008            dmdg=0                    dmcgt=0
+ dwj=0                     xgw=0                     xgl=0
+ rshg=0.1                  gbmin=1e-012              rbpb=50
+ rbpd=50                   rbps=50                   rbdb=50
+ rbsb=50                   rsh=9.68                  acde=1.2
+ dlc=1.53e-008             beta0=8                   alpha1=0.003
+ jswgs=3.00e-12            jsws=3.47e-13             jss=1.56e-07
+ tpbswg=1.9e-03            tcjswg=4.01e-03           tpbsw=1.9e-03
+ tcjsw=1.9e-04             tpb=1.9e-03               tcj=8.55e-04
+ pbswgs=0.7                pbsws=0.8                 pbs=0.8
+ mjswgs=0.98               mjsws=0.01                mjs=0.36
+ ngcon=1                   saref=0.63e-6             sbref=0.63e-6
+ kvsat=-0.5                wlod=0.8e-6               tku0=0.1
+ ku0=1.3249e-7             llodku0=1                 wlodku0=1
+ lku0=1.33e-7              wku0=6.5e-7               pku0=0
+ kvth0=-1.5e-9             stk2=4e-10                steta0=0
+ lkvth0=-1.68e-15          wkvth0=0.5e-6             pkvth0=0
+ llodvth=2                 wlodvth=1                 lodk2=2
+ lodeta0=1                 fnoimod=1                 tnoimod=0
+ noia=1.40e42              noib=8.00e26              noic=8.75
+ wpemod=wpeflag_lvt        kvth0we=-0.0028           lkvth0we=0
+ wkvth0we=0                pkvth0we=0                ku0we=-0.0045
+ lku0we=2.60e-10           wku0we=0                  pku0we=0
+ k2we=0.00045              wk2we=0                   web=-180
+ wec=-3000                 scref=1.00e-06            ud=0
+ em=1.00e07                ef=1.17                   minr=1e-3

     3: type=p
+ lmin=5.0000e-07-dxlp_lvt  lmax=1.2000e-06-dxlp_lvt  wmin=1.0000e-05-dxwp_lvt
+ wmax=9.001e-04            version=4.5               binunit=2
+ paramchk=1                mobmod=0                  capmod=2
+ igcmod=1                  igbmod=1                  diomod=1
+ rdsmod=0                  rbodymod=0                rgatemod=0
+ permod=1                  acnqsmod=0                trnqsmod=0
+ tnom=25                   toxe=toxp_lvt             toxm=toxp_lvt
+ dtox=5e-010               epsrox=3.9                wint=5e-009
+ lint=2.5e-009             ll=0                      wl=0
+ lln=1                     wln=1                     lw=0
+ ww=0                      lwn=1                     wwn=1
+ lwl=0                     wwl=0                     llc=0
+ wlc=0                     lwc=0                     wwc=0
+ lwlc=0                    wwlc=0                    dwc=0
+ xpart=1                   toxref=3e-009             dlcig=2.5e-009
+ xl=-3.5e-8+dxlp_lvt       xw=1.5e-8+dxwp_lvt        vth0=-0.16479429+dvthp_lvt
+ lvth0=4.5737143e-010+dlvthp_lvt                     wvth0=0+dwvthp_lvt
+ pvth0=0+dpvthp_lvt        k1=0.15                   k2=0.022550857+dk2p_lvt
+ lk2=-3.9333943e-009       k3=-0.58                  k3b=0.8
+ w0=0                      dvt0=20                   dvt1=1.8
+ dvt2=-0.032               dvt0w=0                   dvt1w=0
+ dvt2w=0                   dsub=0.5                  minv=0
+ voffl=0                   dvtp0=5.5e-007            dvtp1=5
+ lpe0=0                    lpeb=4.5e-007             xj=1.7000001e-007
+ ngate=8e019               ndep=1.7200001e017        nsd=1e020
+ phin=0                    cdsc=0                    cdscb=0
+ cdscd=0                   cit=0                     voff=-0.105
+ lvoff=0+dlvoffp_lvt       pvoff=0+dpvoffp_lvt       nfactor=0.17142857
+ lnfactor=3.8114286e-007   eta0=0.15+deta0p_lvt      peta0=0+dpeta0p_lvt
+ etab=-0.06                u0=0.0075518286           lu0=-1.3721143e-011
+ ua=-1.0864e-009           lua=-8.5376e-017          ub=2.8324571e-018
+ lub=-4.3450286e-026       uc=8e-011                 vsat=100000
+ lvsat=0+dlvsatp_lvt       pvsat=0+dpvsatp_lvt       a0=4.1457714
+ la0=-3.3845486e-007       ags=1.0910857             lags=7.8058057e-007
+ a1=0                      a2=1                      b0=0
+ b1=0                      keta=-0.18                dwg=0
+ dwb=0                     pclm=1.2                  pdiblc1=0
+ pdiblc2=0.004             pdiblcb=0                 drout=0
+ pvag=2                    delta=0.01                pscbe1=9.264e008
+ pscbe2=1e-020             fprout=1000               pdits=0
+ pditsd=0                  pditsl=0                  rdsw=210
+ prwg=0                    prwb=0                    wr=1
+ alpha0=0                  agidl=9e-008              bgidl=2.3e009
+ cgidl=0.5                 egidl=0.53                aigbacc=0.0117
+ bigbacc=0.0049            cigbacc=0.1498            nigbacc=2.025
+ aigbinv=0.35              bigbinv=0.03              cigbinv=0.006
+ eigbinv=1.1               nigbinv=1                 aigc=0.005997
+ bigc=0.0007088            cigc=5e-011               aigsd=0.00469
+ bigsd=9.291e-005          cigsd=0.001372            nigc=1
+ poxedge=1                 pigcd=2.3                 ntox=ntoxp_lvt
+ xrcrg1=12                 xrcrg2=1                  cgso=cgop_lvt
+ cgdo=cgop_lvt             cgbo=0                    cgdl=cglp_lvt
+ cgsl=cglp_lvt             clc=1e-007                cle=0.6
+ cf=cfp_lvt                ckappas=0.6               moin=11.09
+ noff=2.175                voffcv=-0.03885           kt1=-0.23371429
+ lkt1=-3.0491429e-008      kt1l=0                    kt2=-0.03875
+ ute=-1.199                ua1=2.9724857e-009        lua1=-5.4808343e-016
+ ub1=-5.8072e-018          lub1=1.077872e-024        uc1=-9.2857143e-011
+ luc1=3.8114286e-017       prt=0                     at=236571.43
+ lat=-0.0076228571         njs=1                     ijthsfwd=0.01
+ ijthsrev=0.01             bvs=10                    xjbvs=1
+ cjs=cjp_lvt               cjsws=cjswp_lvt           cjswgs=cjswgp_lvt
+ xtis=3                    dmcg=9.25e-008            dmci=9.25e-008
+ dmdg=0                    dmcgt=0                   dwj=0
+ xgw=0                     xgl=0                     rshg=0.1
+ gbmin=1e-012              rbpb=50                   rbpd=50
+ rbps=50                   rbdb=50                   rbsb=50
+ rsh=9.68                  acde=1.2                  dlc=1.53e-008
+ beta0=8                   alpha1=0.003              jswgs=3.00e-12
+ jsws=3.47e-13             jss=1.56e-07              tpbswg=1.9e-03
+ tcjswg=4.01e-03           tpbsw=1.9e-03             tcjsw=1.9e-04
+ tpb=1.9e-03               tcj=8.55e-04              pbswgs=0.7
+ pbsws=0.8                 pbs=0.8                   mjswgs=0.98
+ mjsws=0.01                mjs=0.36                  ngcon=1
+ saref=0.63e-6             sbref=0.63e-6             kvsat=-0.5
+ wlod=0.8e-6               tku0=0.1                  ku0=1.3249e-7
+ llodku0=1                 wlodku0=1                 lku0=1.33e-7
+ wku0=6.5e-7               pku0=0                    kvth0=-1.5e-9
+ stk2=4e-10                steta0=0                  lkvth0=-1.68e-15
+ wkvth0=0.5e-6             pkvth0=0                  llodvth=2
+ wlodvth=1                 lodk2=2                   lodeta0=1
+ fnoimod=1                 tnoimod=0                 noia=1.40e42
+ noib=8.00e26              noic=8.75                 wpemod=wpeflag_lvt
+ kvth0we=-0.0028           lkvth0we=0                wkvth0we=0
+ pkvth0we=0                ku0we=-0.0045             lku0we=2.60e-10
+ wku0we=0                  pku0we=0                  k2we=0.00045
+ wk2we=0                   web=-180                  wec=-3000
+ scref=1.00e-06            ud=0                      em=1.00e07
+ ef=1.17                   minr=1e-3

     4: type=p
+ lmin=2.4000e-07-dxlp_lvt  lmax=5.0000e-07-dxlp_lvt  wmin=1.0000e-05-dxwp_lvt
+ wmax=9.001e-04            version=4.5               binunit=2
+ paramchk=1                mobmod=0                  capmod=2
+ igcmod=1                  igbmod=1                  diomod=1
+ rdsmod=0                  rbodymod=0                rgatemod=0
+ permod=1                  acnqsmod=0                trnqsmod=0
+ tnom=25                   toxe=toxp_lvt             toxm=toxp_lvt
+ dtox=5e-010               epsrox=3.9                wint=5e-009
+ lint=2.5e-009             ll=0                      wl=0
+ lln=1                     wln=1                     lw=0
+ ww=0                      lwn=1                     wwn=1
+ lwl=0                     wwl=0                     llc=0
+ wlc=0                     lwc=0                     wwc=0
+ lwlc=0                    wwlc=0                    dwc=0
+ xpart=1                   toxref=3e-009             dlcig=2.5e-009
+ xl=-3.5e-8+dxlp_lvt       xw=1.5e-8+dxwp_lvt        vth0=-0.16364615+dvthp_lvt
+ lvth0=-7.0769231e-011+dlvthp_lvt                    wvth0=0+dwvthp_lvt
+ pvth0=0+dpvthp_lvt        k1=0.15                   k2=0.031578462+dk2p_lvt
+ lk2=-8.0860923e-009       k3=-0.58                  k3b=0.8
+ w0=0                      dvt0=20                   dvt1=1.8
+ dvt2=-0.032               dvt0w=0                   dvt1w=0
+ dvt2w=0                   dsub=0.5                  minv=0
+ voffl=0                   dvtp0=5.5e-007            dvtp1=5
+ lpe0=0                    lpeb=4.5e-007             xj=1.7000001e-007
+ ngate=8e019               ndep=1.7200001e017        nsd=1e020
+ phin=0                    cdsc=0                    cdscb=0
+ cdscd=0                   cit=-0.00076923077        lcit=3.5384615e-010
+ voff=-0.105               lvoff=0+dlvoffp_lvt       pvoff=0+dpvoffp_lvt
+ nfactor=1                 eta0=0.15+deta0p_lvt      peta0=0+dpeta0p_lvt
+ etab=-0.06                u0=0.0076543077           lu0=-6.0861538e-011
+ ua=-1.2458462e-009        lua=-1.2030769e-017       ub=2.7510769e-018
+ lub=-6.0153846e-027       uc=6.4615385e-011         luc=7.0769231e-018
+ vsat=100000               a0=2.5715385              la0=3.8569231e-007
+ lvsat=0+dlvsatp_lvt       pvsat=0+dpvsatp_lvt       ags=0.31723077
+ lags=1.1365538e-006       a1=0                      a2=1
+ b0=0                      b1=0                      keta=-0.18
+ dwg=0                     dwb=0                     pclm=1.5846154
+ lpclm=-1.7692308e-007     pdiblc1=0                 pdiblc2=0.0063076923
+ lpdiblc2=-1.0615385e-009  pdiblcb=0                 drout=0
+ pvag=2                    delta=0.01                pscbe1=9.264e008
+ pscbe2=1e-020             fprout=1000               pdits=0
+ pditsd=0                  pditsl=0                  rdsw=210
+ prwg=0                    prwb=0                    wr=1
+ alpha0=0                  agidl=9e-008              bgidl=2.3e009
+ cgidl=0.5                 egidl=0.53                aigbacc=0.0117
+ bigbacc=0.0049            cigbacc=0.1498            nigbacc=2.025
+ aigbinv=0.35              bigbinv=0.03              cigbinv=0.006
+ eigbinv=1.1               nigbinv=1                 aigc=0.005997
+ bigc=0.0007088            cigc=5e-011               aigsd=0.00469
+ bigsd=9.291e-005          cigsd=0.001372            nigc=1
+ poxedge=1                 pigcd=2.3                 ntox=ntoxp_lvt
+ xrcrg1=12                 xrcrg2=1                  cgso=cgop_lvt
+ cgdo=cgop_lvt             cgbo=0                    cgdl=cglp_lvt
+ cgsl=cglp_lvt             clc=1e-007                cle=0.6
+ cf=cfp_lvt                ckappas=0.6               moin=11.09
+ noff=2.175                voffcv=-0.03885           kt1=-0.3
+ kt1l=0                    kt2=-0.03875              ute=-1.5063846
+ lute=1.4139692e-007       ua1=8.4484615e-010        lua1=4.3063077e-016
+ ub1=-2.9047692e-018       lub1=-2.5724615e-025      uc1=-1e-011
+ prt=0                     at=335384.62              lat=-0.053076923
+ njs=1                     ijthsfwd=0.01             ijthsrev=0.01
+ bvs=10                    xjbvs=1                   cjs=cjp_lvt
+ cjsws=cjswp_lvt           cjswgs=cjswgp_lvt         xtis=3
+ dmcg=9.25e-008            dmci=9.25e-008            dmdg=0
+ dmcgt=0                   dwj=0                     xgw=0
+ xgl=0                     rshg=0.1                  gbmin=1e-012
+ rbpb=50                   rbpd=50                   rbps=50
+ rbdb=50                   rbsb=50                   rsh=9.68
+ acde=1.2                  dlc=1.53e-008             beta0=8
+ alpha1=0.003              jswgs=3.00e-12            jsws=3.47e-13
+ jss=1.56e-07              tpbswg=1.9e-03            tcjswg=4.01e-03
+ tpbsw=1.9e-03             tcjsw=1.9e-04             tpb=1.9e-03
+ tcj=8.55e-04              pbswgs=0.7                pbsws=0.8
+ pbs=0.8                   mjswgs=0.98               mjsws=0.01
+ mjs=0.36                  ngcon=1                   saref=0.63e-6
+ sbref=0.63e-6             kvsat=-0.5                wlod=0.8e-6
+ tku0=0.1                  ku0=1.3249e-7             llodku0=1
+ wlodku0=1                 lku0=1.33e-7              wku0=6.5e-7
+ pku0=0                    kvth0=-1.5e-9             stk2=4e-10
+ steta0=0                  lkvth0=-1.68e-15          wkvth0=0.5e-6
+ pkvth0=0                  llodvth=2                 wlodvth=1
+ lodk2=2                   lodeta0=1                 fnoimod=1
+ tnoimod=0                 noia=1.40e42              noib=8.00e26
+ noic=8.75                 wpemod=wpeflag_lvt        kvth0we=-0.0028
+ lkvth0we=0                wkvth0we=0                pkvth0we=0
+ ku0we=-0.0045             lku0we=2.60e-10           wku0we=0
+ pku0we=0                  k2we=0.00045              wk2we=0
+ web=-180                  wec=-3000                 scref=1.00e-06
+ ud=0                      em=1.00e07                ef=1.17
+ minr=1e-3

     5: type=p
+ lmin=1.0e-07              lmax=2.4000e-07-dxlp_lvt  wmin=1.0000e-05-dxwp_lvt
+ wmax=9.001e-04            version=4.5               binunit=2
+ paramchk=1                mobmod=0                  capmod=2
+ igcmod=1                  igbmod=1                  diomod=1
+ rdsmod=0                  rbodymod=0                rgatemod=0
+ permod=1                  acnqsmod=0                trnqsmod=0
+ tnom=25                   toxe=toxp_lvt             toxm=toxp_lvt
+ dtox=5e-010               epsrox=3.9                wint=5e-009
+ lint=2.5e-009             ll=0                      wl=0
+ lln=1                     wln=1                     lw=0
+ ww=0                      lwn=1                     wwn=1
+ lwl=0                     wwl=0                     llc=0
+ wlc=0                     lwc=0                     wwc=0
+ lwlc=0                    wwlc=0                    dwc=0
+ xpart=1                   toxref=3e-009             dlcig=2.5e-009
+ xl=-3.5e-8+dxlp_lvt       xw=1.5e-8+dxwp_lvt        vth0=-0.16571429+dvthp_lvt
+ lvth0=3.4285714e-010+dlvthp_lvt                     wvth0=0+dwvthp_lvt
+ pvth0=0+dpvthp_lvt        k1=0.15                   k2=0.00364+dk2p_lvt
+ lk2=-2.4984e-009          k3=-0.58                  k3b=0.8
+ w0=0                      dvt0=20                   dvt1=1.8
+ dvt2=-0.061142857         ldvt2=5.8285714e-009      dvt0w=0
+ dvt1w=0                   dvt2w=0                   dsub=0.5
+ minv=0                    voffl=0                   dvtp0=5.5e-007
+ dvtp1=5                   lpe0=0                    lpeb=4.5e-007
+ xj=1.7000001e-007         ngate=8e019               ndep=1.7200001e017
+ nsd=1e020                 phin=0                    cdsc=0
+ cdscb=0                   cdscd=0                   cit=-0.0013142857
+ lcit=4.6285714e-010       voff=-0.10071429          lvoff=-8.5714286e-010+dlvoffp_lvt
+ pvoff=0+dpvoffp_lvt       nfactor=1.0642857         lnfactor=-1.2857143e-008
+ eta0=0.15085714+deta0p_lvt                          peta0=0+dpeta0p_lvt
+ leta0=-1.7142857e-010     etab=-0.076971429         letab=3.3942857e-009
+ u0=0.0081857143           lu0=-1.6714286e-010       ua=-1.2837143e-009
+ lua=-4.4571429e-018       ub=2.7321429e-018         lub=-2.2285714e-027
+ uc=8.0028571e-011         luc=3.9942857e-018        vsat=100000
+ lvsat=0+dlvsatp_lvt       pvsat=0+dpvsatp_lvt       a0=2.0571429
+ la0=4.8857143e-007        ags=1.1785714             lags=9.6428571e-007
+ a1=0                      a2=1                      b0=0
+ b1=0                      keta=-0.23481429          lketa=1.0962857e-008
+ dwg=0                     dwb=0                     pclm=0.88814286
+ lpclm=-3.7628571e-008     pdiblc1=0                 pdiblc2=0.001
+ pdiblcb=0                 drout=0                   pvag=2
+ delta=0.01                pscbe1=9.264e008          pscbe2=1e-020
+ fprout=1000               pdits=0                   pditsd=0
+ pditsl=0                  rdsw=210                  prwg=0
+ prwb=0                    wr=1                      alpha0=0
+ agidl=9e-008              bgidl=2.3e009             cgidl=0.5
+ egidl=0.53                aigbacc=0.0117            bigbacc=0.0049
+ cigbacc=0.1498            nigbacc=2.025             aigbinv=0.35
+ bigbinv=0.03              cigbinv=0.006             eigbinv=1.1
+ nigbinv=1                 aigc=0.005997             bigc=0.0007088
+ cigc=5e-011               aigsd=0.00469             bigsd=9.291e-005
+ cigsd=0.001372            nigc=1                    poxedge=1
+ pigcd=2.3                 ntox=ntoxp_lvt            xrcrg1=12
+ xrcrg2=1                  cgso=cgop_lvt             cgdo=cgop_lvt
+ cgbo=0                    cgdl=cglp_lvt             cgsl=cglp_lvt
+ clc=1e-007                cle=0.6                   cf=cfp_lvt
+ ckappas=0.6               moin=11.09                noff=2.175
+ voffcv=-0.03885           kt1=-0.24428571           lkt1=-1.1142857e-008
+ kt1l=0                    kt2=-0.03875              ute=-0.77968571
+ lute=-3.9428571e-009      ua1=3.4672857e-009        lua1=-9.3857143e-017
+ ub1=-5.0387143e-018       lub1=1.6954286e-025       uc1=-1e-011
+ prt=0                     at=72597.143              lat=-0.00051942857
+ njs=1                     ijthsfwd=0.01             ijthsrev=0.01
+ bvs=10                    xjbvs=1                   cjs=cjp_lvt
+ cjsws=cjswp_lvt           cjswgs=cjswgp_lvt         xtis=3
+ dmcg=9.25e-008            dmci=9.25e-008            dmdg=0
+ dmcgt=0                   dwj=0                     xgw=0
+ xgl=0                     rshg=0.1                  gbmin=1e-012
+ rbpb=50                   rbpd=50                   rbps=50
+ rbdb=50                   rbsb=50                   rsh=9.68
+ acde=1.2                  dlc=1.53e-008             beta0=8
+ alpha1=0.003              jswgs=3.00e-12            jsws=3.47e-13
+ jss=1.56e-07              tpbswg=1.9e-03            tcjswg=4.01e-03
+ tpbsw=1.9e-03             tcjsw=1.9e-04             tpb=1.9e-03
+ tcj=8.55e-04              pbswgs=0.7                pbsws=0.8
+ pbs=0.8                   mjswgs=0.98               mjsws=0.01
+ mjs=0.36                  ngcon=1                   saref=0.63e-6
+ sbref=0.63e-6             kvsat=-0.5                wlod=0.8e-6
+ tku0=0.1                  ku0=1.3249e-7             llodku0=1
+ wlodku0=1                 lku0=1.33e-7              wku0=6.5e-7
+ pku0=0                    kvth0=-1.5e-9             stk2=4e-10
+ steta0=0                  lkvth0=-1.68e-15          wkvth0=0.5e-6
+ pkvth0=0                  llodvth=2                 wlodvth=1
+ lodk2=2                   lodeta0=1                 fnoimod=1
+ tnoimod=0                 noia=1.40e42              noib=8.00e26
+ noic=8.75                 wpemod=wpeflag_lvt        kvth0we=-0.0028
+ lkvth0we=0                wkvth0we=0                pkvth0we=0
+ ku0we=-0.0045             lku0we=2.60e-10           wku0we=0
+ pku0we=0                  k2we=0.00045              wk2we=0
+ web=-180                  wec=-3000                 scref=1.00e-06
+ ud=0                      em=1.00e07                ef=1.17
+ minr=1e-3

     6: type=p
+ lmin=1.0000e-05-dxlp_lvt  lmax=2.001e-05            wmin=1.0000e-06-dxwp_lvt
+ wmax=1.0000e-05-dxwp_lvt  version=4.5               binunit=2
+ paramchk=1                mobmod=0                  capmod=2
+ igcmod=1                  igbmod=1                  diomod=1
+ rdsmod=0                  rbodymod=0                rgatemod=0
+ permod=1                  acnqsmod=0                trnqsmod=0
+ tnom=25                   toxe=toxp_lvt             toxm=toxp_lvt
+ dtox=5e-010               epsrox=3.9                wint=5e-009
+ lint=2.5e-009             ll=0                      wl=0
+ lln=1                     wln=1                     lw=0
+ ww=0                      lwn=1                     wwn=1
+ lwl=0                     wwl=0                     llc=0
+ wlc=0                     lwc=0                     wwc=0
+ lwlc=0                    wwlc=0                    dwc=0
+ xpart=1                   toxref=3e-009             dlcig=2.5e-009
+ xl=-3.5e-8+dxlp_lvt       xw=1.5e-8+dxwp_lvt        vth0=-0.17022833+dvthp_lvt
+ wvth0=1.2289475e-008+dwvthp_lvt                     lvth0=0+dlvthp_lvt
+ pvth0=0+dpvthp_lvt        k1=0.15                   k2=0.0099756667+dk2p_lvt
+ wk2=4.245455e-009         k3=-0.58                  k3b=0.8
+ w0=0                      dvt0=20                   dvt1=1.8
+ dvt2=-0.032               dvt0w=0                   dvt1w=0
+ dvt2w=0                   dsub=0.5                  minv=0
+ voffl=0                   dvtp0=5.5e-007            dvtp1=5
+ lpe0=0                    lpeb=4.5e-007             xj=1.7000001e-007
+ ngate=8e019               ndep=1.7200001e017        nsd=1e020
+ phin=0                    cdsc=0                    cdscb=0
+ cdscd=0                   cit=0                     voff=-0.10021372
+ wvoff=5.2397853e-009      lvoff=0+dlvoffp_lvt       pvoff=0+dpvoffp_lvt
+ nfactor=0.5               eta0=0.08165+deta0p_lvt   peta0=0+dpeta0p_lvt
+ weta0=3.351675e-008       etab=-0.015533333         wetab=-4.4689e-008
+ u0=0.0087418167           wu0=-1.4188758e-009       ua=-2.63335e-010
+ wua=-1.3071533e-016       ub=2.0099233e-018         wub=-6.926795e-026
+ uc=2.9278533e-011         wuc=2.0825074e-017        vsat=122233.33
+ lvsat=0+dlvsatp_lvt       pvsat=0+dpvsatp_lvt       wvsat=-0.0223445
+ a0=3.55819                wa0=-3.8209095e-007       ags=1.2415633
+ wags=-1.564115e-008       a1=0                      a2=1
+ b0=0                      b1=0                      keta=-0.06
+ dwg=0                     dwb=0                     pclm=0.42183333
+ wpclm=7.820575e-007       pdiblc1=0                 pdiblc2=0.00044416667
+ wpdiblc2=5.586125e-010    pdiblcb=0                 drout=0
+ pvag=-0.22333333          wpvag=2.23445e-006        delta=0.01
+ pscbe1=9.264e008          pscbe2=1e-020             fprout=1000
+ pdits=0                   pditsd=0                  pditsl=0
+ rdsw=210                  prwg=0                    prwb=0
+ wr=1                      alpha0=0                  agidl=9e-008
+ bgidl=2.3e009             cgidl=0.5                 egidl=0.53
+ aigbacc=0.0117            bigbacc=0.0049            cigbacc=0.1498
+ nigbacc=2.025             aigbinv=0.35              bigbinv=0.03
+ cigbinv=0.006             eigbinv=1.1               nigbinv=1
+ aigc=0.005997             bigc=0.0007088            cigc=5e-011
+ aigsd=0.00469             bigsd=9.291e-005          cigsd=0.001372
+ nigc=1                    poxedge=1                 pigcd=2.3
+ ntox=ntoxp_lvt            xrcrg1=12                 xrcrg2=1
+ cgso=cgop_lvt             cgdo=cgop_lvt             cgbo=0
+ cgdl=cglp_lvt             cgsl=cglp_lvt             clc=1e-007
+ cle=0.6                   cf=cfp_lvt                ckappas=0.6
+ moin=11.09                noff=2.175                voffcv=-0.03885
+ kt1=-0.23888333           wkt1=-1.117225e-008       kt1l=0
+ kt2=-0.03875              ute=-1.378305             wute=-5.6978475e-008
+ ua1=2.5675583e-009        wua1=-6.7592112e-016      ub1=-5.9522317e-018
+ wub1=9.1277282e-025       uc1=-3.6093333e-013       wuc1=-9.6438862e-017
+ prt=0                     at=230000                 njs=1
+ ijthsfwd=0.01             ijthsrev=0.01             bvs=10
+ xjbvs=1                   cjs=cjp_lvt               cjsws=cjswp_lvt
+ cjswgs=cjswgp_lvt         xtis=3                    dmcg=9.25e-008
+ dmci=9.25e-008            dmdg=0                    dmcgt=0
+ dwj=0                     xgw=0                     xgl=0
+ rshg=0.1                  gbmin=1e-012              rbpb=50
+ rbpd=50                   rbps=50                   rbdb=50
+ rbsb=50                   rsh=9.68                  acde=1.2
+ dlc=1.53e-008             beta0=8                   alpha1=0.003
+ jswgs=3.00e-12            jsws=3.47e-13             jss=1.56e-07
+ tpbswg=1.9e-03            tcjswg=4.01e-03           tpbsw=1.9e-03
+ tcjsw=1.9e-04             tpb=1.9e-03               tcj=8.55e-04
+ pbswgs=0.7                pbsws=0.8                 pbs=0.8
+ mjswgs=0.98               mjsws=0.01                mjs=0.36
+ ngcon=1                   saref=0.63e-6             sbref=0.63e-6
+ kvsat=-0.5                wlod=0.8e-6               tku0=0.1
+ ku0=1.3249e-7             llodku0=1                 wlodku0=1
+ lku0=1.33e-7              wku0=6.5e-7               pku0=0
+ kvth0=-1.5e-9             stk2=4e-10                steta0=0
+ lkvth0=-1.68e-15          wkvth0=0.5e-6             pkvth0=0
+ llodvth=2                 wlodvth=1                 lodk2=2
+ lodeta0=1                 fnoimod=1                 tnoimod=0
+ noia=1.40e42              noib=8.00e26              noic=8.75
+ wpemod=wpeflag_lvt        kvth0we=-0.0028           lkvth0we=0
+ wkvth0we=0                pkvth0we=0                ku0we=-0.0045
+ lku0we=2.60e-10           wku0we=0                  pku0we=0
+ k2we=0.00045              wk2we=0                   web=-180
+ wec=-3000                 scref=1.00e-06            ud=0
+ em=1.00e07                ef=1.17                   minr=1e-3

     7: type=p
+ lmin=1.2000e-06-dxlp_lvt  lmax=1.0000e-05-dxlp_lvt  wmin=1.0000e-06-dxwp_lvt
+ wmax=1.0000e-05-dxwp_lvt  version=4.5               binunit=2
+ paramchk=1                mobmod=0                  capmod=2
+ igcmod=1                  igbmod=1                  diomod=1
+ rdsmod=0                  rbodymod=0                rgatemod=0
+ permod=1                  acnqsmod=0                trnqsmod=0
+ tnom=25                   toxe=toxp_lvt             toxm=toxp_lvt
+ dtox=5e-010               epsrox=3.9                wint=5e-009
+ lint=2.5e-009             ll=0                      wl=0
+ lln=1                     wln=1                     lw=0
+ ww=0                      lwn=1                     wwn=1
+ lwl=0                     wwl=0                     llc=0
+ wlc=0                     lwc=0                     wwc=0
+ lwlc=0                    wwlc=0                    dwc=0
+ xpart=1                   toxref=3e-009             dlcig=2.5e-009
+ xl=-3.5e-8+dxlp_lvt       xw=1.5e-8+dxwp_lvt        vth0=-0.17097601+dvthp_lvt
+ lvth0=7.4468204e-009+dlvthp_lvt                     wvth0=1.3703272e-008+dwvthp_lvt
+ pvth0=-1.4081423e-014+dpvthp_lvt                    k1=0.15
+ k2=0.0087597055+dk2p_lvt  lk2=1.2110974e-008        wk2=4.8581006e-009
+ pk2=-6.1019498e-015       k3=-0.58                  k3b=0.8
+ w0=0                      dvt0=20                   dvt1=1.8
+ dvt2=-0.032               dvt0w=0                   dvt1w=0
+ dvt2w=0                   dsub=0.5                  minv=0
+ voffl=0                   dvtp0=5.5e-007            dvtp1=5
+ lpe0=0                    lpeb=4.5e-007             xj=1.7000001e-007
+ ngate=8e019               ndep=1.7200001e017        nsd=1e020
+ phin=0                    cdsc=0                    cdscb=0
+ cdscd=0                   cit=0                     voff=-0.099582798
+ lvoff=-6.2839549e-009+dlvoffp_lvt                   wvoff=5.9304842e-009
+ pvoff=-6.8793617e-015+dpvoffp_lvt                   nfactor=0.5
+ eta0=0.072125038+deta0p_lvt                         leta0=9.4868623e-008
+ weta0=4.3089337e-008      peta0=-9.5342966e-014+dpeta0p_lvt
+ etab=-0.0096718182        letab=-5.8380691e-008     wetab=-5.0579823e-008
+ petab=5.8672594e-014      u0=0.0088974412           lu0=-1.5500205e-009
+ wu0=-1.577928e-009        pu0=1.58416e-015          ua=-1.4064874e-010
+ lua=-1.2219551e-015       wua=-1.928635e-016        pua=6.1899587e-022
+ ub=1.9017109e-018         lub=1.0777955e-024        wub=-3.1124873e-026
+ pub=-3.7990505e-031       uc=2.2886916e-011         luc=6.3660511e-017
+ wuc=2.0624786e-017        puc=1.9948682e-024        vsat=125164.09
+ lvsat=-0.029190345+dlvsatp_lvt                      wvsat=-0.025289911
+ pvsat=2.9336297e-008+dpvsatp_lvt                    a0=3.5290738
+ la0=2.8999755e-007        wa0=-5.3127604e-007       pa0=1.4858835e-012
+ ags=1.1717841             lags=6.9500156e-007       wags=-8.5721627e-009
+ pags=-7.0407113e-014      a1=0                      a2=1
+ b0=0                      b1=0                      keta=-0.042415455
+ lketa=-1.7514207e-007     wketa=-1.7672468e-008     pketa=1.7601778e-013
+ dwg=0                     dwb=0                     pclm=0.31925682
+ lpclm=1.0216621e-006      wpclm=8.851469e-007       ppclm=-1.0267704e-012
+ pdiblc1=0                 pdiblc2=-2.4556818e-005   lpdiblc2=4.6684859e-009
+ wpdiblc2=6.3224778e-010   ppdiblc2=-7.3340743e-016  pdiblcb=0
+ drout=0                   pvag=-0.51640909          lpvag=2.9190345e-006
+ wpvag=2.5289911e-006      ppvag=-2.9336297e-012     delta=0.01
+ pscbe1=9.264e008          pscbe2=1e-020             fprout=1000
+ pdits=0                   pditsd=0                  pditsl=0
+ rdsw=210                  prwg=0                    prwb=0
+ wr=1                      alpha0=0                  agidl=9e-008
+ bgidl=2.3e009             cgidl=0.5                 egidl=0.53
+ aigbacc=0.0117            bigbacc=0.0049            cigbacc=0.1498
+ nigbacc=2.025             aigbinv=0.35              bigbinv=0.03
+ cigbinv=0.006             eigbinv=1.1               nigbinv=1
+ aigc=0.005997             bigc=0.0007088            cigc=5e-011
+ aigsd=0.00469             bigsd=9.291e-005          cigsd=0.001372
+ nigc=1                    poxedge=1                 pigcd=2.3
+ ntox=ntoxp_lvt            xrcrg1=12                 xrcrg2=1
+ cgso=cgop_lvt             cgdo=cgop_lvt             cgbo=0
+ cgdl=cglp_lvt             cgsl=cglp_lvt             clc=1e-007
+ cle=0.6                   cf=cfp_lvt                ckappas=0.6
+ moin=11.09                noff=2.175                voffcv=-0.03885
+ kt1=-0.23609977           lkt1=-2.7724264e-008      wkt1=-1.2644956e-008
+ pkt1=1.4668149e-014       kt1l=0                    kt2=-0.03875
+ ute=-1.4038689            lute=2.5461684e-007       wute=-4.519683e-008
+ pute=-1.1734519e-013      ua1=2.5705906e-009        lua1=-3.0201285e-017
+ wua1=-7.0625886e-016      pua1=3.0216386e-022       ub1=-6.0926426e-018
+ lub1=1.3984933e-024       wub1=1.021164e-024        pub1=-1.0795757e-030
+ uc1=6.9659606e-012        luc1=-7.2975864e-017      wuc1=-1.0380239e-016
+ puc1=7.3340743e-023       prt=0                     at=230000
+ njs=1                     ijthsfwd=0.01             ijthsrev=0.01
+ bvs=10                    xjbvs=1                   cjs=cjp_lvt
+ cjsws=cjswp_lvt           cjswgs=cjswgp_lvt         xtis=3
+ dmcg=9.25e-008            dmci=9.25e-008            dmdg=0
+ dmcgt=0                   dwj=0                     xgw=0
+ xgl=0                     rshg=0.1                  gbmin=1e-012
+ rbpb=50                   rbpd=50                   rbps=50
+ rbdb=50                   rbsb=50                   rsh=9.68
+ acde=1.2                  dlc=1.53e-008             beta0=8
+ alpha1=0.003              jswgs=3.00e-12            jsws=3.47e-13
+ jss=1.56e-07              tpbswg=1.9e-03            tcjswg=4.01e-03
+ tpbsw=1.9e-03             tcjsw=1.9e-04             tpb=1.9e-03
+ tcj=8.55e-04              pbswgs=0.7                pbsws=0.8
+ pbs=0.8                   mjswgs=0.98               mjsws=0.01
+ mjs=0.36                  ngcon=1                   saref=0.63e-6
+ sbref=0.63e-6             kvsat=-0.5                wlod=0.8e-6
+ tku0=0.1                  ku0=1.3249e-7             llodku0=1
+ wlodku0=1                 lku0=1.33e-7              wku0=6.5e-7
+ pku0=0                    kvth0=-1.5e-9             stk2=4e-10
+ steta0=0                  lkvth0=-1.68e-15          wkvth0=0.5e-6
+ pkvth0=0                  llodvth=2                 wlodvth=1
+ lodk2=2                   lodeta0=1                 fnoimod=1
+ tnoimod=0                 noia=1.40e42              noib=8.00e26
+ noic=8.75                 wpemod=wpeflag_lvt        kvth0we=-0.0028
+ lkvth0we=0                wkvth0we=0                pkvth0we=0
+ ku0we=-0.0045             lku0we=2.60e-10           wku0we=0
+ pku0we=0                  k2we=0.00045              wk2we=0
+ web=-180                  wec=-3000                 scref=1.00e-06
+ ud=0                      em=1.00e07                ef=1.17
+ minr=1e-3

     8: type=p
+ lmin=5.0000e-07-dxlp_lvt  lmax=1.2000e-06-dxlp_lvt  wmin=1.0000e-06-dxwp_lvt
+ wmax=1.0000e-05-dxwp_lvt  version=4.5               binunit=2
+ paramchk=1                mobmod=0                  capmod=2
+ igcmod=1                  igbmod=1                  diomod=1
+ rdsmod=0                  rbodymod=0                rgatemod=0
+ permod=1                  acnqsmod=0                trnqsmod=0
+ tnom=25                   toxe=toxp_lvt             toxm=toxp_lvt
+ dtox=5e-010               epsrox=3.9                wint=5e-009
+ lint=2.5e-009             ll=0                      wl=0
+ lln=1                     wln=1                     lw=0
+ ww=0                      lwn=1                     wwn=1
+ lwl=0                     wwl=0                     llc=0
+ wlc=0                     lwc=0                     wwc=0
+ lwlc=0                    wwlc=0                    dwc=0
+ xpart=1                   toxref=3e-009             dlcig=2.5e-009
+ xl=-3.5e-8+dxlp_lvt       xw=1.5e-8+dxwp_lvt        vth0=-0.16499465+dvthp_lvt
+ lvth0=5.0844457e-010+dlvthp_lvt                     wvth0=2.0046209e-009+dwvthp_lvt
+ pvth0=-5.1098679e-016+dpvthp_lvt                    k1=0.15
+ k2=0.02232395+dk2p_lvt    lk2=-3.6235506e-009       wk2=2.2702012e-009
+ pk2=-3.0999866e-015       k3=-0.58                  k3b=0.8
+ w0=0                      dvt0=20                   dvt1=1.8
+ dvt2=-0.032               dvt0w=0                   dvt1w=0
+ dvt2w=0                   dsub=0.5                  minv=0
+ voffl=0                   dvtp0=5.5e-007            dvtp1=5
+ lpe0=0                    lpeb=4.5e-007             xj=1.7000001e-007
+ ngate=8e019               ndep=1.7200001e017        nsd=1e020
+ phin=0                    cdsc=0                    cdscb=0
+ cdscd=0                   cit=0                     voff=-0.105
+ lvoff=0+dlvoffp_lvt       pvoff=0+dpvoffp_lvt       nfactor=0.17142857
+ lnfactor=3.8114286e-007   eta0=0.15390833+deta0p_lvt
+ peta0=0+dpeta0p_lvt       weta0=-3.9102875e-008     etab=-0.06
+ u0=0.0075582223           lu0=3.4734819e-012        wu0=-6.3969111e-011
+ pu0=-1.7203222e-016       ua=-1.1216031e-009        lua=-8.4048098e-017
+ wua=3.5220678e-016        pua=-1.3285657e-023       ub=2.8755669e-018
+ lub=-5.1877354e-026       wub=-4.3131269e-025       pub=8.4312821e-032
+ uc=7.7766667e-011         wuc=2.23445e-017          vsat=100000
+ a0=4.1015897              lvsat=0+dlvsatp_lvt       pvsat=0+dpvsatp_lvt
+ la0=-3.7412094e-007       wa0=4.4203805e-007        pa0=3.5683911e-013
+ ags=1.1027054             lags=7.7513277e-007       wags=-1.1625524e-007
+ pags=5.4505258e-014       a1=0                      a2=1
+ b0=0                      b1=0                      keta=-0.1934
+ wketa=1.34067e-007        dwg=0                     dwb=0
+ pclm=1.2                  pdiblc1=0                 pdiblc2=0.0041467619
+ lpdiblc2=-1.7024381e-010  wpdiblc2=-1.4683529e-009  ppdiblc2=1.7032893e-015
+ pdiblcb=0                 drout=0                   pvag=2
+ delta=0.01                pscbe1=9.264e008          pscbe2=1e-020
+ fprout=1000               pdits=0                   pditsd=0
+ pditsl=0                  rdsw=210                  prwg=0
+ prwb=0                    wr=1                      alpha0=0
+ agidl=9e-008              bgidl=2.3e009             cgidl=0.5
+ egidl=0.53                aigbacc=0.0117            bigbacc=0.0049
+ cigbacc=0.1498            nigbacc=2.025             aigbinv=0.35
+ bigbinv=0.03              cigbinv=0.006             eigbinv=1.1
+ nigbinv=1                 aigc=0.005997             bigc=0.0007088
+ cigc=5e-011               aigsd=0.00469             bigsd=9.291e-005
+ cigsd=0.001372            nigc=1                    poxedge=1
+ pigcd=2.3                 ntox=ntoxp_lvt            xrcrg1=12
+ xrcrg2=1                  cgso=cgop_lvt             cgdo=cgop_lvt
+ cgbo=0                    cgdl=cglp_lvt             cgsl=cglp_lvt
+ clc=1e-007                cle=0.6                   cf=cfp_lvt
+ ckappas=0.6               moin=11.09                noff=2.175
+ voffcv=-0.03885           kt1=-0.23371429           lkt1=-3.0491429e-008
+ kt1l=0                    kt2=-0.03875              ute=-1.1749055
+ lute=-1.0980726e-008      wute=-2.4106523e-007      pute=1.0986216e-013
+ ua1=3.0746448e-009        lua1=-6.1490412e-016      wua1=-1.0221013e-015
+ pua1=6.6854106e-022       ub1=-5.9220603e-018       lub1=1.2006178e-024
+ wub1=1.1491776e-024       pub1=-1.2280716e-030      uc1=-9.2470457e-011
+ luc1=4.2370381e-017       wuc1=-3.8687906e-018      puc1=-4.2582233e-023
+ prt=0                     at=237305.24              lat=-0.0084740762
+ wat=-0.0073417643         pat=8.5164466e-009        njs=1
+ ijthsfwd=0.01             ijthsrev=0.01             bvs=10
+ xjbvs=1                   cjs=cjp_lvt               cjsws=cjswp_lvt
+ cjswgs=cjswgp_lvt         xtis=3                    dmcg=9.25e-008
+ dmci=9.25e-008            dmdg=0                    dmcgt=0
+ dwj=0                     xgw=0                     xgl=0
+ rshg=0.1                  gbmin=1e-012              rbpb=50
+ rbpd=50                   rbps=50                   rbdb=50
+ rbsb=50                   rsh=9.68                  acde=1.2
+ dlc=1.53e-008             beta0=8                   alpha1=0.003
+ jswgs=3.00e-12            jsws=3.47e-13             jss=1.56e-07
+ tpbswg=1.9e-03            tcjswg=4.01e-03           tpbsw=1.9e-03
+ tcjsw=1.9e-04             tpb=1.9e-03               tcj=8.55e-04
+ pbswgs=0.7                pbsws=0.8                 pbs=0.8
+ mjswgs=0.98               mjsws=0.01                mjs=0.36
+ ngcon=1                   saref=0.63e-6             sbref=0.63e-6
+ kvsat=-0.5                wlod=0.8e-6               tku0=0.1
+ ku0=1.3249e-7             llodku0=1                 wlodku0=1
+ lku0=1.33e-7              wku0=6.5e-7               pku0=0
+ kvth0=-1.5e-9             stk2=4e-10                steta0=0
+ lkvth0=-1.68e-15          wkvth0=0.5e-6             pkvth0=0
+ llodvth=2                 wlodvth=1                 lodk2=2
+ lodeta0=1                 fnoimod=1                 tnoimod=0
+ noia=1.40e42              noib=8.00e26              noic=8.75
+ wpemod=wpeflag_lvt        kvth0we=-0.0028           lkvth0we=0
+ wkvth0we=0                pkvth0we=0                ku0we=-0.0045
+ lku0we=2.60e-10           wku0we=0                  pku0we=0
+ k2we=0.00045              wk2we=0                   web=-180
+ wec=-3000                 scref=1.00e-06            ud=0
+ em=1.00e07                ef=1.17                   minr=1e-3

     9: type=p
+ lmin=2.4000e-07-dxlp_lvt  lmax=5.0000e-07-dxlp_lvt  wmin=1.0000e-06-dxwp_lvt
+ wmax=1.0000e-05-dxwp_lvt  version=4.5               binunit=2
+ paramchk=1                mobmod=0                  capmod=2
+ igcmod=1                  igbmod=1                  diomod=1
+ rdsmod=0                  rbodymod=0                rgatemod=0
+ permod=1                  acnqsmod=0                trnqsmod=0
+ tnom=25                   toxe=toxp_lvt             toxm=toxp_lvt
+ dtox=5e-010               epsrox=3.9                wint=5e-009
+ lint=2.5e-009             ll=0                      wl=0
+ lln=1                     wln=1                     lw=0
+ ww=0                      lwn=1                     wwn=1
+ lwl=0                     wwl=0                     llc=0
+ wlc=0                     lwc=0                     wwc=0
+ lwlc=0                    wwlc=0                    dwc=0
+ xpart=1                   toxref=3e-009             dlcig=2.5e-009
+ xl=-3.5e-8+dxlp_lvt       xw=1.5e-8+dxwp_lvt        vth0=-0.16371831+dvthp_lvt
+ lvth0=-7.8671795e-011+dlvthp_lvt                    wvth0=7.2189923e-010+dwvthp_lvt
+ pvth0=7.9065154e-017+dpvthp_lvt                     k1=0.15
+ k2=0.032098313+dk2p_lvt   lk2=-8.1197572e-009       wk2=-5.2011121e-009
+ pk2=3.3681756e-016        k3=-0.58                  k3b=0.8
+ w0=0                      dvt0=20                   dvt1=1.8
+ dvt2=-0.032               dvt0w=0                   dvt1w=0
+ dvt2w=0                   dsub=0.5                  minv=0
+ voffl=0                   dvtp0=5.5e-007            dvtp1=5
+ lpe0=0                    lpeb=4.5e-007             xj=1.7000001e-007
+ ngate=8e019               ndep=1.7200001e017        nsd=1e020
+ phin=0                    cdsc=0                    cdscb=0
+ cdscd=0                   cit=-0.00076923077        lcit=3.5384615e-010
+ voff=-0.10457051          lvoff=-1.975641e-010+dlvoffp_lvt
+ wvoff=-4.2970192e-009     pvoff=1.9766288e-015+dpvoffp_lvt
+ nfactor=1                 eta0=0.148325+deta0p_lvt  leta0=2.5683333e-009
+ weta0=1.6758375e-008      peta0=-2.5696175e-014+dpeta0p_lvt
+ etab=-0.06                u0=0.0076673297           lu0=-4.6715949e-011
+ wu0=-1.3028562e-010       pu0=-1.4152663e-016       ua=-1.2754825e-009
+ lua=-1.3263569e-017       wua=2.9651151e-016        pua=1.2334164e-023
+ ub=2.7651297e-018         lub=-1.0762821e-027       wub=-1.4059847e-025
+ pub=-4.9415721e-032       uc=6.0664103e-011         luc=7.8671795e-018
+ wuc=3.9532577e-017        puc=-7.9065154e-024       vsat=100000
+ lvsat=0+dlvsatp_lvt       pvsat=0+dpvsatp_lvt       a0=2.2460731
+ la0=4.7941672e-007        wa0=3.2562812e-006        pa0=-9.3771272e-013
+ ags=0.39680615            lags=1.0998464e-006       wags=-7.9615172e-007
+ pags=3.6725764e-013       a1=0                      a2=1
+ b0=0                      b1=0                      keta=-0.1934
+ wketa=1.34067e-007        dwg=0                     dwb=0
+ pclm=1.5846154            lpclm=-1.7692308e-007     pdiblc1=0
+ pdiblc2=0.0061702564      lpdiblc2=-1.1010513e-009  wpdiblc2=1.3750462e-009
+ ppdiblc2=3.9532577e-016   pdiblcb=0                 drout=0
+ pvag=2                    delta=0.01                pscbe1=9.264e008
+ pscbe2=1e-020             fprout=1000               pdits=0
+ pditsd=0                  pditsl=0                  rdsw=210
+ prwg=0                    prwb=0                    wr=1
+ alpha0=0                  agidl=9e-008              bgidl=2.3e009
+ cgidl=0.5                 egidl=0.53                aigbacc=0.0117
+ bigbacc=0.0049            cigbacc=0.1498            nigbacc=2.025
+ aigbinv=0.35              bigbinv=0.03              cigbinv=0.006
+ eigbinv=1.1               nigbinv=1                 aigc=0.005997
+ bigc=0.0007088            cigc=5e-011               aigsd=0.00469
+ bigsd=9.291e-005          cigsd=0.001372            nigc=1
+ poxedge=1                 pigcd=2.3                 ntox=ntoxp_lvt
+ xrcrg1=12                 xrcrg2=1                  cgso=cgop_lvt
+ cgdo=cgop_lvt             cgbo=0                    cgdl=cglp_lvt
+ cgsl=cglp_lvt             clc=1e-007                cle=0.6
+ cf=cfp_lvt                ckappas=0.6               moin=11.09
+ noff=2.175                voffcv=-0.03885           kt1=-0.30171795
+ lkt1=7.9025641e-010       wkt1=1.7188077e-008       pkt1=-7.9065154e-015
+ kt1l=0                    kt2=-0.03875              ute=-1.5241654
+ lute=1.4967881e-007       wute=1.778966e-007        pute=-8.2860281e-014
+ ua1=7.3010436e-010        lua1=4.6358446e-016       wua1=1.1479917e-015
+ pua1=-3.2970169e-022      ub1=-2.6916319e-018       lub1=-2.8537928e-025
+ wub1=-2.1324388e-024      pub1=2.8147195e-031       uc1=-3.253959e-012
+ luc1=1.3307918e-018       wuc1=-6.749414e-017       puc1=-1.3314572e-023
+ prt=0                     at=341139.74              lat=-0.056237949
+ wat=-0.057580058          pat=3.1626062e-008        njs=1
+ ijthsfwd=0.01             ijthsrev=0.01             bvs=10
+ xjbvs=1                   cjs=cjp_lvt               cjsws=cjswp_lvt
+ cjswgs=cjswgp_lvt         xtis=3                    dmcg=9.25e-008
+ dmci=9.25e-008            dmdg=0                    dmcgt=0
+ dwj=0                     xgw=0                     xgl=0
+ rshg=0.1                  gbmin=1e-012              rbpb=50
+ rbpd=50                   rbps=50                   rbdb=50
+ rbsb=50                   rsh=9.68                  acde=1.2
+ dlc=1.53e-008             beta0=8                   alpha1=0.003
+ jswgs=3.00e-12            jsws=3.47e-13             jss=1.56e-07
+ tpbswg=1.9e-03            tcjswg=4.01e-03           tpbsw=1.9e-03
+ tcjsw=1.9e-04             tpb=1.9e-03               tcj=8.55e-04
+ pbswgs=0.7                pbsws=0.8                 pbs=0.8
+ mjswgs=0.98               mjsws=0.01                mjs=0.36
+ ngcon=1                   saref=0.63e-6             sbref=0.63e-6
+ kvsat=-0.5                wlod=0.8e-6               tku0=0.1
+ ku0=1.3249e-7             llodku0=1                 wlodku0=1
+ lku0=1.33e-7              wku0=6.5e-7               pku0=0
+ kvth0=-1.5e-9             stk2=4e-10                steta0=0
+ lkvth0=-1.68e-15          wkvth0=0.5e-6             pkvth0=0
+ llodvth=2                 wlodvth=1                 lodk2=2
+ lodeta0=1                 fnoimod=1                 tnoimod=0
+ noia=1.40e42              noib=8.00e26              noic=8.75
+ wpemod=wpeflag_lvt        kvth0we=-0.0028           lkvth0we=0
+ wkvth0we=0                pkvth0we=0                ku0we=-0.0045
+ lku0we=2.60e-10           wku0we=0                  pku0we=0
+ k2we=0.00045              wk2we=0                   web=-180
+ wec=-3000                 scref=1.00e-06            ud=0
+ em=1.00e07                ef=1.17                   minr=1e-3

     10: type=p
+ lmin=1.0e-07              lmax=2.4000e-07-dxlp_lvt  wmin=1.0000e-06-dxwp_lvt
+ wmax=1.0000e-05-dxwp_lvt  version=4.5               binunit=2
+ paramchk=1                mobmod=0                  capmod=2
+ igcmod=1                  igbmod=1                  diomod=1
+ rdsmod=0                  rbodymod=0                rgatemod=0
+ permod=1                  acnqsmod=0                trnqsmod=0
+ tnom=25                   toxe=toxp_lvt             toxm=toxp_lvt
+ dtox=5e-010               epsrox=3.9                wint=5e-009
+ lint=2.5e-009             ll=0                      wl=0
+ lln=1                     wln=1                     lw=0
+ ww=0                      lwn=1                     wwn=1
+ lwl=0                     wwl=0                     llc=0
+ wlc=0                     lwc=0                     wwc=0
+ lwlc=0                    wwlc=0                    dwc=0
+ xpart=1                   toxref=3e-009             dlcig=2.5e-009
+ xl=-3.5e-8+dxlp_lvt       xw=1.5e-8+dxwp_lvt        vth0=-0.16659167+dvthp_lvt
+ lvth0=4.96e-010+dlvthp_lvt                          wvth0=8.7781964e-009+dwvthp_lvt
+ pvth0=-1.5321943e-015+dpvthp_lvt                    k1=0.15
+ k2=0.005013181+dk2p_lvt   lk2=-2.7027309e-009       wk2=-1.3738675e-008
+ pk2=2.0443302e-015        k3=-0.58                  k3b=0.8
+ w0=0                      dvt0=20                   dvt1=1.8
+ dvt2=-0.061142857         ldvt2=5.8285714e-009      dvt0w=0
+ dvt1w=0                   dvt2w=0                   dsub=0.5
+ minv=0                    voffl=0                   dvtp0=5.5e-007
+ dvtp1=5                   lpe0=0                    lpeb=4.5e-007
+ xj=1.7000001e-007         ngate=8e019               ndep=1.7200001e017
+ nsd=1e020                 phin=0                    cdsc=0
+ cdscb=0                   cdscd=0                   cit=-0.0013573571
+ lcit=4.7147143e-010       wcit=4.3092964e-010       pcit=-8.6185929e-017
+ voff=-0.1015119           lvoff=-8.0928571e-010+dlvoffp_lvt
+ wvoff=7.9801786e-009      pvoff=-4.7881071e-016+dpvoffp_lvt
+ nfactor=1.0714643         lnfactor=-1.4292857e-008  wnfactor=-7.1821607e-008
+ pnfactor=1.4364321e-014   eta0=0.16523024+deta0p_lvt
+ leta0=-8.1271429e-010     weta0=-1.4380282e-007     peta0=6.4160636e-015+dpeta0p_lvt
+ etab=-0.077430857         letab=3.4861714e-009      wetab=4.5965829e-009
+ petab=-9.1931657e-016     u0=0.0082584571           lu0=-1.6494143e-010
+ wu0=-7.2779229e-010       pu0=-2.2025293e-017       ua=-1.3386383e-009
+ lua=-6.324e-019           wua=5.495151e-016         pua=-3.8266552e-023
+ ub=2.7853919e-018         lub=-5.1287143e-027       wub=-5.3275672e-025
+ pub=2.9015929e-032        uc=7.9473429e-011         luc=4.1053143e-018
+ wuc=5.5542043e-018        puc=-1.1108409e-024       vsat=100000
+ lvsat=0+dlvsatp_lvt       pvsat=0+dpvsatp_lvt       a0=2.292281
+ la0=4.7017514e-007        wa0=-2.3525566e-006       pa0=1.8405484e-013
+ ags=1.2549833             lags=9.28211e-007         wags=-7.6450111e-007
+ pags=3.6092752e-013       a1=0                      a2=1
+ b0=0                      b1=0                      keta=-0.25385664
+ lketa=1.2091329e-008      wketa=1.9051878e-007      pketa=-1.1290357e-014
+ dwg=0                     dwb=0                     pclm=0.89000929
+ lpclm=-3.8001857e-008     wpclm=-1.8673618e-008     ppclm=3.7347236e-015
+ pdiblc1=0                 pdiblc2=0.00054057143     lpdiblc2=2.4885714e-011
+ wpdiblc2=4.5965829e-009   ppdiblc2=-2.4898157e-016  pdiblcb=0
+ drout=0                   pvag=2                    delta=0.01
+ pscbe1=9.264e008          pscbe2=1e-020             fprout=1000
+ pdits=0                   pditsd=0                  pditsl=0
+ rdsw=210                  prwg=0                    prwb=0
+ wr=1                      alpha0=0                  agidl=9e-008
+ bgidl=2.3e009             cgidl=0.5                 egidl=0.53
+ aigbacc=0.0117            bigbacc=0.0049            cigbacc=0.1498
+ nigbacc=2.025             aigbinv=0.35              bigbinv=0.03
+ cigbinv=0.006             eigbinv=1.1               nigbinv=1
+ aigc=0.005997             bigc=0.0007088            cigc=5e-011
+ aigsd=0.00469             bigsd=9.291e-005          cigsd=0.001372
+ nigc=1                    poxedge=1                 pigcd=2.3
+ ntox=ntoxp_lvt            xrcrg1=12                 xrcrg2=1
+ cgso=cgop_lvt             cgdo=cgop_lvt             cgbo=0
+ cgdl=cglp_lvt             cgsl=cglp_lvt             clc=1e-007
+ cle=0.6                   cf=cfp_lvt                ckappas=0.6
+ moin=11.09                noff=2.175                voffcv=-0.03885
+ kt1=-0.24109524           lkt1=-1.1334286e-008      wkt1=-3.1920714e-008
+ pkt1=1.9152429e-015       kt1l=0                    kt2=-0.03875
+ ute=-0.75883276           lute=-3.3877143e-009      wute=-2.0863379e-007
+ pute=-5.5542043e-015      ua1=3.5041517e-009        lua1=-9.1225e-017
+ wua1=-3.6884385e-016      pua1=-2.6334589e-023      ub1=-4.9439412e-018
+ lub1=1.6508257e-025       wub1=-9.4820482e-025      pub1=4.4625159e-032
+ uc1=3.4e-012              wuc1=-1.34067e-016        prt=0
+ at=59487.157              lat=9.2568571e-005        wat=0.13116541
+ pat=-6.1230314e-009       njs=1                     ijthsfwd=0.01
+ ijthsrev=0.01             bvs=10                    xjbvs=1
+ cjs=cjp_lvt               cjsws=cjswp_lvt           cjswgs=cjswgp_lvt
+ xtis=3                    dmcg=9.25e-008            dmci=9.25e-008
+ dmdg=0                    dmcgt=0                   dwj=0
+ xgw=0                     xgl=0                     rshg=0.1
+ gbmin=1e-012              rbpb=50                   rbpd=50
+ rbps=50                   rbdb=50                   rbsb=50
+ rsh=9.68                  acde=1.2                  dlc=1.53e-008
+ beta0=8                   alpha1=0.003              jswgs=3.00e-12
+ jsws=3.47e-13             jss=1.56e-07              tpbswg=1.9e-03
+ tcjswg=4.01e-03           tpbsw=1.9e-03             tcjsw=1.9e-04
+ tpb=1.9e-03               tcj=8.55e-04              pbswgs=0.7
+ pbsws=0.8                 pbs=0.8                   mjswgs=0.98
+ mjsws=0.01                mjs=0.36                  ngcon=1
+ saref=0.63e-6             sbref=0.63e-6             kvsat=-0.5
+ wlod=0.8e-6               tku0=0.1                  ku0=1.3249e-7
+ llodku0=1                 wlodku0=1                 lku0=1.33e-7
+ wku0=6.5e-7               pku0=0                    kvth0=-1.5e-9
+ stk2=4e-10                steta0=0                  lkvth0=-1.68e-15
+ wkvth0=0.5e-6             pkvth0=0                  llodvth=2
+ wlodvth=1                 lodk2=2                   lodeta0=1
+ fnoimod=1                 tnoimod=0                 noia=1.40e42
+ noib=8.00e26              noic=8.75                 wpemod=wpeflag_lvt
+ kvth0we=-0.0028           lkvth0we=0                wkvth0we=0
+ pkvth0we=0                ku0we=-0.0045             lku0we=2.60e-10
+ wku0we=0                  pku0we=0                  k2we=0.00045
+ wk2we=0                   web=-180                  wec=-3000
+ scref=1.00e-06            ud=0                      em=1.00e07
+ ef=1.17                   minr=1e-3

     11: type=p
+ lmin=1.0000e-05-dxlp_lvt  lmax=2.001e-05            wmin=5.0000e-07-dxwp_lvt
+ wmax=1.0000e-06-dxwp_lvt  version=4.5               binunit=2
+ paramchk=1                mobmod=0                  capmod=2
+ igcmod=1                  igbmod=1                  diomod=1
+ rdsmod=0                  rbodymod=0                rgatemod=0
+ permod=1                  acnqsmod=0                trnqsmod=0
+ tnom=25                   toxe=toxp_lvt             toxm=toxp_lvt
+ dtox=5e-010               epsrox=3.9                wint=5e-009
+ lint=2.5e-009             ll=0                      wl=0
+ lln=1                     wln=1                     lw=0
+ ww=0                      lwn=1                     wwn=1
+ lwl=0                     wwl=0                     llc=0
+ wlc=0                     lwc=0                     wwc=0
+ lwlc=0                    wwlc=0                    dwc=0
+ xpart=1                   toxref=3e-009             dlcig=2.5e-009
+ xl=-3.5e-8+dxlp_lvt       xw=1.5e-8+dxwp_lvt        vth0=-0.15699+dvthp_lvt
+ wvth0=-1.01505e-009+dwvthp_lvt                      lvth0=0+dlvthp_lvt
+ pvth0=0+dpvthp_lvt        k1=0.15                   k2=0.0168765+dk2p_lvt
+ wk2=-2.6898825e-009       k3=-0.58                  k3b=0.8
+ w0=0                      dvt0=20                   dvt1=1.8
+ dvt2=-0.032               dvt0w=0                   dvt1w=0
+ dvt2w=0                   dsub=0.5                  minv=0
+ voffl=0                   dvtp0=5.5e-007            dvtp1=5.505
+ wdvtp1=-5.07525e-007      lpe0=0                    lpeb=4.5e-007
+ xj=1.7000001e-007         ngate=8e019               ndep=1.7200001e017
+ nsd=1e020                 phin=0                    cdsc=0
+ cdscb=0                   cdscd=0                   cit=0
+ voff=-0.10005             wvoff=5.07525e-009        lvoff=0+dlvoffp_lvt
+ pvoff=0+dpvoffp_lvt       nfactor=0.5               eta0=0.115+deta0p_lvt
+ etab=-0.06                u0=0.0068553              peta0=0+dpeta0p_lvt
+ wu0=4.770735e-010         ua=-5.74998e-010          wua=1.8250599e-016
+ ub=2.2036e-018            wub=-2.63913e-025         uc=8.03e-011
+ wuc=-3.04515e-017         vsat=100000               a0=2.98105
+ lvsat=0+dlvsatp_lvt       pvsat=0+dpvsatp_lvt       wa0=1.9793475e-007
+ ags=1.26337               wags=-3.755685e-008       a1=0
+ a2=1                      b0=0                      b1=0
+ keta=-0.0398              wketa=-2.0301e-008        dwg=0
+ dwb=0                     pclm=2.109                wpclm=-9.13545e-007
+ pdiblc1=0                 pdiblc2=0.001             pdiblcb=0
+ drout=0                   pvag=2                    delta=0.01
+ pscbe1=9.264e008          pscbe2=1e-020             fprout=1000
+ pdits=0                   pditsd=0                  pditsl=0
+ rdsw=210                  prwg=0                    prwb=0
+ wr=1                      alpha0=0                  agidl=9e-008
+ bgidl=2.3e009             cgidl=0.5                 egidl=0.53
+ aigbacc=0.0117            bigbacc=0.0049            cigbacc=0.1498
+ nigbacc=2.025             aigbinv=0.35              bigbinv=0.03
+ cigbinv=0.006             eigbinv=1.1               nigbinv=1
+ aigc=0.005997             bigc=0.0007088            cigc=5e-011
+ aigsd=0.00469             bigsd=9.291e-005          cigsd=0.001372
+ nigc=1                    poxedge=1                 pigcd=2.3
+ ntox=ntoxp_lvt            xrcrg1=12                 xrcrg2=1
+ cgso=cgop_lvt             cgdo=cgop_lvt             cgbo=0
+ cgdl=cglp_lvt             cgsl=cglp_lvt             clc=1e-007
+ cle=0.6                   cf=cfp_lvt                ckappas=0.6
+ moin=11.09                noff=2.175                voffcv=-0.03885
+ kt1=-0.2197               wkt1=-3.04515e-008        kt1l=0
+ kt2=-0.03875              ute=-1.20472              wute=-2.314314e-007
+ ua1=1.68795e-009          wua1=2.0808525e-016       ub1=-3.71484e-018
+ wub1=-1.3358058e-024      uc1=-9.632e-011           prt=0
+ at=230000                 njs=1                     ijthsfwd=0.01
+ ijthsrev=0.01             bvs=10                    xjbvs=1
+ cjs=cjp_lvt               cjsws=cjswp_lvt           cjswgs=cjswgp_lvt
+ xtis=3                    dmcg=9.25e-008            dmci=9.25e-008
+ dmdg=0                    dmcgt=0                   dwj=0
+ xgw=0                     xgl=0                     rshg=0.1
+ gbmin=1e-012              rbpb=50                   rbpd=50
+ rbps=50                   rbdb=50                   rbsb=50
+ rsh=9.68                  acde=1.2                  dlc=1.53e-008
+ beta0=8                   alpha1=0.003              jswgs=3.00e-12
+ jsws=3.47e-13             jss=1.56e-07              tpbswg=1.9e-03
+ tcjswg=4.01e-03           tpbsw=1.9e-03             tcjsw=1.9e-04
+ tpb=1.9e-03               tcj=8.55e-04              pbswgs=0.7
+ pbsws=0.8                 pbs=0.8                   mjswgs=0.98
+ mjsws=0.01                mjs=0.36                  ngcon=1
+ saref=0.63e-6             sbref=0.63e-6             kvsat=-0.5
+ wlod=0.8e-6               tku0=0.1                  ku0=1.3249e-7
+ llodku0=1                 wlodku0=1                 lku0=1.33e-7
+ wku0=6.5e-7               pku0=0                    kvth0=-1.5e-9
+ stk2=4e-10                steta0=0                  lkvth0=-1.68e-15
+ wkvth0=0.5e-6             pkvth0=0                  llodvth=2
+ wlodvth=1                 lodk2=2                   lodeta0=1
+ fnoimod=1                 tnoimod=0                 noia=1.40e42
+ noib=8.00e26              noic=8.75                 wpemod=wpeflag_lvt
+ kvth0we=-0.0028           lkvth0we=0                wkvth0we=0
+ pkvth0we=0                ku0we=-0.0045             lku0we=2.60e-10
+ wku0we=0                  pku0we=0                  k2we=0.00045
+ wk2we=0                   web=-180                  wec=-3000
+ scref=1.00e-06            ud=0                      em=1.00e07
+ ef=1.17                   minr=1e-3

     12: type=p
+ lmin=1.2000e-06-dxlp_lvt  lmax=1.0000e-05-dxlp_lvt  wmin=5.0000e-07-dxwp_lvt
+ wmax=1.0000e-06-dxwp_lvt  version=4.5               binunit=2
+ paramchk=1                mobmod=0                  capmod=2
+ igcmod=1                  igbmod=1                  diomod=1
+ rdsmod=0                  rbodymod=0                rgatemod=0
+ permod=1                  acnqsmod=0                trnqsmod=0
+ tnom=25                   toxe=toxp_lvt             toxm=toxp_lvt
+ dtox=5e-010               epsrox=3.9                wint=5e-009
+ lint=2.5e-009             ll=0                      wl=0
+ lln=1                     wln=1                     lw=0
+ ww=0                      lwn=1                     wwn=1
+ lwl=0                     wwl=0                     llc=0
+ wlc=0                     lwc=0                     wwc=0
+ lwlc=0                    wwlc=0                    dwc=0
+ xpart=1                   toxref=3e-009             dlcig=2.5e-009
+ xl=-3.5e-8+dxlp_lvt       xw=1.5e-8+dxwp_lvt        vth0=-0.15605132+dvthp_lvt
+ lvth0=-9.3492256e-009+dlvthp_lvt                    wvth0=-1.2960343e-009+dwvthp_lvt
+ pvth0=2.7986036e-015+dpvthp_lvt                     k1=0.15
+ k2=0.016549723+dk2p_lvt   lk2=3.2547016e-009        wk2=-2.9708668e-009
+ pk2=2.7986036e-015        k3=-0.58                  k3b=0.8
+ w0=0                      dvt0=20                   dvt1=1.8
+ dvt2=-0.032               dvt0w=0                   dvt1w=0
+ dvt2w=0                   dsub=0.5                  minv=0
+ voffl=0                   dvtp0=5.5e-007            dvtp1=5.5715682
+ ldvtp1=-6.6301909e-007    wdvtp1=-5.7442602e-007    pdvtp1=6.6633419e-013
+ lpe0=0                    lpeb=4.5e-007             xj=1.7000001e-007
+ ngate=8e019               ndep=1.7200001e017        nsd=1e020
+ phin=0                    cdsc=0                    cdscb=0
+ cdscd=0                   cit=0                     voff=-0.0993975
+ lvoff=-6.4989e-009+dlvoffp_lvt                      wvoff=5.7442602e-009
+ pvoff=-6.6633419e-015+dpvoffp_lvt                   nfactor=0.5
+ eta0=0.115+deta0p_lvt     etab=-0.06                peta0=0+dpeta0p_lvt
+ u0=0.0067967464           lu0=5.8319422e-010        wu0=5.3327036e-010
+ pu0=-5.5972072e-016       ua=-5.3886084e-010        lua=-3.5992615e-016
+ wua=2.0733965e-016        pua=-2.4734325e-022       ub=2.1722167e-018
+ lub=3.125774e-025         wub=-3.029832e-025        pub=3.8913916e-031
+ uc=7.7703182e-011         luc=2.5864309e-017        wuc=-3.4465561e-017
+ puc=3.9980051e-023        vsat=100000               a0=2.7238754
+ lvsat=0+dlvsatp_lvt       pvsat=0+dpvsatp_lvt       la0=2.5614594e-006
+ wa0=2.7794837e-007        pa0=-7.9693569e-013       ags=1.2099441
+ lags=5.3212205e-007       wags=-4.6922993e-008      pags=9.3286786e-014
+ a1=0                      a2=1                      b0=0
+ b1=0                      keta=-0.049119545         lketa=9.2822673e-008
+ wketa=-1.0934857e-008     pketa=-9.3286786e-014     dwg=0
+ dwb=0                     pclm=2.2288227            lpclm=-1.1934344e-006
+ wpclm=-1.0339668e-006     ppclm=1.1994015e-012      pdiblc1=0
+ pdiblc2=0.00060454545     lpdiblc2=3.9387273e-009   pdiblcb=0
+ drout=0                   pvag=2                    delta=0.01
+ pscbe1=9.264e008          pscbe2=1e-020             fprout=1000
+ pdits=0                   pditsd=0                  pditsl=0
+ rdsw=210                  prwg=0                    prwb=0
+ wr=1                      alpha0=0                  agidl=9e-008
+ bgidl=2.3e009             cgidl=0.5                 egidl=0.53
+ aigbacc=0.0117            bigbacc=0.0049            cigbacc=0.1498
+ nigbacc=2.025             aigbinv=0.35              bigbinv=0.03
+ cigbinv=0.006             eigbinv=1.1               nigbinv=1
+ aigc=0.005997             bigc=0.0007088            cigc=5e-011
+ aigsd=0.00469             bigsd=9.291e-005          cigsd=0.001372
+ nigc=1                    poxedge=1                 pigcd=2.3
+ ntox=ntoxp_lvt            xrcrg1=12                 xrcrg2=1
+ cgso=cgop_lvt             cgdo=cgop_lvt             cgbo=0
+ cgdl=cglp_lvt             cgsl=cglp_lvt             clc=1e-007
+ cle=0.6                   cf=cfp_lvt                ckappas=0.6
+ moin=11.09                noff=2.175                voffcv=-0.03885
+ kt1=-0.21705045           lkt1=-2.6389473e-008      wkt1=-3.178952e-008
+ pkt1=1.3326684e-014       kt1l=0                    kt2=-0.03875
+ ute=-1.225484             lute=2.0680944e-007       wute=-2.2447369e-007
+ pute=-6.9298755e-014      ua1=1.5668012e-009        lua1=1.2066422e-015
+ wua1=3.0254949e-016       pua1=-9.4086387e-022      ub1=-3.5921621e-018
+ lub1=-1.221872e-024       wub1=-1.491819e-024       pub1=1.5538913e-030
+ uc1=-9.632e-011           prt=0                     at=230000
+ njs=1                     ijthsfwd=0.01             ijthsrev=0.01
+ bvs=10                    xjbvs=1                   cjs=cjp_lvt
+ cjsws=cjswp_lvt           cjswgs=cjswgp_lvt         xtis=3
+ dmcg=9.25e-008            dmci=9.25e-008            dmdg=0
+ dmcgt=0                   dwj=0                     xgw=0
+ xgl=0                     rshg=0.1                  gbmin=1e-012
+ rbpb=50                   rbpd=50                   rbps=50
+ rbdb=50                   rbsb=50                   rsh=9.68
+ acde=1.2                  dlc=1.53e-008             beta0=8
+ alpha1=0.003              jswgs=3.00e-12            jsws=3.47e-13
+ jss=1.56e-07              tpbswg=1.9e-03            tcjswg=4.01e-03
+ tpbsw=1.9e-03             tcjsw=1.9e-04             tpb=1.9e-03
+ tcj=8.55e-04              pbswgs=0.7                pbsws=0.8
+ pbs=0.8                   mjswgs=0.98               mjsws=0.01
+ mjs=0.36                  ngcon=1                   saref=0.63e-6
+ sbref=0.63e-6             kvsat=-0.5                wlod=0.8e-6
+ tku0=0.1                  ku0=1.3249e-7             llodku0=1
+ wlodku0=1                 lku0=1.33e-7              wku0=6.5e-7
+ pku0=0                    kvth0=-1.5e-9             stk2=4e-10
+ steta0=0                  lkvth0=-1.68e-15          wkvth0=0.5e-6
+ pkvth0=0                  llodvth=2                 wlodvth=1
+ lodk2=2                   lodeta0=1                 fnoimod=1
+ tnoimod=0                 noia=1.40e42              noib=8.00e26
+ noic=8.75                 wpemod=wpeflag_lvt        kvth0we=-0.0028
+ lkvth0we=0                wkvth0we=0                pkvth0we=0
+ ku0we=-0.0045             lku0we=2.60e-10           wku0we=0
+ pku0we=0                  k2we=0.00045              wk2we=0
+ web=-180                  wec=-3000                 scref=1.00e-06
+ ud=0                      em=1.00e07                ef=1.17
+ minr=1e-3

     13: type=p
+ lmin=5.0000e-07-dxlp_lvt  lmax=1.2000e-06-dxlp_lvt  wmin=5.0000e-07-dxwp_lvt
+ wmax=1.0000e-06-dxwp_lvt  version=4.5               binunit=2
+ paramchk=1                mobmod=0                  capmod=2
+ igcmod=1                  igbmod=1                  diomod=1
+ rdsmod=0                  rbodymod=0                rgatemod=0
+ permod=1                  acnqsmod=0                trnqsmod=0
+ tnom=25                   toxe=toxp_lvt             toxm=toxp_lvt
+ dtox=5e-010               epsrox=3.9                wint=5e-009
+ lint=2.5e-009             ll=0                      wl=0
+ lln=1                     wln=1                     lw=0
+ ww=0                      lwn=1                     wwn=1
+ lwl=0                     wwl=0                     llc=0
+ wlc=0                     lwc=0                     wwc=0
+ lwlc=0                    wwlc=0                    dwc=0
+ xpart=1                   toxref=3e-009             dlcig=2.5e-009
+ xl=-3.5e-8+dxlp_lvt       xw=1.5e-8+dxwp_lvt        vth0=-0.16948709+dvthp_lvt
+ lvth0=6.2362594e-009+dlvthp_lvt                     wvth0=6.5195211e-009+dwvthp_lvt
+ pvth0=-6.2674407e-015+dpvthp_lvt                    k1=0.15
+ k2=0.029153829+dk2p_lvt   lk2=-1.1366061e-008       wk2=-4.5938263e-009
+ pk2=4.6812366e-015        k3=-0.58                  k3b=0.8
+ w0=0                      dvt0=20                   dvt1=1.8
+ dvt2=-0.032               dvt0w=0                   dvt1w=0
+ dvt2w=0                   dsub=0.5                  minv=0
+ voffl=0                   dvtp0=5.5e-007            dvtp1=5
+ lpe0=0                    lpeb=4.5e-007             xj=1.7000001e-007
+ ngate=8e019               ndep=1.7200001e017        nsd=1e020
+ phin=0                    cdsc=0                    cdscb=0
+ cdscd=0                   cit=0                     voff=-0.105
+ lvoff=0+dlvoffp_lvt       pvoff=0+dpvoffp_lvt       nfactor=0.17142857
+ lnfactor=3.8114286e-007   eta0=0.115+deta0p_lvt     peta0=0+dpeta0p_lvt
+ etab=-0.06                u0=0.0075768143           lu0=-3.2168457e-010
+ wu0=-8.2654071e-011       pu0=1.5475162e-016        ua=-7.4093226e-010
+ lua=-1.255233e-016        wua=-3.0367396e-017       pua=2.8396923e-023
+ ub=2.4472657e-018         lub=-6.4794286e-027       wub=-8.7004286e-028
+ pub=3.8687906e-032        uc=1e-010                 vsat=100000
+ lvsat=0+dlvsatp_lvt       pvsat=0+dpvsatp_lvt       a0=5.191378
+ la0=-3.0084368e-007       wa0=-6.5319918e-007       pa0=2.8319547e-013
+ ags=1.0439637             lags=7.2465929e-007       wags=-5.7219819e-008
+ pags=1.052311e-013        a1=0                      a2=1
+ b0=0                      b1=0                      keta=0.0309
+ wketa=-9.13545e-008       dwg=0                     dwb=0
+ pclm=1.2                  pdiblc1=0                 pdiblc2=0.0053405714
+ lpdiblc2=-1.5550629e-009  wpdiblc2=-2.6681314e-009  ppdiblc2=3.0950325e-015
+ pdiblcb=0                 drout=0                   pvag=2
+ delta=0.01                pscbe1=9.264e008          pscbe2=1e-020
+ fprout=1000               pdits=0                   pditsd=0
+ pditsl=0                  rdsw=210                  prwg=0
+ prwb=0                    wr=1                      alpha0=0
+ agidl=9e-008              bgidl=2.3e009             cgidl=0.5
+ egidl=0.53                aigbacc=0.0117            bigbacc=0.0049
+ cigbacc=0.1498            nigbacc=2.025             aigbinv=0.35
+ bigbinv=0.03              cigbinv=0.006             eigbinv=1.1
+ nigbinv=1                 aigc=0.005997             bigc=0.0007088
+ cigc=5e-011               aigsd=0.00469             bigsd=9.291e-005
+ cigsd=0.001372            nigc=1                    poxedge=1
+ pigcd=2.3                 ntox=ntoxp_lvt            xrcrg1=12
+ xrcrg2=1                  cgso=cgop_lvt             cgdo=cgop_lvt
+ cgbo=0                    cgdl=cglp_lvt             cgsl=cglp_lvt
+ clc=1e-007                cle=0.6                   cf=cfp_lvt
+ ckappas=0.6               moin=11.09                noff=2.175
+ voffcv=-0.03885           kt1=-0.18696571           lkt1=-6.1287771e-008
+ wkt1=-4.6982314e-008      pkt1=3.0950325e-014       kt1l=0
+ kt2=-0.03875              ute=-0.921574             lute=-1.4572616e-007
+ wute=-4.9566342e-007      pute=2.4528132e-013       ua1=2.8145226e-009
+ lua1=-2.4071458e-016      wua1=-7.6067847e-016      pua1=2.9248057e-022
+ ub1=-4.3178091e-018       lub1=-3.8012139e-025      wub1=-4.6309481e-025
+ pub1=3.6057128e-031       uc1=-9.632e-011           prt=0
+ at=230000                 njs=1                     ijthsfwd=0.01
+ ijthsrev=0.01             bvs=10                    xjbvs=1
+ cjs=cjp_lvt               cjsws=cjswp_lvt           cjswgs=cjswgp_lvt
+ xtis=3                    dmcg=9.25e-008            dmci=9.25e-008
+ dmdg=0                    dmcgt=0                   dwj=0
+ xgw=0                     xgl=0                     rshg=0.1
+ gbmin=1e-012              rbpb=50                   rbpd=50
+ rbps=50                   rbdb=50                   rbsb=50
+ rsh=9.68                  acde=1.2                  dlc=1.53e-008
+ beta0=8                   alpha1=0.003              jswgs=3.00e-12
+ jsws=3.47e-13             jss=1.56e-07              tpbswg=1.9e-03
+ tcjswg=4.01e-03           tpbsw=1.9e-03             tcjsw=1.9e-04
+ tpb=1.9e-03               tcj=8.55e-04              pbswgs=0.7
+ pbsws=0.8                 pbs=0.8                   mjswgs=0.98
+ mjsws=0.01                mjs=0.36                  ngcon=1
+ saref=0.63e-6             sbref=0.63e-6             kvsat=-0.5
+ wlod=0.8e-6               tku0=0.1                  ku0=1.3249e-7
+ llodku0=1                 wlodku0=1                 lku0=1.33e-7
+ wku0=6.5e-7               pku0=0                    kvth0=-1.5e-9
+ stk2=4e-10                steta0=0                  lkvth0=-1.68e-15
+ wkvth0=0.5e-6             pkvth0=0                  llodvth=2
+ wlodvth=1                 lodk2=2                   lodeta0=1
+ fnoimod=1                 tnoimod=0                 noia=1.40e42
+ noib=8.00e26              noic=8.75                 wpemod=wpeflag_lvt
+ kvth0we=-0.0028           lkvth0we=0                wkvth0we=0
+ pkvth0we=0                ku0we=-0.0045             lku0we=2.60e-10
+ wku0we=0                  pku0we=0                  k2we=0.00045
+ wk2we=0                   web=-180                  wec=-3000
+ scref=1.00e-06            ud=0                      em=1.00e07
+ ef=1.17                   minr=1e-3

     14: type=p
+ lmin=2.4000e-07-dxlp_lvt  lmax=5.0000e-07-dxlp_lvt  wmin=5.0000e-07-dxwp_lvt
+ wmax=1.0000e-06-dxwp_lvt  version=4.5               binunit=2
+ paramchk=1                mobmod=0                  capmod=2
+ igcmod=1                  igbmod=1                  diomod=1
+ rdsmod=0                  rbodymod=0                rgatemod=0
+ permod=1                  acnqsmod=0                trnqsmod=0
+ tnom=25                   toxe=toxp_lvt             toxm=toxp_lvt
+ dtox=5e-010               epsrox=3.9                wint=5e-009
+ lint=2.5e-009             ll=0                      wl=0
+ lln=1                     wln=1                     lw=0
+ ww=0                      lwn=1                     wwn=1
+ lwl=0                     wwl=0                     llc=0
+ wlc=0                     lwc=0                     wwc=0
+ lwlc=0                    wwlc=0                    dwc=0
+ xpart=1                   toxref=3e-009             dlcig=2.5e-009
+ xl=-3.5e-8+dxlp_lvt       xw=1.5e-8+dxwp_lvt        vth0=-0.15826077+dvthp_lvt
+ lvth0=1.0721538e-009+dlvthp_lvt                     wvth0=-4.7629269e-009+dwvthp_lvt
+ pvth0=-1.0775146e-015+dpvthp_lvt                    k1=0.15
+ k2=0.022378077+dk2p_lvt   lk2=-8.2492154e-009       wk2=4.567725e-009
+ pk2=4.66923e-016          k3=-0.58                  k3b=0.8
+ w0=0                      dvt0=20                   dvt1=1.8
+ dvt2=-0.032               dvt0w=0                   dvt1w=0
+ dvt2w=0                   dsub=0.5                  minv=0
+ voffl=0                   dvtp0=5.5e-007            dvtp1=5
+ lpe0=0                    lpeb=4.5e-007             xj=1.7000001e-007
+ ngate=8e019               ndep=1.7200001e017        nsd=1e020
+ phin=0                    cdsc=0                    cdscb=0
+ cdscd=0                   cit=-0.0015461538         lcit=7.1123077e-010
+ wcit=7.8080769e-010       pcit=-3.5917154e-016      voff=-0.1205
+ lvoff=7.13e-009+dlvoffp_lvt                         wvoff=1.1712115e-008
+ pvoff=-5.3875731e-015+dpvoffp_lvt                   nfactor=1
+ eta0=0.165+deta0p_lvt     leta0=-2.3e-008           peta0=0+dpeta0p_lvt
+ etab=-0.06                u0=0.0067413462           lu0=6.2630769e-011
+ wu0=8.0032788e-010        pu0=-2.5142008e-016       ua=-1.169759e-009
+ lua=7.1737e-017           wua=1.9025941e-016        pua=-7.3091408e-023
+ ub=2.6371954e-018         lub=-9.3847077e-026       wub=-1.2024438e-026
+ pub=4.3818928e-032        uc=1e-010                 vsat=100000
+ lvsat=0+dlvsatp_lvt       pvsat=0+dpvsatp_lvt       a0=6.3680392
+ la0=-8.4210785e-007       wa0=-8.8629481e-007       pa0=3.9041946e-013
+ ags=-0.95919769           lags=1.6461135e-006       wags=5.6663214e-007
+ pags=-1.817408e-013       a1=0                      a2=1
+ b0=0                      b1=0                      keta=0.046438462
+ lketa=-7.1476923e-009     wketa=-1.0697065e-007     pketa=7.1834308e-015
+ dwg=0                     dwb=0                     pclm=1.5846154
+ lpclm=-1.7692308e-007     pdiblc1=0                 pdiblc2=0.0011676923
+ lpdiblc2=3.6446154e-010   wpdiblc2=6.4026231e-009   ppdiblc2=-1.0775146e-015
+ pdiblcb=0                 drout=0                   pvag=2
+ delta=0.01                pscbe1=9.264e008          pscbe2=1e-020
+ fprout=1000               pdits=0                   pditsd=0
+ pditsl=0                  rdsw=210                  prwg=0
+ prwb=0                    wr=1                      alpha0=0
+ agidl=9e-008              bgidl=2.3e009             cgidl=0.5
+ egidl=0.53                aigbacc=0.0117            bigbacc=0.0049
+ cigbacc=0.1498            nigbacc=2.025             aigbinv=0.35
+ bigbinv=0.03              cigbinv=0.006             eigbinv=1.1
+ nigbinv=1                 aigc=0.005997             bigc=0.0007088
+ cigc=5e-011               aigsd=0.00469             bigsd=9.291e-005
+ cigsd=0.001372            nigc=1                    poxedge=1
+ pigcd=2.3                 ntox=ntoxp_lvt            xrcrg1=12
+ xrcrg2=1                  cgso=cgop_lvt             cgdo=cgop_lvt
+ cgbo=0                    cgdl=cglp_lvt             cgsl=cglp_lvt
+ clc=1e-007                cle=0.6                   cf=cfp_lvt
+ ckappas=0.6               moin=11.09                noff=2.175
+ voffcv=-0.03885           kt1=-0.30481538           lkt1=-7.0769231e-009
+ wkt1=2.0301e-008          pkt1=1.9938026e-029       kt1l=0
+ kt2=-0.03875              ute=-1.5150469            lute=1.2727138e-007
+ wute=1.6873254e-007       pute=-6.0340818e-014      ua1=1.5421146e-009
+ lua1=3.4459308e-016       wua1=3.3192135e-016       pua1=-2.1011535e-022
+ ub1=-4.7433831e-018       lub1=-1.8435738e-025      wub1=-7.0428854e-026
+ pub1=1.7994494e-031       uc1=-4.4245538e-011       luc1=-2.3954252e-017
+ wuc1=-2.6297603e-017      puc1=1.2096897e-023       prt=0
+ at=283846.15              lat=-0.024769231          njs=1
+ ijthsfwd=0.01             ijthsrev=0.01             bvs=10
+ xjbvs=1                   cjs=cjp_lvt               cjsws=cjswp_lvt
+ cjswgs=cjswgp_lvt         xtis=3                    dmcg=9.25e-008
+ dmci=9.25e-008            dmdg=0                    dmcgt=0
+ dwj=0                     xgw=0                     xgl=0
+ rshg=0.1                  gbmin=1e-012              rbpb=50
+ rbpd=50                   rbps=50                   rbdb=50
+ rbsb=50                   rsh=9.68                  acde=1.2
+ dlc=1.53e-008             beta0=8                   alpha1=0.003
+ jswgs=3.00e-12            jsws=3.47e-13             jss=1.56e-07
+ tpbswg=1.9e-03            tcjswg=4.01e-03           tpbsw=1.9e-03
+ tcjsw=1.9e-04             tpb=1.9e-03               tcj=8.55e-04
+ pbswgs=0.7                pbsws=0.8                 pbs=0.8
+ mjswgs=0.98               mjsws=0.01                mjs=0.36
+ ngcon=1                   saref=0.63e-6             sbref=0.63e-6
+ kvsat=-0.5                wlod=0.8e-6               tku0=0.1
+ ku0=1.3249e-7             llodku0=1                 wlodku0=1
+ lku0=1.33e-7              wku0=6.5e-7               pku0=0
+ kvth0=-1.5e-9             stk2=4e-10                steta0=0
+ lkvth0=-1.68e-15          wkvth0=0.5e-6             pkvth0=0
+ llodvth=2                 wlodvth=1                 lodk2=2
+ lodeta0=1                 fnoimod=1                 tnoimod=0
+ noia=1.40e42              noib=8.00e26              noic=8.75
+ wpemod=wpeflag_lvt        kvth0we=-0.0028           lkvth0we=0
+ wkvth0we=0                pkvth0we=0                ku0we=-0.0045
+ lku0we=2.60e-10           wku0we=0                  pku0we=0
+ k2we=0.00045              wk2we=0                   web=-180
+ wec=-3000                 scref=1.00e-06            ud=0
+ em=1.00e07                ef=1.17                   minr=1e-3

     15: type=p
+ lmin=1.0e-07              lmax=2.4000e-07-dxlp_lvt  wmin=5.0000e-07-dxwp_lvt
+ wmax=1.0000e-06-dxwp_lvt  version=4.5               binunit=2
+ paramchk=1                mobmod=0                  capmod=2
+ igcmod=1                  igbmod=1                  diomod=1
+ rdsmod=0                  rbodymod=0                rgatemod=0
+ permod=1                  acnqsmod=0                trnqsmod=0
+ tnom=25                   toxe=toxp_lvt             toxm=toxp_lvt
+ dtox=5e-010               epsrox=3.9                wint=5e-009
+ lint=2.5e-009             ll=0                      wl=0
+ lln=1                     wln=1                     lw=0
+ ww=0                      lwn=1                     wwn=1
+ lwl=0                     wwl=0                     llc=0
+ wlc=0                     lwc=0                     wwc=0
+ lwlc=0                    wwlc=0                    dwc=0
+ xpart=1                   toxref=3e-009             dlcig=2.5e-009
+ xl=-3.5e-8+dxlp_lvt       xw=1.5e-8+dxwp_lvt        vth0=-0.14775714+dvthp_lvt
+ lvth0=-1.0285714e-009+dlvthp_lvt                    wvth0=-1.01505e-008+dwvthp_lvt
+ pvth0=-2.414854e-030+dpvthp_lvt                     k1=0.15
+ k2=-0.018122286+dk2p_lvt  lk2=-1.4914286e-010       wk2=9.5124686e-009
+ pk2=-5.2202571e-016       k3=-0.58                  k3b=0.8
+ w0=0                      dvt0=20                   dvt1=1.8
+ dvt2=-0.061142857         ldvt2=5.8285714e-009      dvt0w=0
+ dvt1w=0                   dvt2w=0                   dsub=0.5
+ minv=0                    voffl=0                   dvtp0=5.5e-007
+ dvtp1=5                   lpe0=0                    lpeb=4.5e-007
+ xj=1.7000001e-007         ngate=8e019               ndep=1.7200001e017
+ nsd=1e020                 phin=0                    cdsc=0
+ cdscb=0                   cdscd=0                   cit=0.00029785714
+ lcit=3.4242857e-010       wcit=-1.2325607e-009      pcit=4.3502143e-017
+ voff=-0.071928571         lvoff=-2.5842857e-009+dlvoffp_lvt
+ wvoff=-2.1751071e-008     pvoff=1.3050643e-015+dpvoffp_lvt
+ nfactor=1                 eta0=0.022142857+deta0p_lvt
+ peta0=0+dpeta0p_lvt       leta0=5.5714286e-009      etab=-0.072857143
+ letab=2.5714286e-009      u0=0.0081099857           lu0=-2.1109714e-010
+ wu0=-5.785785e-010        pu0=2.43612e-017          ua=-5.4282e-010
+ lua=-5.36508e-017         wua=-2.5028233e-016       pua=1.501694e-023
+ ub=1.9609429e-018         lub=4.1403429e-026        wub=2.9581457e-025
+ pub=-1.7748874e-032       uc=8.5e-011               luc=3e-018
+ vsat=100000               lvsat=0+dlvsatp_lvt       pvsat=0+dpvsatp_lvt
+ a0=-1.5635714             la0=7.4421429e-007        wa0=1.522575e-006
+ pa0=-9.13545e-014         ags=0.98052857            lags=1.2581683e-006
+ wags=-4.8867407e-007      pags=2.9320444e-014       a1=0
+ a2=1                      b0=0                      b1=0
+ keta=0.032385714          lketa=-4.3371429e-009     wketa=-9.7154786e-008
+ pketa=5.2202571e-015      dwg=0                     dwb=0
+ pclm=0.87142857           lpclm=-3.4285714e-008     pdiblc1=0
+ pdiblc2=0.0038012857      lpdiblc2=-1.6225714e-010  wpdiblc2=1.319565e-009
+ ppdiblc2=-6.0903e-017     pdiblcb=0                 drout=0
+ pvag=2                    delta=0.01                pscbe1=9.264e008
+ pscbe2=1e-020             fprout=1000               pdits=0
+ pditsd=0                  pditsl=0                  rdsw=210
+ prwg=0                    prwb=0                    wr=1
+ alpha0=0                  agidl=9e-008              bgidl=2.3e009
+ cgidl=0.5                 egidl=0.53                aigbacc=0.0117
+ bigbacc=0.0049            cigbacc=0.1498            nigbacc=2.025
+ aigbinv=0.35              bigbinv=0.03              cigbinv=0.006
+ eigbinv=1.1               nigbinv=1                 aigc=0.005997
+ bigc=0.0007088            cigc=5e-011               aigsd=0.00469
+ bigsd=9.291e-005          cigsd=0.001372            nigc=1
+ poxedge=1                 pigcd=2.3                 ntox=ntoxp_lvt
+ xrcrg1=12                 xrcrg2=1                  cgso=cgop_lvt
+ cgdo=cgop_lvt             cgbo=0                    cgdl=cglp_lvt
+ cgsl=cglp_lvt             clc=1e-007                cle=0.6
+ cf=cfp_lvt                ckappas=0.6               moin=11.09
+ noff=2.175                voffcv=-0.03885           kt1=-0.30171429
+ lkt1=-7.6971429e-009      wkt1=2.9001429e-008       pkt1=-1.7400857e-015
+ kt1l=0                    kt2=-0.03875              ute=-0.7601
+ lute=-2.3718e-008         wute=-2.0736021e-007      pute=1.4877733e-014
+ ua1=4.2777214e-009        lua1=-2.0252829e-016      wua1=-1.1462815e-015
+ pua1=8.5525213e-023       ub1=-7.2826714e-018       lub1=3.2350029e-025
+ wub1=1.4022191e-024       pub1=-1.1458464e-031      uc1=-1.7859543e-010
+ luc1=2.9157257e-018       wuc1=4.8838406e-017       puc1=-2.9303043e-024
+ prt=0                     at=190000                 lat=-0.006
+ njs=1                     ijthsfwd=0.01             ijthsrev=0.01
+ bvs=10                    xjbvs=1                   cjs=cjp_lvt
+ cjsws=cjswp_lvt           cjswgs=cjswgp_lvt         xtis=3
+ dmcg=9.25e-008            dmci=9.25e-008            dmdg=0
+ dmcgt=0                   dwj=0                     xgw=0
+ xgl=0                     rshg=0.1                  gbmin=1e-012
+ rbpb=50                   rbpd=50                   rbps=50
+ rbdb=50                   rbsb=50                   rsh=9.68
+ acde=1.2                  dlc=1.53e-008             beta0=8
+ alpha1=0.003              jswgs=3.00e-12            jsws=3.47e-13
+ jss=1.56e-07              tpbswg=1.9e-03            tcjswg=4.01e-03
+ tpbsw=1.9e-03             tcjsw=1.9e-04             tpb=1.9e-03
+ tcj=8.55e-04              pbswgs=0.7                pbsws=0.8
+ pbs=0.8                   mjswgs=0.98               mjsws=0.01
+ mjs=0.36                  ngcon=1                   saref=0.63e-6
+ sbref=0.63e-6             kvsat=-0.5                wlod=0.8e-6
+ tku0=0.1                  ku0=1.3249e-7             llodku0=1
+ wlodku0=1                 lku0=1.33e-7              wku0=6.5e-7
+ pku0=0                    kvth0=-1.5e-9             stk2=4e-10
+ steta0=0                  lkvth0=-1.68e-15          wkvth0=0.5e-6
+ pkvth0=0                  llodvth=2                 wlodvth=1
+ lodk2=2                   lodeta0=1                 fnoimod=1
+ tnoimod=0                 noia=1.40e42              noib=8.00e26
+ noic=8.75                 wpemod=wpeflag_lvt        kvth0we=-0.0028
+ lkvth0we=0                wkvth0we=0                pkvth0we=0
+ ku0we=-0.0045             lku0we=2.60e-10           wku0we=0
+ pku0we=0                  k2we=0.00045              wk2we=0
+ web=-180                  wec=-3000                 scref=1.00e-06
+ ud=0                      em=1.00e07                ef=1.17
+ minr=1e-3

     16: type=p
+ lmin=1.0000e-05-dxlp_lvt  lmax=2.001e-05            wmin=2.4000e-07-dxwp_lvt
+ wmax=5.0000e-07-dxwp_lvt  version=4.5               binunit=2
+ paramchk=1                mobmod=0                  capmod=2
+ igcmod=1                  igbmod=1                  diomod=1
+ rdsmod=0                  rbodymod=0                rgatemod=0
+ permod=1                  acnqsmod=0                trnqsmod=0
+ tnom=25                   toxe=toxp_lvt             toxm=toxp_lvt
+ dtox=5e-010               epsrox=3.9                wint=5e-009
+ lint=2.5e-009             ll=0                      wl=0
+ lln=1                     wln=1                     lw=0
+ ww=0                      lwn=1                     wwn=1
+ lwl=0                     wwl=0                     llc=0
+ wlc=0                     lwc=0                     wwc=0
+ lwlc=0                    wwlc=0                    dwc=0
+ xpart=1                   toxref=3e-009             dlcig=2.5e-009
+ xl=-3.5e-8+dxlp_lvt       xw=1.5e-8+dxwp_lvt        vth0=-0.15523077+dvthp_lvt
+ wvth0=-1.9034615e-009+dwvthp_lvt                    lvth0=0+dlvthp_lvt
+ pvth0=0+dpvthp_lvt        k1=0.15                   k2=0.014518269+dk2p_lvt
+ wk2=-1.498976e-009        k3=-0.58                  k3b=0.8
+ w0=0                      dvt0=20                   dvt1=1.8
+ dvt2=-0.032               dvt0w=0                   dvt1w=0
+ dvt2w=0                   dsub=0.5                  minv=0
+ voffl=0                   dvtp0=5.5e-007            dvtp1=4.0288462
+ wdvtp1=2.3793269e-007     lpe0=0                    lpeb=4.5e-007
+ xj=1.7000001e-007         ngate=8e019               ndep=1.7200001e017
+ nsd=1e020                 phin=0                    cdsc=0
+ cdscb=0                   cdscd=0                   cit=0
+ voff=-0.085288462         wvoff=-2.3793269e-009     lvoff=0+dlvoffp_lvt
+ pvoff=0+dpvoffp_lvt       nfactor=0.5               eta0=0.16682692+deta0p_lvt
+ peta0=0+dpeta0p_lvt       weta0=-2.6172596e-008     etab=-0.069423077
+ wetab=4.7586538e-009      u0=0.0070084615           wu0=3.9972692e-010
+ ua=-5.1721154e-010        wua=1.5332383e-016        ub=2.1747692e-018
+ wub=-2.4935346e-025       uc=1.0576923e-011         wuc=4.7586538e-018
+ vsat=100000               lvsat=0+dlvsatp_lvt       pvsat=0+dpvsatp_lvt
+ a0=3.5869038              wa0=-1.0802144e-007       ags=1.1899423
+ wags=-4.7586538e-010      a1=0                      a2=1
+ b0=0                      b1=0                      keta=-0.051730769
+ wketa=-1.4275962e-008     dwg=0                     dwb=0
+ pclm=-0.54807692          wpclm=4.2827885e-007      pdiblc1=0
+ pdiblc2=0.001             pdiblcb=0                 drout=0
+ pvag=2                    delta=0.01                pscbe1=9.264e008
+ pscbe2=1e-020             fprout=1000               pdits=0
+ pditsd=0                  pditsl=0                  rdsw=210
+ prwg=0                    prwb=0                    wr=1
+ alpha0=0                  agidl=9e-008              bgidl=2.3e009
+ cgidl=0.5                 egidl=0.53                aigbacc=0.0117
+ bigbacc=0.0049            cigbacc=0.1498            nigbacc=2.025
+ aigbinv=0.35              bigbinv=0.03              cigbinv=0.006
+ eigbinv=1.1               nigbinv=1                 aigc=0.005997
+ bigc=0.0007088            cigc=5e-011               aigsd=0.00469
+ bigsd=9.291e-005          cigsd=0.001372            nigc=1
+ poxedge=1                 pigcd=2.3                 ntox=ntoxp_lvt
+ xrcrg1=12                 xrcrg2=1                  cgso=cgop_lvt
+ cgdo=cgop_lvt             cgbo=0                    cgdl=cglp_lvt
+ cgsl=cglp_lvt             clc=1e-007                cle=0.6
+ cf=cfp_lvt                ckappas=0.6               moin=11.09
+ noff=2.175                voffcv=-0.03885           kt1=-0.28
+ kt1l=0                    kt2=-0.03875              ute=-1.5970385
+ wute=-3.3310577e-008      ua1=2.6653846e-009        wua1=-2.8551923e-016
+ ub1=-7.3993654e-018       wub1=5.2487952e-025       uc1=-6.4583077e-011
+ wuc1=-1.6027146e-017      prt=0                     at=230000
+ njs=1                     ijthsfwd=0.01             ijthsrev=0.01
+ bvs=10                    xjbvs=1                   cjs=cjp_lvt
+ cjsws=cjswp_lvt           cjswgs=cjswgp_lvt         xtis=3
+ dmcg=9.25e-008            dmci=9.25e-008            dmdg=0
+ dmcgt=0                   dwj=0                     xgw=0
+ xgl=0                     rshg=0.1                  gbmin=1e-012
+ rbpb=50                   rbpd=50                   rbps=50
+ rbdb=50                   rbsb=50                   rsh=9.68
+ acde=1.2                  dlc=1.53e-008             beta0=8
+ alpha1=0.003              jswgs=3.00e-12            jsws=3.47e-13
+ jss=1.56e-07              tpbswg=1.9e-03            tcjswg=4.01e-03
+ tpbsw=1.9e-03             tcjsw=1.9e-04             tpb=1.9e-03
+ tcj=8.55e-04              pbswgs=0.7                pbsws=0.8
+ pbs=0.8                   mjswgs=0.98               mjsws=0.01
+ mjs=0.36                  ngcon=1                   saref=0.63e-6
+ sbref=0.63e-6             kvsat=-0.5                wlod=0.8e-6
+ tku0=0.1                  ku0=1.3249e-7             llodku0=1
+ wlodku0=1                 lku0=1.33e-7              wku0=6.5e-7
+ pku0=0                    kvth0=-1.5e-9             stk2=4e-10
+ steta0=0                  lkvth0=-1.68e-15          wkvth0=0.5e-6
+ pkvth0=0                  llodvth=2                 wlodvth=1
+ lodk2=2                   lodeta0=1                 fnoimod=1
+ tnoimod=0                 noia=1.40e42              noib=8.00e26
+ noic=8.75                 wpemod=wpeflag_lvt        kvth0we=-0.0028
+ lkvth0we=0                wkvth0we=0                pkvth0we=0
+ ku0we=-0.0045             lku0we=2.60e-10           wku0we=0
+ pku0we=0                  k2we=0.00045              wk2we=0
+ web=-180                  wec=-3000                 scref=1.00e-06
+ ud=0                      em=1.00e07                ef=1.17
+ minr=1e-3

     17: type=p
+ lmin=1.2000e-06-dxlp_lvt  lmax=1.0000e-05-dxlp_lvt  wmin=2.4000e-07-dxwp_lvt
+ wmax=5.0000e-07-dxwp_lvt  version=4.5               binunit=2
+ paramchk=1                mobmod=0                  capmod=2
+ igcmod=1                  igbmod=1                  diomod=1
+ rdsmod=0                  rbodymod=0                rgatemod=0
+ permod=1                  acnqsmod=0                trnqsmod=0
+ tnom=25                   toxe=toxp_lvt             toxm=toxp_lvt
+ dtox=5e-010               epsrox=3.9                wint=5e-009
+ lint=2.5e-009             ll=0                      wl=0
+ lln=1                     wln=1                     lw=0
+ ww=0                      lwn=1                     wwn=1
+ lwl=0                     wwl=0                     llc=0
+ wlc=0                     lwc=0                     wwc=0
+ lwlc=0                    wwlc=0                    dwc=0
+ xpart=1                   toxref=3e-009             dlcig=2.5e-009
+ xl=-3.5e-8+dxlp_lvt       xw=1.5e-8+dxwp_lvt        vth0=-0.15436406+dvthp_lvt
+ lvth0=-8.6323773e-009+dlvthp_lvt                    wvth0=-2.1480996e-009+dwvthp_lvt
+ pvth0=2.4365952e-015+dpvthp_lvt                     k1=0.15
+ k2=0.013312133+dk2p_lvt   lk2=1.2013118e-008        wk2=-1.3358839e-009
+ pk2=-1.6243968e-015       k3=-0.58                  k3b=0.8
+ w0=0                      dvt0=20                   dvt1=1.8
+ dvt2=-0.032               dvt0w=0                   dvt1w=0
+ dvt2w=0                   dsub=0.5                  minv=0
+ voffl=0                   dvtp0=5.5e-007            dvtp1=3.9008304
+ ldvtp1=1.2750367e-006     wdvtp1=2.6929655e-007     pdvtp1=-3.1238399e-013
+ lpe0=0                    lpeb=4.5e-007             xj=1.7000001e-007
+ ngate=8e019               ndep=1.7200001e017        nsd=1e020
+ phin=0                    cdsc=0                    cdscb=0
+ cdscd=0                   cit=0                     voff=-0.08144799
+ lvoff=-3.8251101e-008+dlvoffp_lvt                   wvoff=-3.3202426e-009
+ pvoff=9.3715198e-015+dpvoffp_lvt                    nfactor=0.5
+ eta0=0.16682692+deta0p_lvt                          peta0=0+dpeta0p_lvt
+ weta0=-2.6172596e-008     etab=-0.069423077         wetab=4.7586538e-009
+ u0=0.0071369589           lu0=-1.2798339e-009       wu0=3.6146302e-010
+ pu0=3.8110847e-016        ua=-3.9536768e-010        lua=-1.2135648e-015
+ wua=1.3487561e-016        pua=1.8374427e-022        ub=2.0409281e-018
+ lub=1.3330572e-024        wub=-2.3668246e-025       pub=-1.2620313e-031
+ uc=-3.6949301e-012        luc=1.4214766e-016        wuc=6.6404851e-018
+ puc=-1.874304e-023        vsat=100000               a0=3.5251876
+ lvsat=0+dlvsatp_lvt       pvsat=0+dpvsatp_lvt       la0=6.1469394e-007
+ wa0=-1.267143e-007        pa0=1.8618086e-013        ags=1.1137463
+ lags=7.5891195e-007       wags=1.6568767e-009       pags=-2.1242112e-014
+ a1=0                      a2=1                      b0=0
+ b1=0                      keta=-0.033808566         lketa=-1.7850514e-007
+ wketa=-1.8666901e-008     pketa=4.3733759e-014      dwg=0
+ dwb=0                     pclm=-0.77850524          lpclm=2.2950661e-006
+ wpclm=4.8473378e-007      ppclm=-5.6229119e-013     pdiblc1=0
+ pdiblc2=0.00097718531     lpdiblc2=2.2723427e-010   wpdiblc2=-1.8818313e-010
+ ppdiblc2=1.874304e-015    pdiblcb=0                 drout=0
+ pvag=2                    delta=0.01                pscbe1=9.264e008
+ pscbe2=1e-020             fprout=1000               pdits=0
+ pditsd=0                  pditsl=0                  rdsw=210
+ prwg=0                    prwb=0                    wr=1
+ alpha0=0                  agidl=9e-008              bgidl=2.3e009
+ cgidl=0.5                 egidl=0.53                aigbacc=0.0117
+ bigbacc=0.0049            cigbacc=0.1498            nigbacc=2.025
+ aigbinv=0.35              bigbinv=0.03              cigbinv=0.006
+ eigbinv=1.1               nigbinv=1                 aigc=0.005997
+ bigc=0.0007088            cigc=5e-011               aigsd=0.00469
+ bigsd=9.291e-005          cigsd=0.001372            nigc=1
+ poxedge=1                 pigcd=2.3                 ntox=ntoxp_lvt
+ xrcrg1=12                 xrcrg2=1                  cgso=cgop_lvt
+ cgdo=cgop_lvt             cgbo=0                    cgdl=cglp_lvt
+ cgsl=cglp_lvt             clc=1e-007                cle=0.6
+ cf=cfp_lvt                ckappas=0.6               moin=11.09
+ noff=2.175                voffcv=-0.03885           kt1=-0.28
+ kt1l=0                    kt2=-0.03875              ute=-1.6063849
+ lute=9.3090304e-008       wute=-3.211875e-008       pute=-1.1870592e-014
+ ua1=2.7312937e-009        lua1=-6.5645455e-016      wua1=-2.8551923e-016
+ pua1=1.2919899e-037       ub1=-7.5945678e-018       lub1=1.9442164e-024
+ wub1=5.2939591e-025       pub1=-4.4983295e-032      uc1=-6.4583077e-011
+ wuc1=-1.6027146e-017      prt=0                     at=230000
+ njs=1                     ijthsfwd=0.01             ijthsrev=0.01
+ bvs=10                    xjbvs=1                   cjs=cjp_lvt
+ cjsws=cjswp_lvt           cjswgs=cjswgp_lvt         xtis=3
+ dmcg=9.25e-008            dmci=9.25e-008            dmdg=0
+ dmcgt=0                   dwj=0                     xgw=0
+ xgl=0                     rshg=0.1                  gbmin=1e-012
+ rbpb=50                   rbpd=50                   rbps=50
+ rbdb=50                   rbsb=50                   rsh=9.68
+ acde=1.2                  dlc=1.53e-008             beta0=8
+ alpha1=0.003              jswgs=3.00e-12            jsws=3.47e-13
+ jss=1.56e-07              tpbswg=1.9e-03            tcjswg=4.01e-03
+ tpbsw=1.9e-03             tcjsw=1.9e-04             tpb=1.9e-03
+ tcj=8.55e-04              pbswgs=0.7                pbsws=0.8
+ pbs=0.8                   mjswgs=0.98               mjsws=0.01
+ mjs=0.36                  ngcon=1                   saref=0.63e-6
+ sbref=0.63e-6             kvsat=-0.5                wlod=0.8e-6
+ tku0=0.1                  ku0=1.3249e-7             llodku0=1
+ wlodku0=1                 lku0=1.33e-7              wku0=6.5e-7
+ pku0=0                    kvth0=-1.5e-9             stk2=4e-10
+ steta0=0                  lkvth0=-1.68e-15          wkvth0=0.5e-6
+ pkvth0=0                  llodvth=2                 wlodvth=1
+ lodk2=2                   lodeta0=1                 fnoimod=1
+ tnoimod=0                 noia=1.40e42              noib=8.00e26
+ noic=8.75                 wpemod=wpeflag_lvt        kvth0we=-0.0028
+ lkvth0we=0                wkvth0we=0                pkvth0we=0
+ ku0we=-0.0045             lku0we=2.60e-10           wku0we=0
+ pku0we=0                  k2we=0.00045              wk2we=0
+ web=-180                  wec=-3000                 scref=1.00e-06
+ ud=0                      em=1.00e07                ef=1.17
+ minr=1e-3

     18: type=p
+ lmin=5.0000e-07-dxlp_lvt  lmax=1.2000e-06-dxlp_lvt  wmin=2.4000e-07-dxwp_lvt
+ wmax=5.0000e-07-dxwp_lvt  version=4.5               binunit=2
+ paramchk=1                mobmod=0                  capmod=2
+ igcmod=1                  igbmod=1                  diomod=1
+ rdsmod=0                  rbodymod=0                rgatemod=0
+ permod=1                  acnqsmod=0                trnqsmod=0
+ tnom=25                   toxe=toxp_lvt             toxm=toxp_lvt
+ dtox=5e-010               epsrox=3.9                wint=5e-009
+ lint=2.5e-009             ll=0                      wl=0
+ lln=1                     wln=1                     lw=0
+ ww=0                      lwn=1                     wwn=1
+ lwl=0                     wwl=0                     llc=0
+ wlc=0                     lwc=0                     wwc=0
+ lwlc=0                    wwlc=0                    dwc=0
+ xpart=1                   toxref=3e-009             dlcig=2.5e-009
+ xl=-3.5e-8+dxlp_lvt       xw=1.5e-8+dxwp_lvt        vth0=-0.15827868+dvthp_lvt
+ lvth0=-4.091422e-009+dlvthp_lvt                     wvth0=8.5927692e-010+dwvthp_lvt
+ pvth0=-1.0519616e-015+dpvthp_lvt                    k1=0.15
+ k2=0.023308104+dk2p_lvt   lk2=4.1779121e-010        wk2=-1.6417356e-009
+ pk2=-1.2696088e-015       k3=-0.58                  k3b=0.8
+ w0=0                      dvt0=20                   dvt1=1.8
+ dvt2=-0.032               dvt0w=0                   dvt1w=0
+ dvt2w=0                   dsub=0.5                  minv=0
+ voffl=0                   dvtp0=5.5e-007            dvtp1=5
+ lpe0=0                    lpeb=4.5e-007             xj=1.7000001e-007
+ ngate=8e019               ndep=1.7200001e017        nsd=1e020
+ phin=0                    cdsc=0                    cdscb=0
+ cdscd=0                   cit=0                     voff=-0.12680769
+ lvoff=1.4366154e-008+dlvoffp_lvt                    wvoff=1.1012885e-008
+ pvoff=-7.2549077e-015+dpvoffp_lvt                   nfactor=-0.13818681
+ lnfactor=7.402967e-007    wnfactor=1.5635577e-007   pnfactor=-1.8137269e-013
+ eta0=0.16682692+deta0p_lvt                          peta0=0+dpeta0p_lvt
+ weta0=-2.6172596e-008     etab=-0.069423077         wetab=4.7586538e-009
+ u0=0.0056876429           lu0=4.0137275e-010        wu0=8.713775e-010
+ pu0=-2.1039232e-016       ua=-1.4782861e-009        lua=4.2620567e-017
+ wua=3.4199629e-016        pua=-5.6515731e-023       ub=3.1265621e-018
+ lub=7.3721824e-026        wub=-3.4391471e-025       pub=-1.8137269e-033
+ uc=1.0646154e-010         luc=1.4366154e-017        wuc=-3.2630769e-018
+ puc=-7.2549077e-024       vsat=100000               a0=3.4898143
+ lvsat=0+dlvsatp_lvt       pvsat=0+dpvsatp_lvt       la0=6.5572697e-007
+ wa0=2.060905e-007         pa0=-1.9987271e-013       ags=0.96983022
+ lags=9.2585464e-007       wags=-1.9782404e-008      pags=3.6274538e-015
+ a1=0                      a2=1                      b0=0
+ b1=0                      keta=-0.21246154          lketa=2.8732308e-008
+ wketa=3.1543077e-008      pketa=-1.4509815e-014     dwg=0
+ dwb=0                     pclm=1.2                  pdiblc1=0
+ pdiblc2=-0.0095813187     lpdiblc2=1.2475099e-008   wpdiblc2=4.8674231e-009
+ ppdiblc2=-3.9901992e-015  pdiblcb=0                 drout=0
+ pvag=2                    delta=0.01                pscbe1=9.264e008
+ pscbe2=1e-020             fprout=1000               pdits=0
+ pditsd=0                  pditsl=0                  rdsw=210
+ prwg=0                    prwb=0                    wr=1
+ alpha0=0                  agidl=9e-008              bgidl=2.3e009
+ cgidl=0.5                 egidl=0.53                aigbacc=0.0117
+ bigbacc=0.0049            cigbacc=0.1498            nigbacc=2.025
+ aigbinv=0.35              bigbinv=0.03              cigbinv=0.006
+ eigbinv=1.1               nigbinv=1                 aigc=0.005997
+ bigc=0.0007088            cigc=5e-011               aigsd=0.00469
+ bigsd=9.291e-005          cigsd=0.001372            nigc=1
+ poxedge=1                 pigcd=2.3                 ntox=ntoxp_lvt
+ xrcrg1=12                 xrcrg2=1                  cgso=cgop_lvt
+ cgdo=cgop_lvt             cgbo=0                    cgdl=cglp_lvt
+ cgsl=cglp_lvt             clc=1e-007                cle=0.6
+ cf=cfp_lvt                ckappas=0.6               moin=11.09
+ noff=2.175                voffcv=-0.03885           kt1=-0.29238462
+ lkt1=1.4366154e-008       wkt1=6.2542308e-009       pkt1=-7.2549077e-015
+ kt1l=0                    kt2=-0.03875              ute=-2.0644357
+ lute=6.2442927e-007       wute=8.148175e-008        pute=-1.4364717e-013
+ ua1=1.1270066e-009        lua1=1.2045184e-015       wua1=9.1517071e-017
+ pua1=-4.3736211e-022      ub1=-5.4409786e-018       lub1=-5.5394716e-025
+ wub1=1.0410575e-025       pub1=4.483533e-031        uc1=-6.4583077e-011
+ wuc1=-1.6027146e-017      prt=0                     at=230000
+ njs=1                     ijthsfwd=0.01             ijthsrev=0.01
+ bvs=10                    xjbvs=1                   cjs=cjp_lvt
+ cjsws=cjswp_lvt           cjswgs=cjswgp_lvt         xtis=3
+ dmcg=9.25e-008            dmci=9.25e-008            dmdg=0
+ dmcgt=0                   dwj=0                     xgw=0
+ xgl=0                     rshg=0.1                  gbmin=1e-012
+ rbpb=50                   rbpd=50                   rbps=50
+ rbdb=50                   rbsb=50                   rsh=9.68
+ acde=1.2                  dlc=1.53e-008             beta0=8
+ alpha1=0.003              jswgs=3.00e-12            jsws=3.47e-13
+ jss=1.56e-07              tpbswg=1.9e-03            tcjswg=4.01e-03
+ tpbsw=1.9e-03             tcjsw=1.9e-04             tpb=1.9e-03
+ tcj=8.55e-04              pbswgs=0.7                pbsws=0.8
+ pbs=0.8                   mjswgs=0.98               mjsws=0.01
+ mjs=0.36                  ngcon=1                   saref=0.63e-6
+ sbref=0.63e-6             kvsat=-0.5                wlod=0.8e-6
+ tku0=0.1                  ku0=1.3249e-7             llodku0=1
+ wlodku0=1                 lku0=1.33e-7              wku0=6.5e-7
+ pku0=0                    kvth0=-1.5e-9             stk2=4e-10
+ steta0=0                  lkvth0=-1.68e-15          wkvth0=0.5e-6
+ pkvth0=0                  llodvth=2                 wlodvth=1
+ lodk2=2                   lodeta0=1                 fnoimod=1
+ tnoimod=0                 noia=1.40e42              noib=8.00e26
+ noic=8.75                 wpemod=wpeflag_lvt        kvth0we=-0.0028
+ lkvth0we=0                wkvth0we=0                pkvth0we=0
+ ku0we=-0.0045             lku0we=2.60e-10           wku0we=0
+ pku0we=0                  k2we=0.00045              wk2we=0
+ web=-180                  wec=-3000                 scref=1.00e-06
+ ud=0                      em=1.00e07                ef=1.17
+ minr=1e-3

     19: type=p
+ lmin=2.4000e-07-dxlp_lvt  lmax=5.0000e-07-dxlp_lvt  wmin=2.4000e-07-dxwp_lvt
+ wmax=5.0000e-07-dxwp_lvt  version=4.5               binunit=2
+ paramchk=1                mobmod=0                  capmod=2
+ igcmod=1                  igbmod=1                  diomod=1
+ rdsmod=0                  rbodymod=0                rgatemod=0
+ permod=1                  acnqsmod=0                trnqsmod=0
+ tnom=25                   toxe=toxp_lvt             toxm=toxp_lvt
+ dtox=5e-010               epsrox=3.9                wint=5e-009
+ lint=2.5e-009             ll=0                      wl=0
+ lln=1                     wln=1                     lw=0
+ ww=0                      lwn=1                     wwn=1
+ lwl=0                     wwl=0                     llc=0
+ wlc=0                     lwc=0                     wwc=0
+ lwlc=0                    wwlc=0                    dwc=0
+ xpart=1                   toxref=3e-009             dlcig=2.5e-009
+ xl=-3.5e-8+dxlp_lvt       xw=1.5e-8+dxwp_lvt        vth0=-0.16631509+dvthp_lvt
+ lvth0=-3.9467456e-010+dlvthp_lvt                    wvth0=-6.9549556e-010+dwvthp_lvt
+ pvth0=-3.3676627e-016+dpvthp_lvt                    k1=0.15
+ k2=0.045901997+dk2p_lvt   lk2=-9.9753994e-009       wk2=-7.3118547e-009
+ pk2=1.3386459e-015        k3=-0.58                  k3b=0.8
+ w0=0                      dvt0=20                   dvt1=1.8
+ dvt2=-0.032               dvt0w=0                   dvt1w=0
+ dvt2w=0                   dsub=0.5                  minv=0
+ voffl=0                   dvtp0=5.5e-007            dvtp1=5
+ lpe0=0                    lpeb=4.5e-007             xj=1.7000001e-007
+ ngate=8e019               ndep=1.7200001e017        nsd=1e020
+ phin=0                    cdsc=0                    cdscb=0
+ cdscd=0                   cit=0.00036242604         lcit=-1.6671598e-010
+ wcit=-1.8302515e-010      pcit=8.4191568e-017       voff=-0.080636095
+ lvoff=-6.8727811e-009+dlvoffp_lvt                   wvoff=-8.4191568e-009
+ pvoff=1.6838314e-015+dpvoffp_lvt                    nfactor=1.8335799
+ lnfactor=-1.6671598e-007  wnfactor=-4.2095784e-007  pnfactor=8.4191568e-014
+ eta0=0.26394231+deta0p_lvt                          leta0=-4.4673077e-008
+ weta0=-4.9965865e-008     peta0=1.0944904e-014+dpeta0p_lvt
+ etab=-0.069423077         wetab=4.7586538e-009      u0=0.0078180325
+ lu0=-5.7860651e-010       wu0=2.5660126e-010        pu0=7.2404749e-017
+ ua=-1.2125158e-009        lua=-7.9633757e-017       wua=2.1185161e-016
+ pua=3.3508244e-024        ub=3.5356139e-018         lub=-1.1444201e-025
+ wub=-4.6572579e-025       pub=5.421937e-032         uc=1.5218935e-010
+ luc=-6.6686391e-018       wuc=-2.6355621e-017       puc=3.3676627e-024
+ vsat=100000               a0=5.1907071              la0=-1.2668373e-007
+ lvsat=0+dlvsatp_lvt       pvsat=0+dpvsatp_lvt       wa0=-2.9174209e-007
+ pa0=2.9130283e-014        ags=0.092173077           lags=1.3295769e-006
+ wags=3.5689904e-008       pags=-2.1889808e-014      a1=0
+ a2=1                      b0=0                      b1=0
+ keta=-0.17988166          lketa=1.3745562e-008      wketa=7.3210059e-009
+ pketa=-3.3676627e-015     dwg=0                     dwb=0
+ pclm=1.802071             lpclm=-2.7695266e-007     wpclm=-1.0981509e-007
+ ppclm=5.0514941e-014      pdiblc1=0                 pdiblc2=0.02645858
+ lpdiblc2=-4.1032544e-009  wpdiblc2=-6.3692751e-009  ppdiblc2=1.178682e-015
+ pdiblcb=0                 drout=0                   pvag=2
+ delta=0.01                pscbe1=9.264e008          pscbe2=1e-020
+ fprout=1000               pdits=0                   pditsd=0
+ pditsl=0                  rdsw=210                  prwg=0
+ prwb=0                    wr=1                      alpha0=0
+ agidl=9e-008              bgidl=2.3e009             cgidl=0.5
+ egidl=0.53                aigbacc=0.0117            bigbacc=0.0049
+ cigbacc=0.1498            nigbacc=2.025             aigbinv=0.35
+ bigbinv=0.03              cigbinv=0.006             eigbinv=1.1
+ nigbinv=1                 aigc=0.005997             bigc=0.0007088
+ cigc=5e-011               aigsd=0.00469             bigsd=9.291e-005
+ cigsd=0.001372            nigc=1                    poxedge=1
+ pigcd=2.3                 ntox=ntoxp_lvt            xrcrg1=12
+ xrcrg2=1                  cgso=cgop_lvt             cgdo=cgop_lvt
+ cgbo=0                    cgdl=cglp_lvt             cgsl=cglp_lvt
+ clc=1e-007                cle=0.6                   cf=cfp_lvt
+ ckappas=0.6               moin=11.09                noff=2.175
+ voffcv=-0.03885           kt1=-0.25301775           lkt1=-3.7426036e-009
+ wkt1=-5.8568047e-009      pkt1=-1.6838314e-015      kt1l=0
+ kt2=-0.03875              ute=-0.65866716           lute=-2.222426e-008
+ wute=-2.6373924e-007      pute=1.5154482e-014       ua1=4.2199895e-009
+ lua1=-2.1825367e-016      wua1=-1.0204055e-015      pua1=7.4122257e-023
+ ub1=-7.4517944e-018       lub1=3.7102811e-025       wub1=1.2973189e-024
+ pub1=-1.0052473e-031      uc1=-6.4583077e-011       wuc1=-1.6027146e-017
+ prt=0                     at=283846.15              lat=-0.024769231
+ njs=1                     ijthsfwd=0.01             ijthsrev=0.01
+ bvs=10                    xjbvs=1                   cjs=cjp_lvt
+ cjsws=cjswp_lvt           cjswgs=cjswgp_lvt         xtis=3
+ dmcg=9.25e-008            dmci=9.25e-008            dmdg=0
+ dmcgt=0                   dwj=0                     xgw=0
+ xgl=0                     rshg=0.1                  gbmin=1e-012
+ rbpb=50                   rbpd=50                   rbps=50
+ rbdb=50                   rbsb=50                   rsh=9.68
+ acde=1.2                  dlc=1.53e-008             beta0=8
+ alpha1=0.003              jswgs=3.00e-12            jsws=3.47e-13
+ jss=1.56e-07              tpbswg=1.9e-03            tcjswg=4.01e-03
+ tpbsw=1.9e-03             tcjsw=1.9e-04             tpb=1.9e-03
+ tcj=8.55e-04              pbswgs=0.7                pbsws=0.8
+ pbs=0.8                   mjswgs=0.98               mjsws=0.01
+ mjs=0.36                  ngcon=1                   saref=0.63e-6
+ sbref=0.63e-6             kvsat=-0.5                wlod=0.8e-6
+ tku0=0.1                  ku0=1.3249e-7             llodku0=1
+ wlodku0=1                 lku0=1.33e-7              wku0=6.5e-7
+ pku0=0                    kvth0=-1.5e-9             stk2=4e-10
+ steta0=0                  lkvth0=-1.68e-15          wkvth0=0.5e-6
+ pkvth0=0                  llodvth=2                 wlodvth=1
+ lodk2=2                   lodeta0=1                 fnoimod=1
+ tnoimod=0                 noia=1.40e42              noib=8.00e26
+ noic=8.75                 wpemod=wpeflag_lvt        kvth0we=-0.0028
+ lkvth0we=0                wkvth0we=0                pkvth0we=0
+ ku0we=-0.0045             lku0we=2.60e-10           wku0we=0
+ pku0we=0                  k2we=0.00045              wk2we=0
+ web=-180                  wec=-3000                 scref=1.00e-06
+ ud=0                      em=1.00e07                ef=1.17
+ minr=1e-3

     20: type=p
+ lmin=1.0e-07              lmax=2.4000e-07-dxlp_lvt  wmin=2.4000e-07-dxwp_lvt
+ wmax=5.0000e-07-dxwp_lvt  version=4.5               binunit=2
+ paramchk=1                mobmod=0                  capmod=2
+ igcmod=1                  igbmod=1                  diomod=1
+ rdsmod=0                  rbodymod=0                rgatemod=0
+ permod=1                  acnqsmod=0                trnqsmod=0
+ tnom=25                   toxe=toxp_lvt             toxm=toxp_lvt
+ dtox=5e-010               epsrox=3.9                wint=5e-009
+ lint=2.5e-009             ll=0                      wl=0
+ lln=1                     wln=1                     lw=0
+ ww=0                      lwn=1                     wwn=1
+ lwl=0                     wwl=0                     llc=0
+ wlc=0                     lwc=0                     wwc=0
+ lwlc=0                    wwlc=0                    dwc=0
+ xpart=1                   toxref=3e-009             dlcig=2.5e-009
+ xl=-3.5e-8+dxlp_lvt       xw=1.5e-8+dxwp_lvt        vth0=-0.1744533+dvthp_lvt
+ lvth0=1.232967e-009+dlvthp_lvt                      wvth0=3.3310577e-009+dwvthp_lvt
+ pvth0=-1.1420769e-015+dpvthp_lvt                    k1=0.15
+ k2=0.0014142857+dk2p_lvt  lk2=-1.0778571e-009       wk2=-3.535e-010
+ pk2=-5.3025e-017          k3=-0.58                  k3b=0.8
+ w0=0                      dvt0=20                   dvt1=1.8
+ dvt2=-0.061142857         ldvt2=5.8285714e-009      dvt0w=0
+ dvt1w=0                   dvt2w=0                   dsub=0.5
+ minv=0                    voffl=0                   dvtp0=5.5e-007
+ dvtp1=5                   lpe0=0                    lpeb=4.5e-007
+ xj=1.7000001e-007         ngate=8e019               ndep=1.7200001e017
+ nsd=1e020                 phin=0                    cdsc=0
+ cdscb=0                   cdscd=0                   cit=-0.0034217033
+ lcit=5.9010989e-010       wcit=6.4581731e-010       pcit=-8.1576923e-017
+ voff=-0.12711538          lvoff=2.4230769e-009+dlvoffp_lvt
+ wvoff=6.1182692e-009      pvoff=-1.2236538e-015+dpvoffp_lvt
+ nfactor=1                 eta0=-0.01353022+deta0p_lvt
+ leta0=1.0821429e-008      weta0=1.8014904e-008      peta0=-2.65125e-015+dpeta0p_lvt
+ etab=-0.086318681         letab=3.3791209e-009      wetab=6.7980769e-009
+ petab=-4.0788462e-016     u0=0.0055535165           lu0=-1.257033e-010
+ wu0=7.1243846e-010        pu0=-1.8762692e-017       ua=-1.5764863e-009
+ lua=-6.8396703e-018       wua=2.7171913e-016        pua=-8.6226808e-024
+ ub=3.1558489e-018         lub=-3.8489011e-026       wub=-3.0761298e-025
+ pub=2.2596808e-032        uc=1.1798077e-010         luc=1.7307692e-019
+ wuc=-1.6655288e-017       puc=1.4275962e-024        vsat=100000
+ lvsat=0+dlvsatp_lvt       pvsat=0+dpvsatp_lvt       a0=0.24204396
+ la0=8.630489e-007         wa0=6.1073923e-007        pa0=-1.5136598e-013
+ ags=3.2301648             lags=7.0197857e-007       wags=-1.6247404e-006
+ pags=3.1019625e-013       a1=0                      a2=1
+ b0=0                      b1=0                      keta=-0.14115385
+ lketa=6e-009              wketa=-9.5173077e-009     pketa=-5.6605361e-031
+ dwg=0                     dwb=0                     pclm=0.54835165
+ lpclm=-2.6208791e-008     wpclm=1.6315385e-007      ppclm=-4.0788462e-015
+ pdiblc1=0                 pdiblc2=0.0076392857      lpdiblc2=-3.393956e-010
+ wpdiblc2=-6.18625e-010    ppdiblc2=2.8551923e-017   pdiblcb=0
+ drout=0                   pvag=2                    delta=0.01
+ pscbe1=9.264e008          pscbe2=1e-020             fprout=1000
+ pdits=0                   pditsd=0                  pditsl=0
+ rdsw=210                  prwg=0                    prwb=0
+ wr=1                      alpha0=0                  agidl=9e-008
+ bgidl=2.3e009             cgidl=0.5                 egidl=0.53
+ aigbacc=0.0117            bigbacc=0.0049            cigbacc=0.1498
+ nigbacc=2.025             aigbinv=0.35              bigbinv=0.03
+ cigbinv=0.006             eigbinv=1.1               nigbinv=1
+ aigc=0.005997             bigc=0.0007088            cigc=5e-011
+ aigsd=0.00469             bigsd=9.291e-005          cigsd=0.001372
+ nigc=1                    poxedge=1                 pigcd=2.3
+ ntox=ntoxp_lvt            xrcrg1=12                 xrcrg2=1
+ cgso=cgop_lvt             cgdo=cgop_lvt             cgbo=0
+ cgdl=cglp_lvt             cgsl=cglp_lvt             clc=1e-007
+ cle=0.6                   cf=cfp_lvt                ckappas=0.6
+ moin=11.09                noff=2.175                voffcv=-0.03885
+ kt1=-0.19178571           lkt1=-1.5989011e-008      wkt1=-2.65125e-008
+ pkt1=2.4473077e-015       kt1l=0                    kt2=-0.03875
+ ute=-0.81304121           lute=8.6505495e-009       wute=-1.806249e-007
+ pute=-1.4683846e-015      ua1=3.4508668e-009        lua1=-6.4429121e-017
+ wua1=-7.2871986e-016      pua1=1.5785135e-023       ub1=-6.4128269e-018
+ lub1=1.6323462e-025       wub1=9.629476e-025        pub1=-3.3650481e-032
+ uc1=-3.6547253e-011       luc1=-5.6071648e-018      wuc1=-2.2895923e-017
+ puc1=1.3737554e-024       prt=0                     at=190000
+ lat=-0.006                njs=1                     ijthsfwd=0.01
+ ijthsrev=0.01             bvs=10                    xjbvs=1
+ cjs=cjp_lvt               cjsws=cjswp_lvt           cjswgs=cjswgp_lvt
+ xtis=3                    dmcg=9.25e-008            dmci=9.25e-008
+ dmdg=0                    dmcgt=0                   dwj=0
+ xgw=0                     xgl=0                     rshg=0.1
+ gbmin=1e-012              rbpb=50                   rbpd=50
+ rbps=50                   rbdb=50                   rbsb=50
+ rsh=9.68                  acde=1.2                  dlc=1.53e-008
+ beta0=8                   alpha1=0.003              jswgs=3.00e-12
+ jsws=3.47e-13             jss=1.56e-07              tpbswg=1.9e-03
+ tcjswg=4.01e-03           tpbsw=1.9e-03             tcjsw=1.9e-04
+ tpb=1.9e-03               tcj=8.55e-04              pbswgs=0.7
+ pbsws=0.8                 pbs=0.8                   mjswgs=0.98
+ mjsws=0.01                mjs=0.36                  ngcon=1
+ saref=0.63e-6             sbref=0.63e-6             kvsat=-0.5
+ wlod=0.8e-6               tku0=0.1                  ku0=1.3249e-7
+ llodku0=1                 wlodku0=1                 lku0=1.33e-7
+ wku0=6.5e-7               pku0=0                    kvth0=-1.5e-9
+ stk2=4e-10                steta0=0                  lkvth0=-1.68e-15
+ wkvth0=0.5e-6             pkvth0=0                  llodvth=2
+ wlodvth=1                 lodk2=2                   lodeta0=1
+ fnoimod=1                 tnoimod=0                 noia=1.40e42
+ noib=8.00e26              noic=8.75                 wpemod=wpeflag_lvt
+ kvth0we=-0.0028           lkvth0we=0                wkvth0we=0
+ pkvth0we=0                ku0we=-0.0045             lku0we=2.60e-10
+ wku0we=0                  pku0we=0                  k2we=0.00045
+ wk2we=0                   web=-180                  wec=-3000
+ scref=1.00e-06            ud=0                      em=1.00e07
+ ef=1.17                   minr=1e-3

     21: type=p
+ lmin=1.0000e-05-dxlp_lvt  lmax=2.001e-05            wmin=1.2e-07
+ wmax=2.4000e-07-dxwp_lvt  version=4.5               binunit=2
+ paramchk=1                mobmod=0                  capmod=2
+ igcmod=1                  igbmod=1                  diomod=1
+ rdsmod=0                  rbodymod=0                rgatemod=0
+ permod=1                  acnqsmod=0                trnqsmod=0
+ tnom=25                   toxe=toxp_lvt             toxm=toxp_lvt
+ dtox=5e-010               epsrox=3.9                wint=5e-009
+ lint=2.5e-009             ll=0                      wl=0
+ lln=1                     wln=1                     lw=0
+ ww=0                      lwn=1                     wwn=1
+ lwl=0                     wwl=0                     llc=0
+ wlc=0                     lwc=0                     wwc=0
+ lwlc=0                    wwlc=0                    dwc=0
+ xpart=1                   toxref=3e-009             dlcig=2.5e-009
+ xl=-3.5e-8+dxlp_lvt       xw=1.5e-8+dxwp_lvt        vth0=-0.166125+dvthp_lvt
+ wvth0=7.65625e-010+dwvthp_lvt                       lvth0=0+dlvthp_lvt
+ pvth0=0+dpvthp_lvt        k1=0.15                   k2=0.00668125+dk2p_lvt
+ wk2=4.2109375e-010        k3=-0.58                  k3b=0.8
+ w0=0                      dvt0=20                   dvt1=1.8
+ dvt2=-0.032               dvt0w=0                   dvt1w=0
+ dvt2w=0                   dsub=0.5                  minv=0
+ voffl=0                   dvtp0=5.5e-007            dvtp1=5
+ lpe0=0                    lpeb=4.5e-007             xj=1.7000001e-007
+ ngate=8e019               ndep=1.7200001e017        nsd=1e020
+ phin=0                    cdsc=0                    cdscb=0
+ cdscd=0                   cit=0                     voff=-0.10020833
+ wvoff=1.2760417e-009      lvoff=0+dlvoffp_lvt       pvoff=0+dpvoffp_lvt
+ nfactor=0.5               eta0=0.075625+deta0p_lvt  peta0=0+dpeta0p_lvt
+ weta0=-3.828125e-009      etab=-0.070833333         wetab=5.1041667e-009
+ u0=0.00935875             wu0=-1.7609375e-010       ua=6.9130833e-010
+ wua=-1.4276354e-016       ub=9.6116667e-019         wub=4.7979167e-026
+ uc=4.0416667e-011         wuc=-2.5520833e-018       vsat=100000
+ lvsat=0+dlvsatp_lvt       pvsat=0+dpvsatp_lvt       a0=2.4376667
+ wa0=1.7354167e-007        ags=1.2609167             wags=-1.7864583e-008
+ a1=0                      a2=1                      b0=0
+ b1=0                      keta=-0.1725              wketa=1.53125e-008
+ dwg=0                     dwb=0                     pclm=1.2
+ pdiblc1=0                 pdiblc2=0.001             pdiblcb=0
+ drout=0                   pvag=2                    delta=0.01
+ pscbe1=9.264e008          pscbe2=1e-020             fprout=1000
+ pdits=0                   pditsd=0                  pditsl=0
+ rdsw=210                  prwg=0                    prwb=0
+ wr=1                      alpha0=0                  agidl=9e-008
+ bgidl=2.3e009             cgidl=0.5                 egidl=0.53
+ aigbacc=0.0117            bigbacc=0.0049            cigbacc=0.1498
+ nigbacc=2.025             aigbinv=0.35              bigbinv=0.03
+ cigbinv=0.006             eigbinv=1.1               nigbinv=1
+ aigc=0.005997             bigc=0.0007088            cigc=5e-011
+ aigsd=0.00469             bigsd=9.291e-005          cigsd=0.001372
+ nigc=1                    poxedge=1                 pigcd=2.3
+ ntox=ntoxp_lvt            xrcrg1=12                 xrcrg2=1
+ cgso=cgop_lvt             cgdo=cgop_lvt             cgbo=0
+ cgdl=cglp_lvt             cgsl=cglp_lvt             clc=1e-007
+ cle=0.6                   cf=cfp_lvt                ckappas=0.6
+ moin=11.09                noff=2.175                voffcv=-0.03885
+ kt1=-0.30083333           wkt1=5.1041667e-009       kt1l=0
+ kt2=-0.03875              ute=-1.7882083            wute=1.3526042e-008
+ ua1=2.0208333e-009        wua1=-1.2760417e-016      ub1=-6.9330417e-018
+ wub1=4.1063021e-025       uc1=-1.6125e-010          wuc1=7.65625e-018
+ prt=0                     at=230000                 njs=1
+ ijthsfwd=0.01             ijthsrev=0.01             bvs=10
+ xjbvs=1                   cjs=cjp_lvt               cjsws=cjswp_lvt
+ cjswgs=cjswgp_lvt         xtis=3                    dmcg=9.25e-008
+ dmci=9.25e-008            dmdg=0                    dmcgt=0
+ dwj=0                     xgw=0                     xgl=0
+ rshg=0.1                  gbmin=1e-012              rbpb=50
+ rbpd=50                   rbps=50                   rbdb=50
+ rbsb=50                   rsh=9.68                  acde=1.2
+ dlc=1.53e-008             beta0=8                   alpha1=0.003
+ jswgs=3.00e-12            jsws=3.47e-13             jss=1.56e-07
+ tpbswg=1.9e-03            tcjswg=4.01e-03           tpbsw=1.9e-03
+ tcjsw=1.9e-04             tpb=1.9e-03               tcj=8.55e-04
+ pbswgs=0.7                pbsws=0.8                 pbs=0.8
+ mjswgs=0.98               mjsws=0.01                mjs=0.36
+ ngcon=1                   saref=0.63e-6             sbref=0.63e-6
+ kvsat=-0.5                wlod=0.8e-6               tku0=0.1
+ ku0=1.3249e-7             llodku0=1                 wlodku0=1
+ lku0=1.33e-7              wku0=6.5e-7               pku0=0
+ kvth0=-1.5e-9             stk2=4e-10                steta0=0
+ lkvth0=-1.68e-15          wkvth0=0.5e-6             pkvth0=0
+ llodvth=2                 wlodvth=1                 lodk2=2
+ lodeta0=1                 fnoimod=1                 tnoimod=0
+ noia=1.40e42              noib=8.00e26              noic=8.75
+ wpemod=wpeflag_lvt        kvth0we=-0.0028           lkvth0we=0
+ wkvth0we=0                pkvth0we=0                ku0we=-0.0045
+ lku0we=2.60e-10           wku0we=0                  pku0we=0
+ k2we=0.00045              wk2we=0                   web=-180
+ wec=-3000                 scref=1.00e-06            ud=0
+ em=1.00e07                ef=1.17                   minr=1e-3

     22: type=p
+ lmin=1.2000e-06-dxlp_lvt  lmax=1.0000e-05-dxlp_lvt  wmin=1.2e-07
+ wmax=2.4000e-07-dxwp_lvt  version=4.5               binunit=2
+ paramchk=1                mobmod=0                  capmod=2
+ igcmod=1                  igbmod=1                  diomod=1
+ rdsmod=0                  rbodymod=0                rgatemod=0
+ permod=1                  acnqsmod=0                trnqsmod=0
+ tnom=25                   toxe=toxp_lvt             toxm=toxp_lvt
+ dtox=5e-010               epsrox=3.9                wint=5e-009
+ lint=2.5e-009             ll=0                      wl=0
+ lln=1                     wln=1                     lw=0
+ ww=0                      lwn=1                     wwn=1
+ lwl=0                     wwl=0                     llc=0
+ wlc=0                     lwc=0                     wwc=0
+ lwlc=0                    wwlc=0                    dwc=0
+ xpart=1                   toxref=3e-009             dlcig=2.5e-009
+ xl=-3.5e-8+dxlp_lvt       xw=1.5e-8+dxwp_lvt        vth0=-0.16749261+dvthp_lvt
+ lvth0=1.3621432e-008+dlvthp_lvt                     wvth0=1.0683949e-009+dwvthp_lvt
+ pvth0=-3.0155881e-015+dpvthp_lvt                    k1=0.15
+ k2=0.0056203883+dk2p_lvt  lk2=1.0566183e-008        wk2=5.4859351e-010
+ pk2=-1.2698976e-015       k3=-0.58                  k3b=0.8
+ w0=0                      dvt0=20                   dvt1=1.8
+ dvt2=-0.032               dvt0w=0                   dvt1w=0
+ dvt2w=0                   dsub=0.5                  minv=0
+ voffl=0                   dvtp0=5.5e-007            dvtp1=5
+ lpe0=0                    lpeb=4.5e-007             xj=1.7000001e-007
+ ngate=8e019               ndep=1.7200001e017        nsd=1e020
+ phin=0                    cdsc=0                    cdscb=0
+ cdscd=0                   cit=0                     voff=-0.10158144
+ lvoff=1.3676136e-008+dlvoffp_lvt                    wvoff=1.6124527e-009
+ pvoff=-3.3506534e-015+dpvoffp_lvt                   nfactor=0.5
+ eta0=0.075625+deta0p_lvt  peta0=0+dpeta0p_lvt       weta0=-3.828125e-009
+ etab=-0.070833333         wetab=5.1041667e-009      u0=0.0094285587
+ lu0=-6.9529477e-010       wu0=-1.9997893e-010       pu0=2.3789639e-016
+ ua=7.8377e-010            lua=-9.209182e-016        wua=-1.5401312e-016
+ pua=1.1204585e-022        ub=8.3867462e-019         lub=1.2200208e-024
+ wub=5.786965e-026         pub=-9.850921e-032        uc=3.2452652e-011
+ luc=7.9321591e-017        wuc=-2.2156723e-018       puc=-3.3506534e-024
+ vsat=100000               a0=2.2347051              lvsat=0+dlvsatp_lvt
+ pvsat=0+dpvsatp_lvt       la0=2.0214971e-006        wa0=1.8945391e-007
+ pa0=-1.5848591e-013       ags=1.1946616             lags=6.5990093e-007
+ wags=-1.8167353e-008      pags=3.0155881e-015       a1=0
+ a2=1                      b0=0                      b1=0
+ keta=-0.17455966          lketa=2.0514205e-008      wketa=1.5817116e-008
+ pketa=-5.0259801e-015     dwg=0                     dwb=0
+ pclm=1.2                  pdiblc1=0                 pdiblc2=0.00034640152
+ lpdiblc2=6.5098409e-009   wpdiblc2=-3.3641098e-011  ppdiblc2=3.3506534e-016
+ pdiblcb=0                 drout=0                   pvag=2
+ delta=0.01                pscbe1=9.264e008          pscbe2=1e-020
+ fprout=1000               pdits=0                   pditsd=0
+ pditsl=0                  rdsw=210                  prwg=0
+ prwb=0                    wr=1                      alpha0=0
+ agidl=9e-008              bgidl=2.3e009             cgidl=0.5
+ egidl=0.53                aigbacc=0.0117            bigbacc=0.0049
+ cigbacc=0.1498            nigbacc=2.025             aigbinv=0.35
+ bigbinv=0.03              cigbinv=0.006             eigbinv=1.1
+ nigbinv=1                 aigc=0.005997             bigc=0.0007088
+ cigc=5e-011               aigsd=0.00469             bigsd=9.291e-005
+ cigsd=0.001372            nigc=1                    poxedge=1
+ pigcd=2.3                 ntox=ntoxp_lvt            xrcrg1=12
+ xrcrg2=1                  cgso=cgop_lvt             cgdo=cgop_lvt
+ cgbo=0                    cgdl=cglp_lvt             cgsl=cglp_lvt
+ clc=1e-007                cle=0.6                   cf=cfp_lvt
+ ckappas=0.6               moin=11.09                noff=2.175
+ voffcv=-0.03885           kt1=-0.30357955           lkt1=2.7352273e-008
+ wkt1=5.7769886e-009       pkt1=-6.7013068e-015      kt1l=0
+ kt2=-0.03875              ute=-1.8035377            lute=1.5268039e-007
+ wute=1.6183688e-008       pute=-2.6470162e-014      ua1=2.2377841e-009
+ lua1=-2.1608295e-015      wua1=-1.6460937e-016      pua1=3.6857187e-022
+ ub1=-7.4779396e-018       lub1=5.4271833e-024       wub1=5.0082199e-025
+ pub1=-8.9831018e-031      uc1=-1.8184659e-010       luc1=2.0514205e-016
+ wuc1=1.2702415e-017       puc1=-5.0259801e-023      prt=0
+ at=230000                 njs=1                     ijthsfwd=0.01
+ ijthsrev=0.01             bvs=10                    xjbvs=1
+ cjs=cjp_lvt               cjsws=cjswp_lvt           cjswgs=cjswgp_lvt
+ xtis=3                    dmcg=9.25e-008            dmci=9.25e-008
+ dmdg=0                    dmcgt=0                   dwj=0
+ xgw=0                     xgl=0                     rshg=0.1
+ gbmin=1e-012              rbpb=50                   rbpd=50
+ rbps=50                   rbdb=50                   rbsb=50
+ rsh=9.68                  acde=1.2                  dlc=1.53e-008
+ beta0=8                   alpha1=0.003              jswgs=3.00e-12
+ jsws=3.47e-13             jss=1.56e-07              tpbswg=1.9e-03
+ tcjswg=4.01e-03           tpbsw=1.9e-03             tcjsw=1.9e-04
+ tpb=1.9e-03               tcj=8.55e-04              pbswgs=0.7
+ pbsws=0.8                 pbs=0.8                   mjswgs=0.98
+ mjsws=0.01                mjs=0.36                  ngcon=1
+ saref=0.63e-6             sbref=0.63e-6             kvsat=-0.5
+ wlod=0.8e-6               tku0=0.1                  ku0=1.3249e-7
+ llodku0=1                 wlodku0=1                 lku0=1.33e-7
+ wku0=6.5e-7               pku0=0                    kvth0=-1.5e-9
+ stk2=4e-10                steta0=0                  lkvth0=-1.68e-15
+ wkvth0=0.5e-6             pkvth0=0                  llodvth=2
+ wlodvth=1                 lodk2=2                   lodeta0=1
+ fnoimod=1                 tnoimod=0                 noia=1.40e42
+ noib=8.00e26              noic=8.75                 wpemod=wpeflag_lvt
+ kvth0we=-0.0028           lkvth0we=0                wkvth0we=0
+ pkvth0we=0                ku0we=-0.0045             lku0we=2.60e-10
+ wku0we=0                  pku0we=0                  k2we=0.00045
+ wk2we=0                   web=-180                  wec=-3000
+ scref=1.00e-06            ud=0                      em=1.00e07
+ ef=1.17                   minr=1e-3

     23: type=p
+ lmin=5.0000e-07-dxlp_lvt  lmax=1.2000e-06-dxlp_lvt  wmin=1.2e-07
+ wmax=2.4000e-07-dxwp_lvt  version=4.5               binunit=2
+ paramchk=1                mobmod=0                  capmod=2
+ igcmod=1                  igbmod=1                  diomod=1
+ rdsmod=0                  rbodymod=0                rgatemod=0
+ permod=1                  acnqsmod=0                trnqsmod=0
+ tnom=25                   toxe=toxp_lvt             toxm=toxp_lvt
+ dtox=5e-010               epsrox=3.9                wint=5e-009
+ lint=2.5e-009             ll=0                      wl=0
+ lln=1                     wln=1                     lw=0
+ ww=0                      lwn=1                     wwn=1
+ lwl=0                     wwl=0                     llc=0
+ wlc=0                     lwc=0                     wwc=0
+ lwlc=0                    wwlc=0                    dwc=0
+ xpart=1                   toxref=3e-009             dlcig=2.5e-009
+ xl=-3.5e-8+dxlp_lvt       xw=1.5e-8+dxwp_lvt        vth0=-0.14646786+dvthp_lvt
+ lvth0=-1.0767286e-008+dlvthp_lvt                    wvth0=-2.034375e-009+dwvthp_lvt
+ pvth0=5.83625e-016+dpvthp_lvt                       k1=0.15
+ k2=0.0191375+dk2p_lvt     lk2=-5.1136667e-009       wk2=-6.199375e-010
+ pk2=8.5598333e-017        k3=-0.58                  k3b=0.8
+ w0=0                      dvt0=20                   dvt1=1.8
+ dvt2=-0.032               dvt0w=0                   dvt1w=0
+ dvt2w=0                   dsub=0.5                  minv=0
+ voffl=0                   dvtp0=5.5e-007            dvtp1=5
+ lpe0=0                    lpeb=4.5e-007             xj=1.7000001e-007
+ ngate=8e019               ndep=1.7200001e017        nsd=1e020
+ phin=0                    cdsc=0                    cdscb=0
+ cdscd=0                   cit=0                     voff=-0.069803571
+ lvoff=-2.318619e-008+dlvoffp_lvt                    wvoff=-2.953125e-009
+ pvoff=1.9454167e-015+dpvoffp_lvt                    nfactor=0.5
+ eta0=0.075625+deta0p_lvt  peta0=0+dpeta0p_lvt       weta0=-3.828125e-009
+ etab=-0.070833333         wetab=5.1041667e-009      u0=0.0095930952
+ lu0=-8.8615714e-010       wu0=-8.5458333e-011       pu0=1.050525e-016
+ ua=3.2059036e-010         lua=-3.8362981e-016       wua=-9.8728437e-017
+ pua=4.7915612e-023        ub=1.7593167e-018         lub=1.52076e-025
+ wub=-8.9395833e-027       pub=-2.10105e-032         uc=1.4135714e-010
+ luc=-4.7007619e-017       wuc=-1.18125e-017         puc=7.7816667e-024
+ vsat=100000               a0=4.3960298              lvsat=0+dlvsatp_lvt
+ pvsat=0+dpvsatp_lvt       la0=-4.8563952e-007       wa0=-1.5932292e-008
+ pa0=7.9762083e-014        ags=0.81640714            lags=1.098676e-006
+ wags=1.780625e-008        pags=-3.8713792e-014      a1=0
+ a2=1                      b0=0                      b1=0
+ keta=-0.11347619          lketa=-5.0342619e-008     wketa=7.2916667e-009
+ pketa=4.8635417e-015      dwg=0                     dwb=0
+ pclm=1.2                  pdiblc1=0                 pdiblc2=0.012666667
+ lpdiblc2=-7.7816667e-009  wpdiblc2=-5.8333333e-010  ppdiblc2=9.7270833e-016
+ pdiblcb=0                 drout=0                   pvag=2
+ delta=0.01                pscbe1=9.264e008          pscbe2=1e-020
+ fprout=1000               pdits=0                   pditsd=0
+ pditsl=0                  rdsw=210                  prwg=0
+ prwb=0                    wr=1                      alpha0=0
+ agidl=9e-008              bgidl=2.3e009             cgidl=0.5
+ egidl=0.53                aigbacc=0.0117            bigbacc=0.0049
+ cigbacc=0.1498            nigbacc=2.025             aigbinv=0.35
+ bigbinv=0.03              cigbinv=0.006             eigbinv=1.1
+ nigbinv=1                 aigc=0.005997             bigc=0.0007088
+ cigc=5e-011               aigsd=0.00469             bigsd=9.291e-005
+ cigsd=0.001372            nigc=1                    poxedge=1
+ pigcd=2.3                 ntox=ntoxp_lvt            xrcrg1=12
+ xrcrg2=1                  cgso=cgop_lvt             cgdo=cgop_lvt
+ cgbo=0                    cgdl=cglp_lvt             cgsl=cglp_lvt
+ clc=1e-007                cle=0.6                   cf=cfp_lvt
+ ckappas=0.6               moin=11.09                noff=2.175
+ voffcv=-0.03885           kt1=-0.25316667           lkt1=-3.1126667e-008
+ wkt1=-3.3541667e-009      pkt1=3.8908333e-015       kt1l=0
+ kt2=-0.03875              ute=-1.7212024            lute=5.7171429e-008
+ wute=-2.6104167e-009      pute=-4.669e-015          ua1=8.6342964e-010
+ lua1=-5.6657839e-016      wua1=1.5609344e-016       pua1=-3.4433875e-024
+ ub1=-4.3265333e-018       lub1=1.771552e-024        wub1=-1.6893333e-025
+ pub1=-1.21394e-031        uc1=-5e-012               wuc1=-3.0625e-017
+ prt=0                     at=223154.76              lat=0.0079404762
+ wat=0.0016770833          pat=-1.9454167e-009       njs=1
+ ijthsfwd=0.01             ijthsrev=0.01             bvs=10
+ xjbvs=1                   cjs=cjp_lvt               cjsws=cjswp_lvt
+ cjswgs=cjswgp_lvt         xtis=3                    dmcg=9.25e-008
+ dmci=9.25e-008            dmdg=0                    dmcgt=0
+ dwj=0                     xgw=0                     xgl=0
+ rshg=0.1                  gbmin=1e-012              rbpb=50
+ rbpd=50                   rbps=50                   rbdb=50
+ rbsb=50                   rsh=9.68                  acde=1.2
+ dlc=1.53e-008             beta0=8                   alpha1=0.003
+ jswgs=3.00e-12            jsws=3.47e-13             jss=1.56e-07
+ tpbswg=1.9e-03            tcjswg=4.01e-03           tpbsw=1.9e-03
+ tcjsw=1.9e-04             tpb=1.9e-03               tcj=8.55e-04
+ pbswgs=0.7                pbsws=0.8                 pbs=0.8
+ mjswgs=0.98               mjsws=0.01                mjs=0.36
+ ngcon=1                   saref=0.63e-6             sbref=0.63e-6
+ kvsat=-0.5                wlod=0.8e-6               tku0=0.1
+ ku0=1.3249e-7             llodku0=1                 wlodku0=1
+ lku0=1.33e-7              wku0=6.5e-7               pku0=0
+ kvth0=-1.5e-9             stk2=4e-10                steta0=0
+ lkvth0=-1.68e-15          wkvth0=0.5e-6             pkvth0=0
+ llodvth=2                 wlodvth=1                 lodk2=2
+ lodeta0=1                 fnoimod=1                 tnoimod=0
+ noia=1.40e42              noib=8.00e26              noic=8.75
+ wpemod=wpeflag_lvt        kvth0we=-0.0028           lkvth0we=0
+ wkvth0we=0                pkvth0we=0                ku0we=-0.0045
+ lku0we=2.60e-10           wku0we=0                  pku0we=0
+ k2we=0.00045              wk2we=0                   web=-180
+ wec=-3000                 scref=1.00e-06            ud=0
+ em=1.00e07                ef=1.17                   minr=1e-3

     24: type=p
+ lmin=2.4000e-07-dxlp_lvt  lmax=5.0000e-07-dxlp_lvt  wmin=1.2e-07
+ wmax=2.4000e-07-dxwp_lvt  version=4.5               binunit=2
+ paramchk=1                mobmod=0                  capmod=2
+ igcmod=1                  igbmod=1                  diomod=1
+ rdsmod=0                  rbodymod=0                rgatemod=0
+ permod=1                  acnqsmod=0                trnqsmod=0
+ tnom=25                   toxe=toxp_lvt             toxm=toxp_lvt
+ dtox=5e-010               epsrox=3.9                wint=5e-009
+ lint=2.5e-009             ll=0                      wl=0
+ lln=1                     wln=1                     lw=0
+ ww=0                      lwn=1                     wwn=1
+ lwl=0                     wwl=0                     llc=0
+ wlc=0                     lwc=0                     wwc=0
+ lwlc=0                    wwlc=0                    dwc=0
+ xpart=1                   toxref=3e-009             dlcig=2.5e-009
+ xl=-3.5e-8+dxlp_lvt       xw=1.5e-8+dxwp_lvt        vth0=-0.16282372+dvthp_lvt
+ lvth0=-3.2435897e-009+dlvthp_lvt                    wvth0=-1.5508814e-009+dwvthp_lvt
+ pvth0=3.6121795e-016+dpvthp_lvt                     k1=0.15
+ k2=0.013501603+dk2p_lvt   lk2=-2.5211538e-009       wk2=6.2624199e-010
+ pk2=-4.8764423e-016       k3=-0.58                  k3b=0.8
+ w0=0                      dvt0=20                   dvt1=1.8
+ dvt2=-0.032               dvt0w=0                   dvt1w=0
+ dvt2w=0                   dsub=0.5                  minv=0
+ voffl=0                   dvtp0=5.5e-007            dvtp1=5
+ lpe0=0                    lpeb=4.5e-007             xj=1.7000001e-007
+ ngate=8e019               ndep=1.7200001e017        nsd=1e020
+ phin=0                    cdsc=0                    cdscb=0
+ cdscd=0                   cit=-0.00078525641        lcit=3.6121795e-010
+ wcit=9.8157051e-011       pcit=-4.5152244e-017      voff=-0.12421474
+ lvoff=1.8429487e-009+dlvoffp_lvt                    wvoff=2.2576122e-009
+ pvoff=-4.5152244e-016+dpvoffp_lvt                   nfactor=-0.28525641
+ lnfactor=3.6121795e-007   wnfactor=9.8157051e-008   pnfactor=-4.5152244e-014
+ eta0=0.075625+deta0p_lvt  peta0=0+dpeta0p_lvt       weta0=-3.828125e-009
+ etab=-0.070833333         wetab=5.1041667e-009      u0=0.0073125
+ lu0=1.6291667e-010        wu0=3.8045673e-010        pu0=-1.0926843e-016
+ ua=-6.0918558e-010        lua=4.4067115e-017        wua=6.4035697e-017
+ pua=-2.6955889e-023       ub=2.0194679e-018         lub=3.240641e-026
+ wub=-9.4270032e-026       pub=1.8241506e-032        uc=7.7564103e-012
+ luc=1.4448718e-017        wuc=9.0304487e-018        puc=-1.8060897e-024
+ vsat=100000               a0=3.6953558              lvsat=0+dlvsatp_lvt
+ pvsat=0+dpvsatp_lvt       la0=-1.6332949e-007       wa0=7.461899e-008
+ pa0=3.8108494e-014        ags=0.70258974            lags=1.1510321e-006
+ wags=-1.1386218e-007      pags=2.1853686e-014       a1=0
+ a2=1                      b0=0                      b1=0
+ keta=-0.25496795          lketa=1.474359e-008       wketa=2.5717147e-008
+ pketa=-3.6121795e-015     dwg=0                     dwb=0
+ pclm=1.3538462            lpclm=-7.0769231e-008     pdiblc1=0
+ pdiblc2=-0.011397436      lpdiblc2=3.2878205e-009   wpdiblc2=2.9054487e-009
+ ppdiblc2=-6.3213141e-016  pdiblcb=0                 drout=0
+ pvag=2                    delta=0.01                pscbe1=9.264e008
+ pscbe2=1e-020             fprout=1000               pdits=0
+ pditsd=0                  pditsl=0                  rdsw=210
+ prwg=0                    prwb=0                    wr=1
+ alpha0=0                  agidl=9e-008              bgidl=2.3e009
+ cgidl=0.5                 egidl=0.53                aigbacc=0.0117
+ bigbacc=0.0049            cigbacc=0.1498            nigbacc=2.025
+ aigbinv=0.35              bigbinv=0.03              cigbinv=0.006
+ eigbinv=1.1               nigbinv=1                 aigc=0.005997
+ bigc=0.0007088            cigc=5e-011               aigsd=0.00469
+ bigsd=9.291e-005          cigsd=0.001372            nigc=1
+ poxedge=1                 pigcd=2.3                 ntox=ntoxp_lvt
+ xrcrg1=12                 xrcrg2=1                  cgso=cgop_lvt
+ cgdo=cgop_lvt             cgbo=0                    cgdl=cglp_lvt
+ cgsl=cglp_lvt             clc=1e-007                cle=0.6
+ cf=cfp_lvt                ckappas=0.6               moin=11.09
+ noff=2.175                voffcv=-0.03885           kt1=-0.29775641
+ lkt1=-1.0615385e-008      wkt1=5.1041667e-009       pkt1=5.012906e-030
+ kt1l=0                    kt2=-0.03875              ute=-1.7864359
+ lute=8.7178846e-008       wute=1.2564103e-008       pute=-1.1649279e-014
+ ua1=-9.6150929e-010       lua1=2.7289353e-016       wua1=2.4906174e-016
+ pua1=-4.6208806e-023      ub1=1.3809615e-019        lub1=-2.8217756e-025
+ wub1=-5.6220433e-025      pub1=5.9510657e-032       uc1=-5e-012
+ wuc1=-3.0625e-017         prt=0                     at=294262.82
+ lat=-0.024769231          wat=-0.0025520833         njs=1
+ ijthsfwd=0.01             ijthsrev=0.01             bvs=10
+ xjbvs=1                   cjs=cjp_lvt               cjsws=cjswp_lvt
+ cjswgs=cjswgp_lvt         xtis=3                    dmcg=9.25e-008
+ dmci=9.25e-008            dmdg=0                    dmcgt=0
+ dwj=0                     xgw=0                     xgl=0
+ rshg=0.1                  gbmin=1e-012              rbpb=50
+ rbpd=50                   rbps=50                   rbdb=50
+ rbsb=50                   rsh=9.68                  acde=1.2
+ dlc=1.53e-008             beta0=8                   alpha1=0.003
+ jswgs=3.00e-12            jsws=3.47e-13             jss=1.56e-07
+ tpbswg=1.9e-03            tcjswg=4.01e-03           tpbsw=1.9e-03
+ tcjsw=1.9e-04             tpb=1.9e-03               tcj=8.55e-04
+ pbswgs=0.7                pbsws=0.8                 pbs=0.8
+ mjswgs=0.98               mjsws=0.01                mjs=0.36
+ ngcon=1                   saref=0.63e-6             sbref=0.63e-6
+ kvsat=-0.5                wlod=0.8e-6               tku0=0.1
+ ku0=1.3249e-7             llodku0=1                 wlodku0=1
+ lku0=1.33e-7              wku0=6.5e-7               pku0=0
+ kvth0=-1.5e-9             stk2=4e-10                steta0=0
+ lkvth0=-1.68e-15          wkvth0=0.5e-6             pkvth0=0
+ llodvth=2                 wlodvth=1                 lodk2=2
+ lodeta0=1                 fnoimod=1                 tnoimod=0
+ noia=1.40e42              noib=8.00e26              noic=8.75
+ wpemod=wpeflag_lvt        kvth0we=-0.0028           lkvth0we=0
+ wkvth0we=0                pkvth0we=0                ku0we=-0.0045
+ lku0we=2.60e-10           wku0we=0                  pku0we=0
+ k2we=0.00045              wk2we=0                   web=-180
+ wec=-3000                 scref=1.00e-06            ud=0
+ em=1.00e07                ef=1.17                   minr=1e-3

     25: type=p
+ lmin=1.0e-07              lmax=2.4000e-07-dxlp_lvt  wmin=1.2e-07
+ wmax=2.4000e-07-dxwp_lvt  version=4.5               binunit=2
+ paramchk=1                mobmod=0                  capmod=2
+ igcmod=1                  igbmod=1                  diomod=1
+ rdsmod=0                  rbodymod=0                rgatemod=0
+ permod=1                  acnqsmod=0                trnqsmod=0
+ tnom=25                   toxe=toxp_lvt             toxm=toxp_lvt
+ dtox=5e-010               epsrox=3.9                wint=5e-009
+ lint=2.5e-009             ll=0                      wl=0
+ lln=1                     wln=1                     lw=0
+ ww=0                      lwn=1                     wwn=1
+ lwl=0                     wwl=0                     llc=0
+ wlc=0                     lwc=0                     wwc=0
+ lwlc=0                    wwlc=0                    dwc=0
+ xpart=1                   toxref=3e-009             dlcig=2.5e-009
+ xl=-3.5e-8+dxlp_lvt       xw=1.5e-8+dxwp_lvt        vth0=-0.16279167+dvthp_lvt
+ lvth0=-3.25e-009+dlvthp_lvt                         wvth0=4.7395833e-010+dwvthp_lvt
+ pvth0=-4.375e-017+dpvthp_lvt                        k1=0.15
+ k2=0.010358333+dk2p_lvt   lk2=-1.8925e-009          wk2=-2.5447917e-009
+ pk2=1.465625e-016         k3=-0.58                  k3b=0.8
+ w0=0                      dvt0=20                   dvt1=1.8
+ dvt2=-0.061142857         ldvt2=5.8285714e-009      dvt0w=0
+ dvt1w=0                   dvt2w=0                   dsub=0.5
+ minv=0                    voffl=0                   dvtp0=5.5e-007
+ dvtp1=5                   lpe0=0                    lpeb=4.5e-007
+ xj=1.7000001e-007         ngate=8e019               ndep=1.7200001e017
+ nsd=1e020                 phin=0                    cdsc=0
+ cdscb=0                   cdscd=0                   cit=-0.00048809524
+ lcit=3.0178571e-010       wcit=-7.2916667e-011      pcit=-1.09375e-017
+ voff=-0.10214286          lvoff=-2.5714286e-009+dlvoffp_lvt
+ pvoff=0+dpvoffp_lvt       nfactor=1.7440476         lnfactor=-4.4642857e-008
+ wnfactor=-1.8229167e-007  pnfactor=1.09375e-014     eta0=0.075625+deta0p_lvt
+ peta0=0+dpeta0p_lvt       weta0=-3.828125e-009      etab=-0.083869048
+ letab=2.6071429e-009      wetab=6.1979167e-009      petab=-2.1875e-016
+ u0=0.0095090476           lu0=-2.7639286e-010       wu0=-2.5666667e-010
+ pu0=1.815625e-017         ua=6.6785714e-012         lua=-7.9105714e-017
+ wua=-1.1615625e-016       pua=9.0825e-024           ub=1.8257321e-018
+ lub=7.1153571e-026        wub=1.8265625e-026        pub=-4.265625e-033
+ uc=4.3303571e-011         luc=7.3392857e-018        wuc=1.640625e-018
+ puc=-3.28125e-025         vsat=100000               a0=2.0641726
+ la0=1.6290714e-007        lvsat=0+dlvsatp_lvt       pvsat=0+dpvsatp_lvt
+ wa0=1.6431771e-007        pa0=2.016875e-014         ags=-3.5621429
+ lags=2.0039786e-006       wags=3.9375e-008          pags=-8.79375e-015
+ a1=0                      a2=1                      b0=0
+ b1=0                      keta=-0.22464286          lketa=8.6785714e-009
+ wketa=1.09375e-008        pketa=-6.5625e-016        dwg=0
+ dwb=0                     pclm=1.2142857            lpclm=-4.2857143e-008
+ pdiblc1=0                 pdiblc2=0.0065130952      lpdiblc2=-2.9428571e-010
+ wpdiblc2=-3.4270833e-010  ppdiblc2=1.75e-017        pdiblcb=0
+ drout=0                   pvag=2                    delta=0.01
+ pscbe1=9.264e008          pscbe2=1e-020             fprout=1000
+ pdits=0                   pditsd=0                  pditsl=0
+ rdsw=210                  prwg=0                    prwb=0
+ wr=1                      alpha0=0                  agidl=9e-008
+ bgidl=2.3e009             cgidl=0.5                 egidl=0.53
+ aigbacc=0.0117            bigbacc=0.0049            cigbacc=0.1498
+ nigbacc=2.025             aigbinv=0.35              bigbinv=0.03
+ cigbinv=0.006             eigbinv=1.1               nigbinv=1
+ aigc=0.005997             bigc=0.0007088            cigc=5e-011
+ aigsd=0.00469             bigsd=9.291e-005          cigsd=0.001372
+ nigc=1                    poxedge=1                 pigcd=2.3
+ ntox=ntoxp_lvt            xrcrg1=12                 xrcrg2=1
+ cgso=cgop_lvt             cgdo=cgop_lvt             cgbo=0
+ cgdl=cglp_lvt             cgsl=cglp_lvt             clc=1e-007
+ cle=0.6                   cf=cfp_lvt                ckappas=0.6
+ moin=11.09                noff=2.175                voffcv=-0.03885
+ kt1=-0.32083333           lkt1=-6e-009              wkt1=5.1041667e-009
+ kt1l=0                    kt2=-0.03875              ute=-1.3923988
+ lute=8.3714286e-009       wute=-3.8682292e-008      pute=-1.4e-015
+ ua1=2.6894048e-010        lua1=2.6803571e-017       wua1=5.0852083e-017
+ pua1=-6.566875e-024       ub1=-1.3968631e-018       lub1=2.4814286e-026
+ wub1=-2.6596354e-025      pub1=2.625e-034           uc1=-5e-012
+ wuc1=-3.0625e-017         prt=0                     at=207113.1
+ lat=-0.0073392857         wat=-0.0041927083         pat=3.28125e-010
+ njs=1                     ijthsfwd=0.01             ijthsrev=0.01
+ bvs=10                    xjbvs=1                   cjs=cjp_lvt
+ cjsws=cjswp_lvt           cjswgs=cjswgp_lvt         xtis=3
+ dmcg=9.25e-008            dmci=9.25e-008            dmdg=0
+ dmcgt=0                   dwj=0                     xgw=0
+ xgl=0                     rshg=0.1                  gbmin=1e-012
+ rbpb=50                   rbpd=50                   rbps=50
+ rbdb=50                   rbsb=50                   rsh=9.68
+ acde=1.2                  dlc=1.53e-008             beta0=8
+ alpha1=0.003              jswgs=3.00e-12            jsws=3.47e-13
+ jss=1.56e-07              tpbswg=1.9e-03            tcjswg=4.01e-03
+ tpbsw=1.9e-03             tcjsw=1.9e-04             tpb=1.9e-03
+ tcj=8.55e-04              pbswgs=0.7                pbsws=0.8
+ pbs=0.8                   mjswgs=0.98               mjsws=0.01
+ mjs=0.36                  ngcon=1                   saref=0.63e-6
+ sbref=0.63e-6             kvsat=-0.5                wlod=0.8e-6
+ tku0=0.1                  ku0=1.3249e-7             llodku0=1
+ wlodku0=1                 lku0=1.33e-7              wku0=6.5e-7
+ pku0=0                    kvth0=-1.5e-9             stk2=4e-10
+ steta0=0                  lkvth0=-1.68e-15          wkvth0=0.5e-6
+ pkvth0=0                  llodvth=2                 wlodvth=1
+ lodk2=2                   lodeta0=1                 fnoimod=1
+ tnoimod=0                 noia=1.40e42              noib=8.00e26
+ noic=8.75                 wpemod=wpeflag_lvt        kvth0we=-0.0028
+ lkvth0we=0                wkvth0we=0                pkvth0we=0
+ ku0we=-0.0045             lku0we=2.60e-10           wku0we=0
+ pku0we=0                  k2we=0.00045              wk2we=0
+ web=-180                  wec=-3000                 scref=1.00e-06
+ ud=0                      em=1.00e07                ef=1.17
+ minr=1e-3

     }
endsection mos_lvt

//  ********************************************************************************************
//

section mos_18
//  ********************************************************************************************
//
//                *
//                                    1.8V NMOS DEVICE MODELS
//                  *
//
//                *
//  ********************************************************************************************

model nch_18 bsim4  {
     1: type=n
+ lmin=1e-005-dxln_18       lmax=0.0009001            wmin=1e-005-dxwn_18
+ wmax=0.0009001            version=4.5               binunit=2
+ paramchk=1                mobmod=0                  capmod=2
+ igcmod=0                  igbmod=0                  geomod=0
+ diomod=1                  rdsmod=0                  rbodymod=0
+ rgatemod=0                permod=1                  acnqsmod=0
+ trnqsmod=0                tempmod=0                 tnom=25
+ toxe=toxn_18              toxm=toxn_18              dtox=2.15e-010
+ epsrox=3.9                wint=1e-008               lint=6.25e-009
+ ll=0                      wl=0                      lln=1
+ wln=1                     lw=0                      ww=0
+ lwn=1                     wwn=1                     lwl=0
+ wwl=0                     llc=0                     wlc=0
+ lwc=0                     wwc=0                     lwlc=0
+ wwlc=0                    xl=-5.5e-08+dxln_18       xw=0+dxwn_18
+ dlc=dlcn_18               dwc=0                     xpart=1
+ toxref=3e-009             dlcig=6.25e-009           vth0=0.352+dvthn_18
+ k1=0.5288                 k2=0.0013+dk2n_18         k3=-0.85
+ k3b=0.9                   w0=0                      dvt0=0
+ dvt1=0                    dvt2=0                    dvt0w=0
+ dvt1w=0                   dvt2w=0                   dsub=0.32
+ minv=-0.3                 voffl=0                   dvtp0=1.4e-006
+ dvtp1=0.06                lpe0=3.2e-008             lpeb=0
+ xj=1.5e-007               ngate=4e+020              ndep=4.2e+017
+ nsd=1e+020                phin=0                    cdsc=0
+ cdscb=0                   cdscd=0                   cit=0
+ voff=-0.1215              nfactor=1.4               eta0=0.033
+ etab=-0.058               u0=0.05183158             ua=2.479073e-010
+ ub=2.400418e-018          uc=2.49e-010              vsat=96500.88
+ a0=1.177707               ags=0.5753095             a1=0
+ a2=0.8                    b0=0                      b1=0
+ keta=-0.06                dwg=0                     dwb=0
+ pclm=0.2                  pdiblc1=0                 pdiblc2=0.00095
+ pdiblcb=0                 drout=0.56                pvag=0.8
+ delta=0.012               pscbe1=7.506e+008         pscbe2=1e-020
+ fprout=0                  pdits=0                   pditsd=0
+ pditsl=0                  rsh=10.5                  rdsw=150+drdswn_18
+ prwg=0                    prwb=0                    wr=1
+ alpha0=0                  alpha1=2.2950             beta0=17.8
+ agidl=2.56e-012           bgidl=8.66e+008           cgidl=0.25
+ egidl=0.2624              aigbacc=0.01213           bigbacc=0.006537
+ cigbacc=0.2809            nigbacc=4.05              aigbinv=0.35
+ bigbinv=0.03              cigbinv=0.006             eigbinv=1.1
+ nigbinv=1                 aigc=0.01                 bigc=0.00144
+ cigc=1.515e-005           aigsd=0.008379            bigsd=0.0002699
+ cigsd=3.925e-020          nigc=1                    poxedge=1
+ pigcd=2.171               ntox=1                    xrcrg1=12
+ xrcrg2=1                  cgso=cgon_18              cgdo=cgon_18
+ cgbo=0                    cgdl=cgln_18              cgsl=cgln_18
+ clc=1e-007                cle=0.6                   cf=cfn_18
+ ckappas=0.6               ckappad=0.6               acde=0.4
+ moin=5                    noff=1.695                voffcv=-0.07
+ kt1=-0.26                 kt1l=0                    kt2=-0.02
+ ute=-1.63                 ua1=2.700668e-009         ub1=-3.63e-018
+ uc1=-1.7e-010             prt=0                     at=220000
+ jss=2.85e-07              jsd=2.85e-07              jsws=6.9e-13
+ jswd=6.9e-13              jswgs=6.9e-13             jswgd=6.9e-13
+ njs=1                     njd=1                     ijthsfwd=0.01
+ ijthdfwd=0.01             ijthsrev=0.01             ijthdrev=0.01
+ bvs=10                    bvd=10                    xjbvs=1
+ xjbvd=1                   pbs=0.613                 pbd=0.613
+ cjs=cjn_18                cjd=cjn_18                mjs=0.279
+ mjd=0.279                 pbsws=0.613               pbswd=0.613
+ cjsws=cjswn_18            cjswd=cjswn_18            mjsws=0.01
+ mjswd=0.01                pbswgs=0.952              pbswgd=0.952
+ cjswgs=cjswgn_18          cjswgd=cjswgn_18          mjswgs=0.541
+ mjswgd=0.541              tpb=0.00133               tcj=0.000766
+ tpbsw=0.00133             tcjsw=0.0001              tpbswg=0.00133
+ tcjswg=0.00088            xtis=3                    xtid=3
+ jtsswgs=1.000e-08         jtsswgd=1.000e-08         njtsswg=40.31
+ xtsswgs=0.4558            xtsswgd=0.4558            tnjtsswg=1
+ dmcg=1.255e-007           dmci=1.255e-007           dmdg=0
+ dmcgt=0                   dwj=0                     xgw=0
+ xgl=0                     rshg=1                    gbmin=1e-012
+ rbpb=50                   rbpd=50                   rbps=50
+ rbdb=50                   rbsb=50                   ngcon=1
+ lvth0=0+dlvthn_18         wvth0=0+dwvthn_18         lvsat=0+dlvsatn_18
+ lpclm=0+dlpclmn_18        saref=0.82e-6             sbref=0.82e-6
+ kvsat=0.40                wlod=0.15e-6              tku0=0.1
+ ku0=-7.0e-8               llodku0=1                 wlodku0=1
+ lku0=2.0e-7               wku0=0.2e-6               pku0=0.5e-13
+ kvth0=4e-9                stk2=0                    steta0=0
+ lkvth0=-4.68e-11          wkvth0=7e-7               pkvth0=0
+ llodvth=1                 wlodvth=1                 lodk2=1
+ lodeta0=1                 fnoimod=1                 noia=5.3e+41
+ noib=1.0e+20              noic=1.0e+7               em=1.00e+07
+ ef=0.92                   tnoimod=0                 ud=0
+ wpemod=wpeflag_18         kvth0we=4.5e-3            lkvth0we=0.0e-11
+ wkvth0we=0                pkvth0we=0                ku0we=-2e-4
+ lku0we=0                  wku0we=0                  pku0we=0
+ k2we=0.0                  wk2we=0                   web=0
+ wec=0                     scref=1e-6                lnfactor=0+dlnfactorn_18
+ minr=1e-3

     2: type=n
+ lmin=1.2e-006-dxln_18     lmax=1e-005-dxln_18       wmin=1e-005-dxwn_18
+ wmax=0.0009001            version=4.5               binunit=2
+ paramchk=1                mobmod=0                  capmod=2
+ igcmod=0                  igbmod=0                  geomod=0
+ diomod=1                  rdsmod=0                  rbodymod=0
+ rgatemod=0                permod=1                  acnqsmod=0
+ trnqsmod=0                tempmod=0                 tnom=25
+ toxe=toxn_18              toxm=toxn_18              dtox=2.15e-010
+ epsrox=3.9                wint=1e-008               lint=6.25e-009
+ ll=0                      wl=0                      lln=1
+ wln=1                     lw=0                      ww=0
+ lwn=1                     wwn=1                     lwl=0
+ wwl=0                     llc=0                     wlc=0
+ lwc=0                     wwc=0                     lwlc=0
+ wwlc=0                    xl=-5.5e-08+dxln_18       xw=0+dxwn_18
+ dlc=dlcn_18               dwc=0                     xpart=1
+ toxref=3e-009             dlcig=6.25e-009           vth0=0.35225739+dvthn_18
+ lvth0=-2.5564901e-009+dlvthn_18                     k1=0.5288
+ k2=0.0017118182+dk2n_18   lk2=-4.0903841e-009       k3=-0.85
+ k3b=0.9                   w0=0                      dvt0=0
+ dvt1=0                    dvt2=0                    dvt0w=0
+ dvt1w=0                   dvt2w=0                   dsub=0.32
+ minv=-0.3                 voffl=0                   dvtp0=1.4e-006
+ dvtp1=0.06                lpe0=3.2e-008             lpeb=0
+ xj=1.5e-007               ngate=4e+020              ndep=4.2e+017
+ nsd=1e+020                phin=0                    cdsc=0
+ cdscb=0                   cdscd=0                   cit=0
+ voff=-0.12085653          lvoff=-6.3912251e-009     nfactor=1.4
+ eta0=0.033                etab=-0.058               u0=0.05183158
+ ua=2.644865e-010          lua=-1.6467286e-016       ub=2.3966578e-018
+ lub=3.7347763e-026        uc=2.4887131e-010         luc=1.278245e-018
+ vsat=96500.88             a0=1.2217617              la0=-4.3757306e-007
+ ags=0.55900459            lags=1.6194853e-007       a1=0
+ a2=0.8                    b0=0                      b1=0
+ keta=-0.058198295         lketa=-1.789543e-008      dwg=0
+ dwb=0                     pclm=0.18455682           lpclm=1.533894e-007+dlpclmn_18
+ pdiblc1=0                 pdiblc2=0.00068617898     lpdiblc2=2.6204023e-009
+ pdiblcb=0                 drout=0.56                pvag=0.8
+ delta=0.012               pscbe1=7.506e+008         pscbe2=1e-020
+ fprout=0                  pdits=0                   pditsd=0
+ pditsl=0                  rsh=10.5                  rdsw=150+drdswn_18
+ prwg=0                    prwb=0                    wr=1
+ alpha0=0                  alpha1=2.2950             beta0=17.8
+ agidl=2.56e-012           bgidl=8.66e+008           cgidl=0.25
+ egidl=0.2624              aigbacc=0.01213           bigbacc=0.006537
+ cigbacc=0.2809            nigbacc=4.05              aigbinv=0.35
+ bigbinv=0.03              cigbinv=0.006             eigbinv=1.1
+ nigbinv=1                 aigc=0.01                 bigc=0.00144
+ cigc=1.515e-005           aigsd=0.008379            bigsd=0.0002699
+ cigsd=3.925e-020          nigc=1                    poxedge=1
+ pigcd=2.171               ntox=1                    xrcrg1=12
+ xrcrg2=1                  cgso=cgon_18              cgdo=cgon_18
+ cgbo=0                    cgdl=cgln_18              cgsl=cgln_18
+ clc=1e-007                cle=0.6                   cf=cfn_18
+ ckappas=0.6               ckappad=0.6               acde=0.4
+ moin=5                    noff=1.695                voffcv=-0.07
+ kt1=-0.26                 kt1l=0                    kt2=-0.02
+ ute=-1.6467703            lute=1.6657067e-007       ua1=2.6936591e-009
+ lua1=6.9615781e-017       ub1=-3.5993942e-018       lub1=-3.0399223e-025
+ uc1=-1.7257386e-010       luc1=2.5564901e-017       prt=0
+ at=234799.72              lat=-0.14699818           jss=2.85e-07
+ jsd=2.85e-07              jsws=6.9e-13              jswd=6.9e-13
+ jswgs=6.9e-13             jswgd=6.9e-13             njs=1
+ njd=1                     ijthsfwd=0.01             ijthdfwd=0.01
+ ijthsrev=0.01             ijthdrev=0.01             bvs=10
+ bvd=10                    xjbvs=1                   xjbvd=1
+ pbs=0.613                 pbd=0.613                 cjs=cjn_18
+ cjd=cjn_18                mjs=0.279                 mjd=0.279
+ pbsws=0.613               pbswd=0.613               cjsws=cjswn_18
+ cjswd=cjswn_18            mjsws=0.01                mjswd=0.01
+ pbswgs=0.952              pbswgd=0.952              cjswgs=cjswgn_18
+ cjswgd=cjswgn_18          mjswgs=0.541              mjswgd=0.541
+ tpb=0.00133               tcj=0.000766              tpbsw=0.00133
+ tcjsw=0.0001              tpbswg=0.00133            tcjswg=0.00088
+ xtis=3                    xtid=3                    jtsswgs=1.000e-08
+ jtsswgd=1.000e-08         njtsswg=40.31             xtsswgs=0.4558
+ xtsswgd=0.4558            tnjtsswg=1                dmcg=1.255e-007
+ dmci=1.255e-007           dmdg=0                    dmcgt=0
+ dwj=0                     xgw=0                     xgl=0
+ rshg=1                    gbmin=1e-012              rbpb=50
+ rbpd=50                   rbps=50                   rbdb=50
+ rbsb=50                   ngcon=1                   wvth0=0+dwvthn_18
+ saref=0.82e-6             sbref=0.82e-6             kvsat=0.40
+ wlod=0.15e-6              tku0=0.1                  ku0=-7.0e-8
+ llodku0=1                 wlodku0=1                 lku0=2.0e-7
+ wku0=0.2e-6               pku0=0.5e-13              kvth0=4e-9
+ stk2=0                    steta0=0                  lkvth0=-4.68e-11
+ wkvth0=7e-7               pkvth0=0                  llodvth=1
+ wlodvth=1                 lodk2=1                   lodeta0=1
+ fnoimod=1                 noia=5.3e+41              noib=1.0e+20
+ noic=1.0e+7               em=1.00e+07               ef=0.92
+ tnoimod=0                 ud=0                      wpemod=wpeflag_18
+ kvth0we=4.5e-3            lkvth0we=0.0e-11          wkvth0we=0
+ pkvth0we=0                ku0we=-2e-4               lku0we=0
+ wku0we=0                  pku0we=0                  k2we=0.0
+ wk2we=0                   web=0                     wec=0
+ scref=1e-6                lvsat=0+dlvsatn_18        lnfactor=0+dlnfactorn_18
+ minr=1e-3

     3: type=n
+ lmin=7e-007-dxln_18       lmax=1.2e-006-dxln_18     wmin=1e-005-dxwn_18
+ wmax=0.0009001            version=4.5               binunit=2
+ paramchk=1                mobmod=0                  capmod=2
+ igcmod=0                  igbmod=0                  geomod=0
+ diomod=1                  rdsmod=0                  rbodymod=0
+ rgatemod=0                permod=1                  acnqsmod=0
+ trnqsmod=0                tempmod=0                 tnom=25
+ toxe=toxn_18              toxm=toxn_18              dtox=2.15e-010
+ epsrox=3.9                wint=1e-008               lint=6.25e-009
+ ll=0                      wl=0                      lln=1
+ wln=1                     lw=0                      ww=0
+ lwn=1                     wwn=1                     lwl=0
+ wwl=0                     llc=0                     wlc=0
+ lwc=0                     wwc=0                     lwlc=0
+ wwlc=0                    xl=-5.5e-08+dxln_18       xw=0+dxwn_18
+ dlc=dlcn_18               dwc=0                     xpart=1
+ toxref=3e-009             dlcig=6.25e-009           vth0=0.35+dvthn_18
+ k1=0.5288                 k2=0.0083465+dk2n_18      lk2=-1.1604161e-008
+ k3=-0.85                  k3b=0.9                   w0=0
+ dvt0=0                    dvt1=0                    dvt2=0
+ dvt0w=0                   dvt1w=0                   dvt2w=0
+ dsub=0.32                 minv=-0.3                 voffl=0
+ dvtp0=1.4e-006            dvtp1=0.06                lpe0=3.2e-008
+ lpeb=0                    xj=1.5e-007               ngate=4e+020
+ ndep=4.2e+017             nsd=1e+020                phin=0
+ cdsc=0                    cdscb=0                   cdscd=0
+ cit=-0.000506             lcit=5.73045e-010         voff=-0.12397
+ lvoff=-2.865225e-009      nfactor=1.4               eta0=0.033
+ etab=-0.058               u0=0.05183158             ua=2.3830927e-010
+ lua=-1.3502715e-016       ub=2.4102005e-018         lub=2.2010658e-026
+ uc=2.6518e-010            luc=-1.719135e-017        vsat=96500.728
+ lvsat=1.719135e-007+dlvsatn_18                      a0=1.0741751
+ la0=-2.7043125e-007       ags=0.74957886            lags=-5.3876831e-008
+ a1=0                      a2=0.8                    b0=0
+ b1=0                      keta=-0.090445            lketa=1.8623962e-008
+ dwg=0                     dwb=0                     pclm=0.32
+ pdiblc1=0                 pdiblc2=-0.0014275        lpdiblc2=5.0141437e-009
+ pdiblcb=0                 drout=0.56                pvag=0.8
+ delta=0.012               pscbe1=7.506e+008         pscbe2=1e-020
+ fprout=0                  pdits=0                   pditsd=0
+ pditsl=0                  rsh=10.5                  rdsw=150+drdswn_18
+ prwg=0                    prwb=0                    wr=1
+ alpha0=0                  alpha1=2.2950             beta0=17.8
+ agidl=2.56e-012           bgidl=8.66e+008           cgidl=0.25
+ egidl=0.2624              aigbacc=0.01213           bigbacc=0.006537
+ cigbacc=0.2809            nigbacc=4.05              aigbinv=0.35
+ bigbinv=0.03              cigbinv=0.006             eigbinv=1.1
+ nigbinv=1                 aigc=0.01                 bigc=0.00144
+ cigc=1.515e-005           aigsd=0.008379            bigsd=0.0002699
+ cigsd=3.925e-020          nigc=1                    poxedge=1
+ pigcd=2.171               ntox=1                    xrcrg1=12
+ xrcrg2=1                  cgso=cgon_18              cgdo=cgon_18
+ cgbo=0                    cgdl=cgln_18              cgsl=cgln_18
+ clc=1e-007                cle=0.6                   cf=cfn_18
+ ckappas=0.6               ckappad=0.6               acde=0.4
+ moin=5                    noff=1.695                voffcv=-0.07
+ kt1=-0.22363125           lkt1=-4.1187609e-008      kt1l=0
+ kt2=-0.02                 ute=-2.1271128            lute=7.1055861e-007
+ ua1=1.4098404e-009        lua1=1.5235404e-015       ub1=-4.2973128e-018
+ lub1=4.864006e-025        uc1=-1.5e-010             prt=0
+ at=161925                 lat=-0.064467562          jss=2.85e-07
+ jsd=2.85e-07              jsws=6.9e-13              jswd=6.9e-13
+ jswgs=6.9e-13             jswgd=6.9e-13             njs=1
+ njd=1                     ijthsfwd=0.01             ijthdfwd=0.01
+ ijthsrev=0.01             ijthdrev=0.01             bvs=10
+ bvd=10                    xjbvs=1                   xjbvd=1
+ pbs=0.613                 pbd=0.613                 cjs=cjn_18
+ cjd=cjn_18                mjs=0.279                 mjd=0.279
+ pbsws=0.613               pbswd=0.613               cjsws=cjswn_18
+ cjswd=cjswn_18            mjsws=0.01                mjswd=0.01
+ pbswgs=0.952              pbswgd=0.952              cjswgs=cjswgn_18
+ cjswgd=cjswgn_18          mjswgs=0.541              mjswgd=0.541
+ tpb=0.00133               tcj=0.000766              tpbsw=0.00133
+ tcjsw=0.0001              tpbswg=0.00133            tcjswg=0.00088
+ xtis=3                    xtid=3                    jtsswgs=1.000e-08
+ jtsswgd=1.000e-08         njtsswg=40.31             xtsswgs=0.4558
+ xtsswgd=0.4558            tnjtsswg=1                vtsswgs=10
+ vtsswgd=10                dmcg=1.255e-007           dmci=1.255e-007
+ dmdg=0                    dmcgt=0                   dwj=0
+ xgw=0                     xgl=0                     rshg=1
+ gbmin=1e-012              rbpb=50                   rbpd=50
+ rbps=50                   rbdb=50                   rbsb=50
+ ngcon=1                   lvth0=0+dlvthn_18         saref=0.82e-6
+ sbref=0.82e-6             kvsat=0.40                wlod=0.15e-6
+ tku0=0.1                  ku0=-7.0e-8               llodku0=1
+ wlodku0=1                 lku0=2.0e-7               wku0=0.2e-6
+ pku0=0.5e-13              kvth0=4e-9                stk2=0
+ steta0=0                  lkvth0=-4.68e-11          wkvth0=7e-7
+ pkvth0=0                  llodvth=1                 wlodvth=1
+ lodk2=1                   lodeta0=1                 fnoimod=1
+ noia=5.3e+41              noib=1.0e+20              noic=1.0e+7
+ em=1.00e+07               ef=0.92                   tnoimod=0
+ ud=0                      wpemod=wpeflag_18         kvth0we=4.5e-3
+ lkvth0we=0.0e-11          wkvth0we=0                pkvth0we=0
+ ku0we=-2e-4               lku0we=0                  wku0we=0
+ pku0we=0                  k2we=0.0                  wk2we=0
+ web=0                     wec=0                     scref=1e-6
+ wvth0=0+dwvthn_18         lpclm=0+dlpclmn_18        lnfactor=0+dlnfactorn_18
+ minr=1e-3

     4: type=n
+ lmin=4e-007-dxln_18       lmax=7e-007-dxln_18       wmin=1e-005-dxwn_18
+ wmax=0.0009001            version=4.5               binunit=2
+ paramchk=1                mobmod=0                  capmod=2
+ igcmod=0                  igbmod=0                  geomod=0
+ diomod=1                  rdsmod=0                  rbodymod=0
+ rgatemod=0                permod=1                  acnqsmod=0
+ trnqsmod=0                tempmod=0                 tnom=25
+ toxe=toxn_18              toxm=toxn_18              dtox=2.15e-010
+ epsrox=3.9                wint=1e-008               lint=6.25e-009
+ ll=0                      wl=0                      lln=1
+ wln=1                     lw=0                      ww=0
+ lwn=1                     wwn=1                     lwl=0
+ wwl=0                     llc=0                     wlc=0
+ lwc=0                     wwc=0                     lwlc=0
+ wwlc=0                    xl=-5.5e-08+dxln_18       xw=0+dxwn_18
+ dlc=dlcn_18               dwc=0                     xpart=1
+ toxref=3e-009             dlcig=6.25e-009           vth0=0.35775833+dvthn_18
+ lvth0=-4.9071458e-009+dlvthn_18                     k1=0.5288
+ k2=0.0044083333+dk2n_18   lk2=-9.1132708e-009       k3=-0.85
+ k3b=0.9                   w0=0                      dvt0=0
+ dvt1=0                    dvt2=0                    dvt0w=0
+ dvt1w=0                   dvt2w=0                   dsub=0.32
+ minv=-0.3                 voffl=0                   dvtp0=1.4e-006
+ dvtp1=0.06                lpe0=3.2e-008             lpeb=0
+ xj=1.5e-007               ngate=4e+020              ndep=4.2e+017
+ nsd=1e+020                phin=0                    cdsc=0
+ cdscb=0                   cdscd=0                   cit=0.0004
+ voff=-0.13404167          lvoff=3.5051042e-009      nfactor=1.4
+ eta0=0.033                etab=-0.058               u0=0.05183158
+ ua=-3.0780122e-011        lua=3.5171891e-017        ub=2.7830417e-018
+ lub=-2.1381135e-025       uc=2.4686667e-010         luc=-5.6081667e-018
+ vsat=96501                a0=0.74428889             la0=-6.1778232e-008
+ ags=1.2899393             lags=-3.9565483e-007      a1=0
+ a2=0.8                    b0=0                      b1=0
+ keta=-0.089816667         lketa=1.8226542e-008      dwg=0
+ dwb=0                     pclm=0.24241667           lpclm=4.9071458e-008+dlpclmn_18
+ pdiblc1=0                 pdiblc2=0.004505          lpdiblc2=1.2618375e-009
+ pdiblcb=0.44333333        lpdiblcb=-2.8040833e-007  drout=0.56
+ pvag=0.8                  delta=0.012               pscbe1=7.506e+008
+ pscbe2=1e-020             fprout=0                  pdits=0
+ pditsd=0                  pditsl=0                  rsh=10.5
+ rdsw=150+drdswn_18        prwg=0                    prwb=0
+ wr=1                      alpha0=0                  alpha1=2.2950
+ beta0=17.8                agidl=2.56e-012           bgidl=8.66e+008
+ cgidl=0.25                egidl=0.2624              aigbacc=0.01213
+ bigbacc=0.006537          cigbacc=0.2809            nigbacc=4.05
+ aigbinv=0.35              bigbinv=0.03              cigbinv=0.006
+ eigbinv=1.1               nigbinv=1                 aigc=0.01
+ bigc=0.00144              cigc=1.515e-005           aigsd=0.008379
+ bigsd=0.0002699           cigsd=3.925e-020          nigc=1
+ poxedge=1                 pigcd=2.171               ntox=1
+ xrcrg1=12                 xrcrg2=1                  cgso=cgon_18
+ cgdo=cgon_18              cgbo=0                    cgdl=cgln_18
+ cgsl=cgln_18              clc=1e-007                cle=0.6
+ cf=cfn_18                 ckappas=0.6               ckappad=0.6
+ acde=0.4                  moin=5                    noff=1.695
+ voffcv=-0.07              kt1=-0.27395375           lkt1=-9.3586281e-009
+ kt1l=0                    kt2=-0.02                 ute=-0.6475925
+ lute=-2.2523799e-007      ua1=4.637215e-009         lua1=-5.1777399e-016
+ ub1=-3.1011483e-018       lub1=-2.7017343e-025      uc1=-1.5e-010
+ prt=0                     at=98791.667              lat=-0.024535729
+ jss=2.85e-07              jsd=2.85e-07              jsws=6.9e-13
+ jswd=6.9e-13              jswgs=6.9e-13             jswgd=6.9e-13
+ njs=1                     njd=1                     ijthsfwd=0.01
+ ijthdfwd=0.01             ijthsrev=0.01             ijthdrev=0.01
+ bvs=10                    bvd=10                    xjbvs=1
+ xjbvd=1                   pbs=0.613                 pbd=0.613
+ cjs=cjn_18                cjd=cjn_18                mjs=0.279
+ mjd=0.279                 pbsws=0.613               pbswd=0.613
+ cjsws=cjswn_18            cjswd=cjswn_18            mjsws=0.01
+ mjswd=0.01                pbswgs=0.952              pbswgd=0.952
+ cjswgs=cjswgn_18          cjswgd=cjswgn_18          mjswgs=0.541
+ mjswgd=0.541              tpb=0.00133               tcj=0.000766
+ tpbsw=0.00133             tcjsw=0.0001              tpbswg=0.00133
+ tcjswg=0.00088            xtis=3                    xtid=3
+ jtsswgs=1.000e-08         jtsswgd=1.000e-08         njtsswg=40.31
+ xtsswgs=0.4558            xtsswgd=0.4558            tnjtsswg=1
+ dmcg=1.255e-007           dmci=1.255e-007           dmdg=0
+ dmcgt=0                   dwj=0                     xgw=0
+ xgl=0                     rshg=1                    gbmin=1e-012
+ rbpb=50                   rbpd=50                   rbps=50
+ rbdb=50                   rbsb=50                   ngcon=1
+ saref=0.82e-6             sbref=0.82e-6             kvsat=0.40
+ wlod=0.15e-6              tku0=0.1                  ku0=-7.0e-8
+ llodku0=1                 wlodku0=1                 lku0=2.0e-7
+ wku0=0.2e-6               pku0=0.5e-13              kvth0=4e-9
+ stk2=0                    steta0=0                  lkvth0=-4.68e-11
+ wkvth0=7e-7               pkvth0=0                  llodvth=1
+ wlodvth=1                 lodk2=1                   lodeta0=1
+ fnoimod=1                 noia=5.3e+41              noib=1.0e+20
+ noic=1.0e+7               em=1.00e+07               ef=0.92
+ tnoimod=0                 ud=0                      wpemod=wpeflag_18
+ kvth0we=4.5e-3            lkvth0we=0.0e-11          wkvth0we=0
+ pkvth0we=0                ku0we=-2e-4               lku0we=0
+ wku0we=0                  pku0we=0                  k2we=0.0
+ wk2we=0                   web=0                     wec=0
+ scref=1e-6                wvth0=0+dwvthn_18         lvsat=0+dlvsatn_18
+ lnfactor=0+dlnfactorn_18  minr=1e-3

     5: type=n
+ lmin=2e-07                lmax=4e-007-dxln_18       wmin=1e-005-dxwn_18
+ wmax=0.0009001            version=4.5               binunit=2
+ paramchk=1                mobmod=0                  capmod=2
+ igcmod=0                  igbmod=0                  geomod=0
+ diomod=1                  rdsmod=0                  rbodymod=0
+ rgatemod=0                permod=1                  acnqsmod=0
+ trnqsmod=0                tempmod=0                 tnom=25
+ toxe=toxn_18              toxm=toxn_18              dtox=2.15e-010
+ epsrox=3.9                wint=1e-008               lint=6.25e-009
+ ll=0                      wl=0                      lln=1
+ wln=1                     lw=0                      ww=0
+ lwn=1                     wwn=1                     lwl=0
+ wwl=0                     llc=0                     wlc=0
+ lwc=0                     wwc=0                     lwlc=0
+ wwlc=0                    xl=-5.5e-08+dxln_18       xw=0+dxwn_18
+ dlc=dlcn_18               dwc=0                     xpart=1
+ toxref=3e-009             dlcig=6.25e-009           vth0=0.3502875+dvthn_18
+ lvth0=-2.4230938e-009+dlvthn_18                     k1=0.5288
+ k2=-0.005775+dk2n_18      lk2=-5.7273125e-009       k3=-0.85
+ k3b=0.9                   w0=0                      dvt0=0
+ dvt1=0                    dvt2=0                    dvt0w=0
+ dvt1w=0                   dvt2w=0                   dsub=0.32
+ minv=-0.3                 voffl=0                   dvtp0=1.4e-006
+ dvtp1=0.06                lpe0=3.2e-008             lpeb=0
+ xj=1.5e-007               ngate=4e+020              ndep=4.2e+017
+ nsd=1e+020                phin=0                    cdsc=0
+ cdscb=0                   cdscd=0                   cit=0.000125725
+ lcit=9.1196438e-011       voff=-0.11124375          lvoff=-4.0752031e-009
+ nfactor=1.4               eta0=0.033                etab=-0.058
+ u0=0.056638402            lu0=-1.5982682e-009       ua=4.9101687e-010
+ lua=-1.3832561e-016       ub=1.7543588e-018         lub=1.2822572e-025
+ uc=1.882625e-010          luc=1.3877719e-017        vsat=96965.413
+ lvsat=-0.00015441716+dlvsatn_18                     a0=0.86223913
+ la0=-1.0099668e-007       ags=-0.043365             lags=4.7668863e-008
+ a1=0                      a2=0.8                    b0=0
+ b1=0                      keta=-0.0462625           lketa=3.7447813e-009
+ dwg=0                     dwb=0                     pclm=0.264125
+ lpclm=4.1853437e-008+dlpclmn_18                     pdiblc1=0
+ pdiblc2=0.0064960125      lpdiblc2=5.9982584e-010   pdiblcb=-0.665
+ lpdiblcb=8.81125e-008     drout=0.56                pvag=0.8
+ delta=0.012               pscbe1=7.506e+008         pscbe2=1e-020
+ fprout=0                  pdits=0                   pditsd=0
+ pditsl=0                  rsh=10.5                  rdsw=150+drdswn_18
+ prwg=0                    prwb=0                    wr=1
+ alpha0=0                  alpha1=2.2950             beta0=17.8
+ agidl=2.56e-012           bgidl=8.66e+008           cgidl=0.25
+ egidl=0.2624              aigbacc=0.01213           bigbacc=0.006537
+ cigbacc=0.2809            nigbacc=4.05              aigbinv=0.35
+ bigbinv=0.03              cigbinv=0.006             eigbinv=1.1
+ nigbinv=1                 aigc=0.01                 bigc=0.00144
+ cigc=1.515e-005           aigsd=0.008379            bigsd=0.0002699
+ cigsd=3.925e-020          nigc=1                    poxedge=1
+ pigcd=2.171               ntox=1                    xrcrg1=12
+ xrcrg2=1                  cgso=cgon_18              cgdo=cgon_18
+ cgbo=0                    cgdl=cgln_18              cgsl=cgln_18
+ clc=1e-007                cle=0.6                   cf=cfn_18
+ ckappas=0.6               ckappad=0.6               acde=0.4
+ moin=5                    noff=1.695                voffcv=-0.07
+ kt1=-0.2846895            lkt1=-5.7889912e-009      kt1l=0
+ kt2=-0.02                 ute=-0.99004              lute=-1.113742e-007
+ ua1=3.6333863e-009        lua1=-1.8400093e-016      ub1=-3.5156037e-018
+ lub1=-1.32367e-025        uc1=-8.52975e-012         luc1=-4.7038858e-017
+ prt=0                     at=25000                  jss=2.85e-07
+ jsd=2.85e-07              jsws=6.9e-13              jswd=6.9e-13
+ jswgs=6.9e-13             jswgd=6.9e-13             njs=1
+ njd=1                     ijthsfwd=0.01             ijthdfwd=0.01
+ ijthsrev=0.01             ijthdrev=0.01             bvs=10
+ bvd=10                    xjbvs=1                   xjbvd=1
+ pbs=0.613                 pbd=0.613                 cjs=cjn_18
+ cjd=cjn_18                mjs=0.279                 mjd=0.279
+ pbsws=0.613               pbswd=0.613               cjsws=cjswn_18
+ cjswd=cjswn_18            mjsws=0.01                mjswd=0.01
+ pbswgs=0.952              pbswgd=0.952              cjswgs=cjswgn_18
+ cjswgd=cjswgn_18          mjswgs=0.541              mjswgd=0.541
+ tpb=0.00133               tcj=0.000766              tpbsw=0.00133
+ tcjsw=0.0001              tpbswg=0.00133            tcjswg=0.00088
+ xtis=3                    xtid=3                    jtsswgs=1.000e-08
+ jtsswgd=1.000e-08         njtsswg=40.31             xtsswgs=0.4558
+ xtsswgd=0.4558            tnjtsswg=1                dmcg=1.255e-007
+ dmci=1.255e-007           dmdg=0                    dmcgt=0
+ dwj=0                     xgw=0                     xgl=0
+ rshg=1                    gbmin=1e-012              rbpb=50
+ rbpd=50                   rbps=50                   rbdb=50
+ rbsb=50                   ngcon=1                   saref=0.82e-6
+ sbref=0.82e-6             kvsat=0.40                wlod=0.15e-6
+ tku0=0.1                  ku0=-7.0e-8               llodku0=1
+ wlodku0=1                 lku0=2.0e-7               wku0=0.2e-6
+ pku0=0.5e-13              kvth0=4e-9                stk2=0
+ steta0=0                  lkvth0=-4.68e-11          wkvth0=7e-7
+ pkvth0=0                  llodvth=1                 wlodvth=1
+ lodk2=1                   lodeta0=1                 fnoimod=1
+ noia=5.3e+41              noib=1.0e+20              noic=1.0e+7
+ em=1.00e+07               ef=0.92                   tnoimod=0
+ ud=0                      wpemod=wpeflag_18         kvth0we=4.5e-3
+ lkvth0we=0.0e-11          wkvth0we=0                pkvth0we=0
+ ku0we=-2e-4               lku0we=0                  wku0we=0
+ pku0we=0                  k2we=0.0                  wk2we=0
+ web=0                     wec=0                     scref=1e-6
+ wvth0=0+dwvthn_18         lnfactor=0+dlnfactorn_18  minr=1e-3

     6: type=n
+ lmin=1e-005-dxln_18       lmax=0.0009001            wmin=1e-006-dxwn_18
+ wmax=1e-005-dxwn_18       version=4.5               binunit=2
+ paramchk=1                mobmod=0                  capmod=2
+ igcmod=0                  igbmod=0                  geomod=0
+ diomod=1                  rdsmod=0                  rbodymod=0
+ rgatemod=0                permod=1                  acnqsmod=0
+ trnqsmod=0                tempmod=0                 tnom=25
+ toxe=toxn_18              toxm=toxn_18              dtox=2.15e-010
+ epsrox=3.9                wint=1e-008               lint=6.25e-009
+ ll=0                      wl=0                      lln=1
+ wln=1                     lw=0                      ww=0
+ lwn=1                     wwn=1                     lwl=0
+ wwl=0                     llc=0                     wlc=0
+ lwc=0                     wwc=0                     lwlc=0
+ wwlc=0                    xl=-5.5e-08+dxln_18       xw=0+dxwn_18
+ dlc=dlcn_18               dwc=0                     xpart=1
+ toxref=3e-009             dlcig=6.25e-009           vth0=0.352+dvthn_18
+ k1=0.5288                 k2=0.0011366667+dk2n_18   wk2=1.6300667e-009
+ k3=-0.85                  k3b=0.9                   w0=0
+ dvt0=0                    dvt1=0                    dvt2=0
+ dvt0w=0                   dvt1w=0                   dvt2w=0
+ dsub=0.32                 minv=-0.3                 voffl=0
+ dvtp0=1.4e-006            dvtp1=0.06                lpe0=3.2e-008
+ lpeb=0                    xj=1.5e-007               ngate=4e+020
+ ndep=4.2e+017             nsd=1e+020                phin=0
+ cdsc=0                    cdscb=0                   cdscd=0
+ cit=-4.3555555e-005       wcit=4.3468444e-010       voff=-0.12079222
+ wvoff=-7.0636222e-009     nfactor=1.4               eta0=0.033871111
+ weta0=-8.6936889e-009     etab=-0.058871111         wetab=8.6936889e-009
+ u0=0.052956574            wu0=-1.1227443e-008       ua=2.5363161e-010
+ wua=-5.712862e-017        ub=2.4634156e-018         wub=-6.2871563e-025
+ uc=2.5596889e-010         wuc=-6.9549511e-017       vsat=96500.88
+ a0=1.1491988              wa0=2.8451184e-007        ags=0.5753592
+ wags=-4.9597495e-010      a1=0                      a2=0.8
+ b0=0                      b1=0                      keta=-0.060762222
+ wketa=7.6069778e-009      dwg=0                     dwb=0
+ pclm=0.2                  pdiblc1=0                 pdiblc2=0.00097504444
+ wpdiblc2=-2.4994356e-010  pdiblcb=0                 drout=0.56
+ pvag=0.8                  delta=0.012               pscbe1=7.506e+008
+ pscbe2=1e-020             fprout=0                  pdits=0
+ pditsd=0                  pditsl=0                  rsh=10.5
+ rdsw=150+drdswn_18        prwg=0                    prwb=0
+ wr=1                      alpha0=0                  alpha1=2.2950
+ beta0=17.8                agidl=2.56e-012           bgidl=8.66e+008
+ cgidl=0.25                egidl=0.2624              aigbacc=0.01213
+ bigbacc=0.006537          cigbacc=0.2809            nigbacc=4.05
+ aigbinv=0.35              bigbinv=0.03              cigbinv=0.006
+ eigbinv=1.1               nigbinv=1                 aigc=0.01
+ bigc=0.00144              cigc=1.515e-005           aigsd=0.008379
+ bigsd=0.0002699           cigsd=3.925e-020          nigc=1
+ poxedge=1                 pigcd=2.171               ntox=1
+ xrcrg1=12                 xrcrg2=1                  cgso=cgon_18
+ cgdo=cgon_18              cgbo=0                    cgdl=cgln_18
+ cgsl=cgln_18              clc=1e-007                cle=0.6
+ cf=cfn_18                 ckappas=0.6               ckappad=0.6
+ acde=0.4                  moin=5                    noff=1.695
+ voffcv=-0.07              kt1=-0.26108889           wkt1=1.0867111e-008
+ kt1l=0                    kt2=-0.02                 ute=-1.6566778
+ wute=2.6624422e-007       ua1=2.6636264e-009        wua1=3.6967521e-016
+ ub1=-3.6121415e-018       wub1=-1.7822823e-025      uc1=-1.7217778e-010
+ wuc1=2.1734222e-017       prt=0                     at=220000
+ jss=2.85e-07              jsd=2.85e-07              jsws=6.9e-13
+ jswd=6.9e-13              jswgs=6.9e-13             jswgd=6.9e-13
+ njs=1                     njd=1                     ijthsfwd=0.01
+ ijthdfwd=0.01             ijthsrev=0.01             ijthdrev=0.01
+ bvs=10                    bvd=10                    xjbvs=1
+ xjbvd=1                   pbs=0.613                 pbd=0.613
+ cjs=cjn_18                cjd=cjn_18                mjs=0.279
+ mjd=0.279                 pbsws=0.613               pbswd=0.613
+ cjsws=cjswn_18            cjswd=cjswn_18            mjsws=0.01
+ mjswd=0.01                pbswgs=0.952              pbswgd=0.952
+ cjswgs=cjswgn_18          cjswgd=cjswgn_18          mjswgs=0.541
+ mjswgd=0.541              tpb=0.00133               tcj=0.000766
+ tpbsw=0.00133             tcjsw=0.0001              tpbswg=0.00133
+ tcjswg=0.00088            xtis=3                    xtid=3
+ jtsswgs=1.000e-08         jtsswgd=1.000e-08         njtsswg=40.31
+ xtsswgs=0.4558            xtsswgd=0.4558            tnjtsswg=1
+ dmcg=1.255e-007           dmci=1.255e-007           dmdg=0
+ dmcgt=0                   dwj=0                     xgw=0
+ xgl=0                     rshg=1                    gbmin=1e-012
+ rbpb=50                   rbpd=50                   rbps=50
+ rbdb=50                   rbsb=50                   ngcon=1
+ lvth0=0+dlvthn_18         wvth0=0+dwvthn_18         saref=0.82e-6
+ sbref=0.82e-6             kvsat=0.40                wlod=0.15e-6
+ tku0=0.1                  ku0=-7.0e-8               llodku0=1
+ wlodku0=1                 lku0=2.0e-7               wku0=0.2e-6
+ pku0=0.5e-13              kvth0=4e-9                stk2=0
+ steta0=0                  lkvth0=-4.68e-11          wkvth0=7e-7
+ pkvth0=0                  llodvth=1                 wlodvth=1
+ lodk2=1                   lodeta0=1                 fnoimod=1
+ noia=5.3e+41              noib=1.0e+20              noic=1.0e+7
+ em=1.00e+07               ef=0.92                   tnoimod=0
+ ud=0                      wpemod=wpeflag_18         kvth0we=4.5e-3
+ lkvth0we=0.0e-11          wkvth0we=0                pkvth0we=0
+ ku0we=-2e-4               lku0we=0                  wku0we=0
+ pku0we=0                  k2we=0.0                  wk2we=0
+ web=0                     wec=0                     scref=1e-6
+ lvsat=0+dlvsatn_18        lpclm=0+dlpclmn_18        lnfactor=0+dlnfactorn_18
+ minr=1e-3

     7: type=n
+ lmin=1.2e-006-dxln_18     lmax=1e-005-dxln_18       wmin=1e-006-dxwn_18
+ wmax=1e-005-dxwn_18       version=4.5               binunit=2
+ paramchk=1                mobmod=0                  capmod=2
+ igcmod=0                  igbmod=0                  geomod=0
+ diomod=1                  rdsmod=0                  rbodymod=0
+ rgatemod=0                permod=1                  acnqsmod=0
+ trnqsmod=0                tempmod=0                 tnom=25
+ toxe=toxn_18              toxm=toxn_18              dtox=2.15e-010
+ epsrox=3.9                wint=1e-008               lint=6.25e-009
+ ll=0                      wl=0                      lln=1
+ wln=1                     lw=0                      ww=0
+ lwn=1                     wwn=1                     lwl=0
+ wwl=0                     llc=0                     wlc=0
+ lwc=0                     wwc=0                     lwlc=0
+ wwlc=0                    xl=-5.5e-08+dxln_18       xw=0+dxwn_18
+ dlc=dlcn_18               dwc=0                     xpart=1
+ toxref=3e-009             dlcig=6.25e-009           vth0=0.35222936+dvthn_18
+ lvth0=-2.2781167e-009+dlvthn_18                     wvth0=2.7970462e-010+dwvthn_18
+ pvth0=-2.7781662e-015     k1=0.5288                 k2=0.0015681034+dk2n_18
+ lk2=-4.2852454e-009       wk2=1.4342734e-009        pk2=1.9447163e-015
+ k3=-0.85                  k3b=0.9                   w0=0
+ dvt0=0                    dvt1=0                    dvt2=0
+ dvt0w=0                   dvt1w=0                   dvt2w=0
+ dsub=0.32                 minv=-0.3                 voffl=0
+ dvtp0=1.4e-006            dvtp1=0.06                lpe0=3.2e-008
+ lpeb=0                    xj=1.5e-007               ngate=4e+020
+ ndep=4.2e+017             nsd=1e+020                phin=0
+ cdsc=0                    cdscb=0                   cdscd=0
+ cit=-3.9351578e-005       lcit=-4.1756004e-011      wcit=3.9272875e-010
+ pcit=4.1672492e-016       voff=-0.12005066          lvoff=-7.3655319e-009
+ wvoff=-8.0425884e-009     pvoff=9.7235815e-015      nfactor=1.4
+ eta0=0.033871111          weta0=-8.6936889e-009     etab=-0.058871111
+ wetab=8.6936889e-009      u0=0.052956574            wu0=-1.1227443e-008
+ ua=2.70128e-010           lua=-1.6385035e-016       wua=-5.6302179e-017
+ pua=-8.2086336e-024       ub=2.4599954e-018         lub=3.3970955e-026
+ wub=-6.3210858e-025       pub=3.3700544e-032        uc=2.5582618e-010
+ luc=1.4174317e-018        wuc=-6.9409659e-017       puc=-1.3890831e-024
+ vsat=96500.88             a0=1.1886553              la0=-3.9190218e-007
+ wa0=3.3040113e-007        pa0=-4.5579538e-013       ags=0.5597999
+ lags=1.5454272e-007       wags=-7.9372087e-009      pags=7.3910054e-014
+ a1=0                      a2=0.8                    b0=0
+ b1=0                      keta=-0.05914269          lketa=-1.6086004e-008
+ wketa=9.4250578e-009      pketa=-1.805808e-014      dwg=0
+ dwb=0                     pclm=0.18525748           lpclm=1.4643007e-007+dlpclmn_18
+ wpclm=-6.9926155e-009     ppclm=6.9454154e-014      pdiblc1=0
+ pdiblc2=0.00074107166     lpdiblc2=2.3239347e-009   wpdiblc2=-5.4782898e-010
+ ppdiblc2=2.9587469e-015   pdiblcb=0                 drout=0.56
+ pvag=0.8                  delta=0.012               pscbe1=7.506e+008
+ pscbe2=1e-020             fprout=0                  pdits=0
+ pditsd=0                  pditsl=0                  rsh=10.5
+ rdsw=150+drdswn_18        prwg=0                    prwb=0
+ wr=1                      alpha0=0                  alpha1=2.2950
+ beta0=17.8                agidl=2.56e-012           bgidl=8.66e+008
+ cgidl=0.25                egidl=0.2624              aigbacc=0.01213
+ bigbacc=0.006537          cigbacc=0.2809            nigbacc=4.05
+ aigbinv=0.35              bigbinv=0.03              cigbinv=0.006
+ eigbinv=1.1               nigbinv=1                 aigc=0.01
+ bigc=0.00144              cigc=1.515e-005           aigsd=0.008379
+ bigsd=0.0002699           cigsd=3.925e-020          nigc=1
+ poxedge=1                 pigcd=2.171               ntox=1
+ xrcrg1=12                 xrcrg2=1                  cgso=cgon_18
+ cgdo=cgon_18              cgbo=0                    cgdl=cgln_18
+ cgsl=cgln_18              clc=1e-007                cle=0.6
+ cf=cfn_18                 ckappas=0.6               ckappad=0.6
+ acde=0.4                  moin=5                    noff=1.695
+ voffcv=-0.07              kt1=-0.26122902           lkt1=1.3918668e-009
+ wkt1=1.2265634e-008       pkt1=-1.3890831e-014      kt1l=0
+ kt2=-0.02                 ute=-1.671981             lute=1.5199949e-007
+ wute=2.5160336e-007       pute=1.4542033e-013       ua1=2.6594291e-009
+ lua1=4.1690061e-017       wua1=3.4161594e-016       pua1=2.7869868e-022
+ ub1=-3.5793585e-018       lub1=-3.2561683e-025      wub1=-1.9995624e-025
+ pub1=2.158135e-031        uc1=-1.7573257e-010       luc1=3.5307968e-017
+ wuc1=3.1523884e-017       puc1=-9.7235815e-023      prt=0
+ at=234743.66              lat=-0.14644143           wat=0.00055940924
+ pat=-5.5563323e-009       jss=2.85e-07              jsd=2.85e-07
+ jsws=6.9e-13              jswd=6.9e-13              jswgs=6.9e-13
+ jswgd=6.9e-13             njs=1                     njd=1
+ ijthsfwd=0.01             ijthdfwd=0.01             ijthsrev=0.01
+ ijthdrev=0.01             bvs=10                    bvd=10
+ xjbvs=1                   xjbvd=1                   pbs=0.613
+ pbd=0.613                 cjs=cjn_18                cjd=cjn_18
+ mjs=0.279                 mjd=0.279                 pbsws=0.613
+ pbswd=0.613               cjsws=cjswn_18            cjswd=cjswn_18
+ mjsws=0.01                mjswd=0.01                pbswgs=0.952
+ pbswgd=0.952              cjswgs=cjswgn_18          cjswgd=cjswgn_18
+ mjswgs=0.541              mjswgd=0.541              tpb=0.00133
+ tcj=0.000766              tpbsw=0.00133             tcjsw=0.0001
+ tpbswg=0.00133            tcjswg=0.00088            xtis=3
+ xtid=3                    jtsswgs=1.000e-08         jtsswgd=1.000e-08
+ njtsswg=40.31             xtsswgs=0.4558            xtsswgd=0.4558
+ tnjtsswg=1                dmcg=1.255e-007           dmci=1.255e-007
+ dmdg=0                    dmcgt=0                   dwj=0
+ xgw=0                     xgl=0                     rshg=1
+ gbmin=1e-012              rbpb=50                   rbpd=50
+ rbps=50                   rbdb=50                   rbsb=50
+ saref=0.82e-6             sbref=0.82e-6             kvsat=0.40
+ wlod=0.15e-6              tku0=0.1                  ku0=-7.0e-8
+ llodku0=1                 wlodku0=1                 lku0=2.0e-7
+ wku0=0.2e-6               pku0=0.5e-13              kvth0=4e-9
+ stk2=0                    steta0=0                  lkvth0=-4.68e-11
+ wkvth0=7e-7               pkvth0=0                  llodvth=1
+ wlodvth=1                 lodk2=1                   lodeta0=1
+ fnoimod=1                 noia=5.3e+41              noib=1.0e+20
+ noic=1.0e+7               em=1.00e+07               ef=0.92
+ tnoimod=0                 ud=0                      wpemod=wpeflag_18
+ kvth0we=4.5e-3            lkvth0we=0.0e-11          wkvth0we=0
+ pkvth0we=0                ku0we=-2e-4               lku0we=0
+ wku0we=0                  pku0we=0                  k2we=0.0
+ wk2we=0                   web=0                     wec=0
+ scref=1e-6                ngcon=1                   lvsat=0+dlvsatn_18
+ lnfactor=0+dlnfactorn_18  minr=1e-3

     8: type=n
+ lmin=7e-007-dxln_18       lmax=1.2e-006-dxln_18     wmin=1e-006-dxwn_18
+ wmax=1e-005-dxwn_18       version=4.5               binunit=2
+ paramchk=1                mobmod=0                  capmod=2
+ igcmod=0                  igbmod=0                  geomod=0
+ diomod=1                  rdsmod=0                  rbodymod=0
+ rgatemod=0                permod=1                  acnqsmod=0
+ trnqsmod=0                tempmod=0                 tnom=25
+ toxe=toxn_18              toxm=toxn_18              dtox=2.15e-010
+ epsrox=3.9                wint=1e-008               lint=6.25e-009
+ ll=0                      wl=0                      lln=1
+ wln=1                     lw=0                      ww=0
+ lwn=1                     wwn=1                     lwl=0
+ wwl=0                     llc=0                     wlc=0
+ lwc=0                     wwc=0                     lwlc=0
+ wwlc=0                    xl=-5.5e-08+dxln_18       xw=0+dxwn_18
+ dlc=dlcn_18               dwc=0                     xpart=1
+ toxref=3e-009             dlcig=6.25e-009           vth0=0.35021778+dvthn_18
+ wvth0=-2.1734222e-009+dwvthn_18                     k1=0.5288
+ k2=0.0080444967+dk2n_18   lk2=-1.1619761e-008       wk2=3.0139933e-009
+ pk2=1.5568359e-016        k3=-0.85                  k3b=0.9
+ w0=0                      dvt0=0                    dvt1=0
+ dvt2=0                    dvt0w=0                   dvt1w=0
+ dvt2w=0                   dsub=0.32                 minv=-0.3
+ voffl=0                   dvtp0=1.4e-006            dvtp1=0.06
+ lpe0=3.2e-008             lpeb=0                    xj=1.5e-007
+ ngate=4e+020              ndep=4.2e+017             nsd=1e+020
+ phin=0                    cdsc=0                    cdscb=0
+ cdscd=0                   cit=-0.00060977111        lcit=6.0424412e-010
+ wcit=1.0356357e-009       pcit=-3.1136718e-016      voff=-0.1238867
+ lvoff=-3.0212206e-009     wvoff=-8.31334e-010       pvoff=1.5568359e-015
+ nfactor=1.4               eta0=0.033871111          weta0=-8.6936889e-009
+ etab=-0.058871111         wetab=8.6936889e-009      u0=0.052956574
+ wu0=-1.1227443e-008       ua=2.4116346e-010         lua=-1.3104801e-016
+ wua=-2.8484757e-017       pua=-3.9711864e-023       ub=2.4700999e-018
+ lub=2.2527628e-026        wub=-5.9779521e-025       pub=-5.1593542e-033
+ uc=2.7184454e-010         luc=-1.6723363e-017       wuc=-6.6512154e-017
+ puc=-4.6705078e-024       vsat=96500.712            lvsat=1.9063297e-007+dlvsatn_18
+ wvsat=1.6496275e-007      pvsat=-1.8682031e-013     a0=1.089373
+ la0=-2.7946496e-007       wa0=-1.5167548e-007       pa0=9.0156368e-014
+ ags=0.76705177            lags=-8.0170027e-008      wags=-1.7437963e-007
+ pags=2.624061e-013        a1=0                      a2=0.8
+ b0=0                      b1=0                      keta=-0.089706926
+ lketa=1.8527994e-008      wketa=-7.3659757e-009     pketa=9.5776546e-016
+ dwg=0                     dwb=0                     pclm=0.31042322
+ lpclm=4.6798675e-009+dlpclmn_18                     wpclm=9.5576242e-008
+ ppclm=-4.6705078e-014     pdiblc1=0                 pdiblc2=-0.00173081
+ lpdiblc2=5.1233407e-009   wpdiblc2=3.0270338e-009   ppdiblc2=-1.0897851e-015
+ pdiblcb=0                 drout=0.56                pvag=0.8
+ delta=0.012               pscbe1=7.506e+008         pscbe2=1e-020
+ fprout=0                  pdits=0                   pditsd=0
+ pditsl=0                  rsh=10.5                  rdsw=150+drdswn_18
+ prwg=0                    prwb=0                    wr=1
+ alpha0=0                  alpha1=2.2950             beta0=17.8
+ agidl=2.56e-012           bgidl=8.66e+008           cgidl=0.25
+ egidl=0.2624              aigbacc=0.01213           bigbacc=0.006537
+ cigbacc=0.2809            nigbacc=4.05              aigbinv=0.35
+ bigbinv=0.03              cigbinv=0.006             eigbinv=1.1
+ nigbinv=1                 aigc=0.01                 bigc=0.00144
+ cigc=1.515e-005           aigsd=0.008379            bigsd=0.0002699
+ cigsd=3.925e-020          nigc=1                    poxedge=1
+ pigcd=2.171               ntox=1                    xrcrg1=12
+ xrcrg2=1                  cgso=cgon_18              cgdo=cgon_18
+ cgbo=0                    cgdl=cgln_18              cgsl=cgln_18
+ clc=1e-007                cle=0.6                   cf=cfn_18
+ ckappas=0.6               ckappad=0.6               acde=0.4
+ moin=5                    noff=1.695                voffcv=-0.07
+ kt1=-0.22242599           lkt1=-4.2552571e-008      wkt1=-1.2028534e-008
+ pkt1=1.3622314e-014       kt1l=0                    kt2=-0.02
+ ute=-2.2431517            lute=7.9885024e-007       wute=1.1580676e-006
+ pute=-8.8115045e-013      ua1=1.1568323e-009        lua1=1.7433809e-015
+ wua1=2.5250217e-015       pua1=-2.1940084e-021      ub1=-4.3074702e-018
+ lub1=4.9896963e-025       wub1=1.0137042e-025       pub1=-1.2543894e-031
+ uc1=-1.4180067e-010       luc1=-3.1199117e-018      wuc1=-8.1829347e-017
+ puc1=3.1136718e-023       prt=0                     at=161534.09
+ lat=-0.063531589          wat=0.0039012929          pat=-9.3410155e-009
+ jss=2.85e-07              jsd=2.85e-07              jsws=6.9e-13
+ jswd=6.9e-13              jswgs=6.9e-13             jswgd=6.9e-13
+ njs=1                     njd=1                     ijthsfwd=0.01
+ ijthdfwd=0.01             ijthsrev=0.01             ijthdrev=0.01
+ bvs=10                    bvd=10                    xjbvs=1
+ xjbvd=1                   pbs=0.613                 pbd=0.613
+ cjs=cjn_18                cjd=cjn_18                mjs=0.279
+ mjd=0.279                 pbsws=0.613               pbswd=0.613
+ cjsws=cjswn_18            cjswd=cjswn_18            mjsws=0.01
+ mjswd=0.01                pbswgs=0.952              pbswgd=0.952
+ cjswgs=cjswgn_18          cjswgd=cjswgn_18          mjswgs=0.541
+ mjswgd=0.541              tpb=0.00133               tcj=0.000766
+ tpbsw=0.00133             tcjsw=0.0001              tpbswg=0.00133
+ tcjswg=0.00088            xtis=3                    xtid=3
+ jtsswgs=1.000e-08         jtsswgd=1.000e-08         njtsswg=40.31
+ xtsswgs=0.4558            xtsswgd=0.4558            tnjtsswg=1
+ dmcg=1.255e-007           dmci=1.255e-007           dmdg=0
+ dmcgt=0                   dwj=0                     xgw=0
+ xgl=0                     rshg=1                    gbmin=1e-012
+ rbpb=50                   rbpd=50                   rbps=50
+ rbdb=50                   rbsb=50                   saref=0.82e-6
+ sbref=0.82e-6             kvsat=0.40                wlod=0.15e-6
+ tku0=0.1                  ku0=-7.0e-8               llodku0=1
+ wlodku0=1                 lku0=2.0e-7               wku0=0.2e-6
+ pku0=0.5e-13              kvth0=4e-9                stk2=0
+ steta0=0                  lkvth0=-4.68e-11          wkvth0=7e-7
+ pkvth0=0                  llodvth=1                 wlodvth=1
+ lodk2=1                   lodeta0=1                 fnoimod=1
+ noia=5.3e+41              noib=1.0e+20              noic=1.0e+7
+ em=1.00e+07               ef=0.92                   tnoimod=0
+ ud=0                      wpemod=wpeflag_18         kvth0we=4.5e-3
+ lkvth0we=0.0e-11          wkvth0we=0                pkvth0we=0
+ ku0we=-2e-4               lku0we=0                  wku0we=0
+ pku0we=0                  k2we=0.0                  wk2we=0
+ web=0                     wec=0                     scref=1e-6
+ ngcon=1                   lvth0=0+dlvthn_18         lnfactor=0+dlnfactorn_18
+ minr=1e-3

     9: type=n
+ lmin=4e-007-dxln_18       lmax=7e-007-dxln_18       wmin=1e-006-dxwn_18
+ wmax=1e-005-dxwn_18       version=4.5               binunit=2
+ paramchk=1                mobmod=0                  capmod=2
+ igcmod=0                  igbmod=0                  geomod=0
+ diomod=1                  rdsmod=0                  rbodymod=0
+ rgatemod=0                permod=1                  acnqsmod=0
+ trnqsmod=0                tempmod=0                 tnom=25
+ toxe=toxn_18              toxm=toxn_18              dtox=2.15e-010
+ epsrox=3.9                wint=1e-008               lint=6.25e-009
+ ll=0                      wl=0                      lln=1
+ wln=1                     lw=0                      ww=0
+ lwn=1                     wwn=1                     lwl=0
+ wwl=0                     llc=0                     wlc=0
+ lwc=0                     wwc=0                     lwlc=0
+ wwlc=0                    xl=-5.5e-08+dxln_18       xw=0+dxwn_18
+ dlc=dlcn_18               dwc=0                     xpart=1
+ toxref=3e-009             dlcig=6.25e-009           vth0=0.35797611+dvthn_18
+ lvth0=-4.9071458e-009+dlvthn_18                     wvth0=-2.1734222e-009+dwvthn_18
+ pvth0=-1.7718746e-028     k1=0.5288                 k2=0.0039609815+dk2n_18
+ lk2=-9.0369375e-009       wk2=4.4645715e-009        pk2=-7.6180713e-016
+ k3=-0.85                  k3b=0.9                   w0=0
+ dvt0=0                    dvt1=0                    dvt2=0
+ dvt0w=0                   dvt1w=0                   dvt2w=0
+ dsub=0.32                 minv=-0.3                 voffl=0
+ dvtp0=1.4e-006            dvtp1=0.06                lpe0=3.2e-008
+ lpeb=0                    xj=1.5e-007               ngate=4e+020
+ ndep=4.2e+017             nsd=1e+020                phin=0
+ cdsc=0                    cdscb=0                   cdscd=0
+ cit=0.00039382963         lcit=-3.0533352e-011      wcit=6.1580296e-011
+ pcit=3.0472285e-016       voff=-0.134205            lvoff=3.5051042e-009
+ wvoff=1.6300667e-009      pvoff=5.6377829e-029      nfactor=1.4
+ eta0=0.033871111          weta0=-8.6936889e-009     etab=-0.058871111
+ wetab=8.6936889e-009      u0=0.052956574            wu0=-1.1227443e-008
+ ua=-2.8864737e-011        lua=3.9744826e-017        wua=-1.9115542e-017
+ pua=-4.5637892e-023       ub=2.8598592e-018         lub=-2.2399514e-025
+ wub=-7.6663879e-025       pub=1.0163421e-031        uc=2.5221946e-010
+ luc=-4.3104992e-018       wuc=-5.3420907e-017       puc=-1.2950721e-023
+ vsat=96501.028            lvsat=-9.1600055e-009+dlvsatn_18
+ wvsat=-2.7493791e-007     pvsat=9.1416855e-014      a0=0.72443876
+ la0=-4.8644028e-008       wa0=1.9810432e-007        pa0=-1.3107935e-013
+ ags=1.3036845             lags=-4.1959021e-007      wags=-1.3717653e-007
+ pags=2.3887514e-013       a1=0                      a2=0.8
+ b0=0                      b1=0                      keta=-0.088580456
+ lketa=1.7815502e-008      wketa=-1.2337381e-008     pketa=4.102179e-015
+ dwg=0                     dwb=0                     pclm=0.23782519
+ lpclm=5.0598126e-008+dlpclmn_18                     wpclm=4.5822985e-008
+ ppclm=-1.5236143e-014     pdiblc1=0                 pdiblc2=0.0046157037
+ lpdiblc2=1.1091707e-009   wpdiblc2=-1.104823e-009   ppdiblc2=1.5236143e-015
+ pdiblcb=0.44333333        lpdiblcb=-2.8040833e-007  drout=0.56
+ pvag=0.8                  delta=0.012               pscbe1=7.506e+008
+ pscbe2=1e-020             fprout=0                  pdits=0
+ pditsd=0                  pditsl=0                  rsh=10.5
+ rdsw=150+drdswn_18        prwg=0                    prwb=0
+ wr=1                      alpha0=0                  alpha1=2.2950
+ beta0=17.8                agidl=2.56e-012           bgidl=8.66e+008
+ cgidl=0.25                egidl=0.2624              aigbacc=0.01213
+ bigbacc=0.006537          cigbacc=0.2809            nigbacc=4.05
+ aigbinv=0.35              bigbinv=0.03              cigbinv=0.006
+ eigbinv=1.1               nigbinv=1                 aigc=0.01
+ bigc=0.00144              cigc=1.515e-005           aigsd=0.008379
+ bigsd=0.0002699           cigsd=3.925e-020          nigc=1
+ poxedge=1                 pigcd=2.171               ntox=1
+ xrcrg1=12                 xrcrg2=1                  cgso=cgon_18
+ cgdo=cgon_18              cgbo=0                    cgdl=cgln_18
+ cgsl=cgln_18              clc=1e-007                cle=0.6
+ cf=cfn_18                 ckappas=0.6               ckappad=0.6
+ acde=0.4                  moin=5                    noff=1.695
+ voffcv=-0.07              kt1=-0.27688576           lkt1=-8.1067607e-009
+ wkt1=2.9261508e-008       pkt1=-1.2493637e-014      kt1l=0
+ kt2=-0.02                 ute=-0.55894224           lute=-2.6641222e-007
+ wute=-8.8472955e-007      pute=4.1091877e-013       ua1=4.9261275e-009
+ lua1=-6.4069829e-016      wua1=-2.8833464e-015      pua1=1.2267845e-021
+ ub1=-3.1038382e-018       lub1=-2.6232758e-025      wub1=2.6844952e-026
+ pub1=-7.8301584e-032      uc1=-1.4311278e-010       luc1=-2.2900014e-018
+ wuc1=-6.8734478e-017      puc1=2.2854214e-023       prt=0
+ at=100483.98              lat=-0.024917396          wat=-0.016889302
+ pat=3.8090356e-009        jss=2.85e-07              jsd=2.85e-07
+ jsws=6.9e-13              jswd=6.9e-13              jswgs=6.9e-13
+ jswgd=6.9e-13             njs=1                     njd=1
+ ijthsfwd=0.01             ijthdfwd=0.01             ijthsrev=0.01
+ ijthdrev=0.01             bvs=10                    bvd=10
+ xjbvs=1                   xjbvd=1                   pbs=0.613
+ pbd=0.613                 cjs=cjn_18                cjd=cjn_18
+ mjs=0.279                 mjd=0.279                 pbsws=0.613
+ pbswd=0.613               cjsws=cjswn_18            cjswd=cjswn_18
+ mjsws=0.01                mjswd=0.01                pbswgs=0.952
+ pbswgd=0.952              cjswgs=cjswgn_18          cjswgd=cjswgn_18
+ mjswgs=0.541              mjswgd=0.541              tpb=0.00133
+ tcj=0.000766              tpbsw=0.00133             tcjsw=0.0001
+ tpbswg=0.00133            tcjswg=0.00088            xtis=3
+ xtid=3                    jtsswgs=1.000e-08         jtsswgd=1.000e-08
+ njtsswg=40.31             xtsswgs=0.4558            xtsswgd=0.4558
+ tnjtsswg=1                dmcg=1.255e-007           dmci=1.255e-007
+ dmdg=0                    dmcgt=0                   dwj=0
+ xgw=0                     xgl=0                     rshg=1
+ gbmin=1e-012              rbpb=50                   rbpd=50
+ rbps=50                   rbdb=50                   saref=0.82e-6
+ sbref=0.82e-6             kvsat=0.40                wlod=0.15e-6
+ tku0=0.1                  ku0=-7.0e-8               llodku0=1
+ wlodku0=1                 lku0=2.0e-7               wku0=0.2e-6
+ pku0=0.5e-13              kvth0=4e-9                stk2=0
+ steta0=0                  lkvth0=-4.68e-11          wkvth0=7e-7
+ pkvth0=0                  llodvth=1                 wlodvth=1
+ lodk2=1                   lodeta0=1                 fnoimod=1
+ noia=5.3e+41              noib=1.0e+20              noic=1.0e+7
+ em=1.00e+07               ef=0.92                   tnoimod=0
+ ud=0                      wpemod=wpeflag_18         kvth0we=4.5e-3
+ lkvth0we=0.0e-11          wkvth0we=0                pkvth0we=0
+ ku0we=-2e-4               lku0we=0                  wku0we=0
+ pku0we=0                  k2we=0.0                  wk2we=0
+ web=0                     wec=0                     scref=1e-6
+ rbsb=50                   ngcon=1                   lnfactor=0+dlnfactorn_18
+ minr=1e-3

     10: type=n
+ lmin=2e-07                lmax=4e-007-dxln_18       wmin=1e-006-dxwn_18
+ wmax=1e-005-dxwn_18       version=4.5               binunit=2
+ paramchk=1                mobmod=0                  capmod=2
+ igcmod=0                  igbmod=0                  geomod=0
+ diomod=1                  rdsmod=0                  rbodymod=0
+ rgatemod=0                permod=1                  acnqsmod=0
+ trnqsmod=0                tempmod=0                 tnom=25
+ toxe=toxn_18              toxm=toxn_18              dtox=2.15e-010
+ epsrox=3.9                wint=1e-008               lint=6.25e-009
+ ll=0                      wl=0                      lln=1
+ wln=1                     lw=0                      ww=0
+ lwn=1                     wwn=1                     lwl=0
+ wwl=0                     llc=0                     wlc=0
+ lwc=0                     wwc=0                     lwlc=0
+ wwlc=0                    xl=-5.5e-08+dxln_18       xw=0+dxwn_18
+ dlc=dlcn_18               dwc=0                     xpart=1
+ toxref=3e-009             dlcig=6.25e-009           vth0=0.35079383+dvthn_18
+ lvth0=-2.5190385e-009+dlvthn_18                     wvth0=-5.0532067e-009+dwvthn_18
+ pvth0=9.5752833e-016      k1=0.5288                 k2=-0.0063174028+dk2n_18
+ lk2=-5.6193747e-009       wk2=5.4131797e-009        pk2=-1.0772194e-015
+ k3=-0.85                  k3b=0.9                   w0=0
+ dvt0=0                    dvt1=0                    dvt2=0
+ dvt0w=0                   dvt1w=0                   dvt2w=0
+ dsub=0.32                 minv=-0.3                 voffl=0
+ dvtp0=1.4e-006            dvtp1=0.06                lpe0=3.2e-008
+ lpeb=0                    xj=1.5e-007               ngate=4e+020
+ ndep=4.2e+017             nsd=1e+020                phin=0
+ cdsc=0                    cdscb=0                   cdscd=0
+ cit=5.0733889e-006        lcit=9.8728098e-011       wcit=1.2041031e-009
+ pcit=-7.5165974e-017      voff=-0.11129888          lvoff=-4.1111824e-009
+ wvoff=5.501475e-010       pvoff=3.5907312e-016      nfactor=1.4
+ eta0=0.033871111          weta0=-8.6936889e-009     etab=-0.058871111
+ wetab=8.6936889e-009      u0=0.057853972            lu0=-1.6283848e-009
+ wu0=-1.2131393e-008       pu0=3.0056335e-016        ua=5.2799418e-010
+ lua=-1.4541077e-016       wua=-3.6903354e-016       pua=7.0709843e-023
+ ub=1.75223e-018           lub=1.4429156e-025        wub=2.1245039e-026
+ pub=-1.6033716e-031       uc=1.9044844e-010         luc=1.6228364e-017
+ wuc=-2.1815726e-017       puc=-2.3459444e-023       vsat=97015.982
+ lvsat=-0.00017123147+dlvsatn_18                     wvsat=-0.00050468222
+ pvsat=1.6780684e-010      a0=0.90417529             la0=-1.0840643e-007
+ wa0=-4.1852296e-007       pa0=7.3949219e-014        ags=-0.15580148
+ lags=6.5688867e-008       wags=1.122116e-006        pags=-1.7983964e-013
+ a1=0                      a2=0.8                    b0=0
+ b1=0                      keta=-0.043737639         lketa=2.9052649e-009
+ wketa=-2.5198114e-008     pketa=8.3783729e-015      dwg=0
+ dwb=0                     pclm=0.264125             lpclm=4.1853437e-008+dlpclmn_18
+ pdiblc1=0                 pdiblc2=0.0060954116      lpdiblc2=6.1716785e-010
+ wpdiblc2=3.9979966e-009   ppdiblc2=-1.7307325e-016  pdiblcb=-0.665
+ lpdiblcb=8.81125e-008     drout=0.56                pvag=0.8
+ delta=0.012               pscbe1=7.506e+008         pscbe2=1e-020
+ fprout=0                  pdits=0                   pditsd=0
+ pditsl=0                  rsh=10.5                  rdsw=150+drdswn_18
+ prwg=0                    prwb=0                    wr=1
+ alpha0=0                  alpha1=2.2950             beta0=17.8
+ agidl=2.56e-012           bgidl=8.66e+008           cgidl=0.25
+ egidl=0.2624              aigbacc=0.01213           bigbacc=0.006537
+ cigbacc=0.2809            nigbacc=4.05              aigbinv=0.35
+ bigbinv=0.03              cigbinv=0.006             eigbinv=1.1
+ nigbinv=1                 aigc=0.01                 bigc=0.00144
+ cigc=1.515e-005           aigsd=0.008379            bigsd=0.0002699
+ cigsd=3.925e-020          nigc=1                    poxedge=1
+ pigcd=2.171               ntox=1                    xrcrg1=12
+ xrcrg2=1                  cgso=cgon_18              cgdo=cgon_18
+ cgbo=0                    cgdl=cgln_18              cgsl=cgln_18
+ clc=1e-007                cle=0.6                   cf=cfn_18
+ ckappas=0.6               ckappad=0.6               acde=0.4
+ moin=5                    noff=1.695                voffcv=-0.07
+ kt1=-0.28242815           lkt1=-6.2639176e-009      wkt1=-2.2568273e-008
+ pkt1=4.7397652e-015       kt1l=0                    kt2=-0.02
+ ute=-1.0079952            lute=-1.171021e-007       wute=1.7919323e-007
+ pute=5.7164441e-014       ua1=3.5797547e-009        lua1=-1.9302933e-016
+ wua1=5.3524326e-016       pua1=9.0103416e-023       ub1=-3.4647162e-018
+ lub1=-1.4233566e-025      wub1=-5.0785814e-025      pub1=9.9487193e-032
+ uc1=6.8747883e-012        luc1=-5.2160867e-017      wuc1=-1.5373729e-016
+ puc1=5.111765e-023        prt=0                     at=25905.139
+ lat=-0.0001199309         wat=-0.0090332861         pat=1.1969104e-009
+ jss=2.85e-07              jsd=2.85e-07              jsws=6.9e-13
+ jswd=6.9e-13              jswgs=6.9e-13             jswgd=6.9e-13
+ njs=1                     njd=1                     ijthsfwd=0.01
+ ijthdfwd=0.01             ijthsrev=0.01             ijthdrev=0.01
+ bvs=10                    bvd=10                    xjbvs=1
+ xjbvd=1                   pbs=0.613                 pbd=0.613
+ cjs=cjn_18                cjd=cjn_18                mjs=0.279
+ mjd=0.279                 pbsws=0.613               pbswd=0.613
+ cjsws=cjswn_18            cjswd=cjswn_18            mjsws=0.01
+ mjswd=0.01                pbswgs=0.952              pbswgd=0.952
+ cjswgs=cjswgn_18          cjswgd=cjswgn_18          mjswgs=0.541
+ mjswgd=0.541              tpb=0.00133               tcj=0.000766
+ tpbsw=0.00133             tcjsw=0.0001              tpbswg=0.00133
+ tcjswg=0.00088            xtis=3                    xtid=3
+ jtsswgs=1.000e-08         jtsswgd=1.000e-08         njtsswg=40.31
+ xtsswgs=0.4558            xtsswgd=0.4558            tnjtsswg=1
+ dmcg=1.255e-007           dmci=1.255e-007           dmdg=0
+ dmcgt=0                   dwj=0                     xgw=0
+ xgl=0                     rshg=1                    gbmin=1e-012
+ rbpb=50                   rbpd=50                   rbps=50
+ rbdb=50                   rbsb=50                   ngcon=1
+ saref=0.82e-6             sbref=0.82e-6             kvsat=0.40
+ wlod=0.15e-6              tku0=0.1                  ku0=-7.0e-8
+ llodku0=1                 wlodku0=1                 lku0=2.0e-7
+ wku0=0.2e-6               pku0=0.5e-13              kvth0=4e-9
+ stk2=0                    steta0=0                  lkvth0=-4.68e-11
+ wkvth0=7e-7               pkvth0=0                  llodvth=1
+ wlodvth=1                 lodk2=1                   lodeta0=1
+ fnoimod=1                 noia=5.3e+41              noib=1.0e+20
+ noic=1.0e+7               em=1.00e+07               ef=0.92
+ tnoimod=0                 ud=0                      wpemod=wpeflag_18
+ kvth0we=4.5e-3            lkvth0we=0.0e-11          wkvth0we=0
+ pkvth0we=0                ku0we=-2e-4               lku0we=0
+ wku0we=0                  pku0we=0                  k2we=0.0
+ wk2we=0                   web=0                     wec=0
+ scref=1e-6                lnfactor=0+dlnfactorn_18  minr=1e-3

     11: type=n
+ lmin=1e-005-dxln_18       lmax=0.0009001            wmin=6e-007-dxwn_18
+ wmax=1e-006-dxwn_18       version=4.5               binunit=2
+ paramchk=1                mobmod=0                  capmod=2
+ igcmod=0                  igbmod=0                  geomod=0
+ diomod=1                  rdsmod=0                  rbodymod=0
+ rgatemod=0                permod=1                  acnqsmod=0
+ trnqsmod=0                tempmod=0                 tnom=25
+ toxe=toxn_18              toxm=toxn_18              dtox=2.15e-010
+ epsrox=3.9                wint=1e-008               lint=6.25e-009
+ ll=0                      wl=0                      lln=1
+ wln=1                     lw=0                      ww=0
+ lwn=1                     wwn=1                     lwl=0
+ wwl=0                     llc=0                     wlc=0
+ lwc=0                     wwc=0                     lwlc=0
+ wwlc=0                    xl=-5.5e-08+dxln_18       xw=0+dxwn_18
+ dlc=dlcn_18               dwc=0                     xpart=1
+ toxref=3e-009             dlcig=6.25e-009           vth0=0.352+dvthn_18
+ k1=0.5288                 k2=0.001785+dk2n_18       wk2=9.947e-010
+ k3=-0.85                  k3b=0.9                   w0=0
+ dvt0=0                    dvt1=0                    dvt2=0
+ dvt0w=0                   dvt1w=0                   dvt2w=0
+ dsub=0.32                 minv=-0.3                 voffl=0
+ dvtp0=1.4e-006            dvtp1=0.06                lpe0=3.2e-008
+ lpeb=0                    xj=1.5e-007               ngate=4e+020
+ ndep=4.2e+017             nsd=1e+020                phin=0
+ cdsc=0                    cdscb=0                   cdscd=0
+ cit=0.0005015             wcit=-9.947e-011          voff=-0.11176
+ wvoff=-1.59152e-008       nfactor=1.4               eta0=0.0453
+ weta0=-1.9894e-008        etab=-0.05                u0=0.040195
+ wu0=1.2789e-009           ua=-2.084717e-011         wua=2.1186058e-016
+ ub=1.9468126e-018         wub=-1.2244473e-025       uc=1.7775e-010
+ wuc=7.105e-018            vsat=92877.156            wvsat=0.0035512495
+ a0=1.7107149              wa0=-2.6577389e-007       ags=0.62306096
+ wags=-4.7243703e-008      a1=0                      a2=0.8
+ b0=0                      b1=0                      keta=-0.0414
+ wketa=-1.1368e-008        dwg=0                     dwb=0
+ pclm=0.2                  pdiblc1=0                 pdiblc2=0.0005315
+ wpdiblc2=1.8473e-010      pdiblcb=0                 drout=0.56
+ pvag=0.8                  delta=0.012               pscbe1=7.506e+008
+ pscbe2=1e-020             fprout=0                  pdits=0
+ pditsd=0                  pditsl=0                  rsh=10.5
+ rdsw=150+drdswn_18        prwg=0                    prwb=0
+ wr=1                      alpha0=0                  alpha1=2.2950
+ beta0=17.8                agidl=2.56e-012           bgidl=8.66e+008
+ cgidl=0.25                egidl=0.2624              aigbacc=0.01213
+ bigbacc=0.006537          cigbacc=0.2809            nigbacc=4.05
+ aigbinv=0.35              bigbinv=0.03              cigbinv=0.006
+ eigbinv=1.1               nigbinv=1                 aigc=0.01
+ bigc=0.00144              cigc=1.515e-005           aigsd=0.008379
+ bigsd=0.0002699           cigsd=3.925e-020          nigc=1
+ poxedge=1                 pigcd=2.171               ntox=1
+ xrcrg1=12                 xrcrg2=1                  cgso=cgon_18
+ cgdo=cgon_18              cgbo=0                    cgdl=cgln_18
+ cgsl=cgln_18              clc=1e-007                cle=0.6
+ cf=cfn_18                 ckappas=0.6               ckappad=0.6
+ acde=0.4                  moin=5                    noff=1.695
+ voffcv=-0.07              kt1=-0.25725              wkt1=7.105e-009
+ kt1l=0                    kt2=-0.02                 ute=-0.49325
+ wute=-8.73915e-007        ua1=7.2172027e-009        wua1=-4.0928296e-015
+ ub1=-6.6853172e-018       wub1=2.8334839e-024       uc1=-1.5e-010
+ prt=0                     at=220000                 jss=2.85e-07
+ jsd=2.85e-07              jsws=6.9e-13              jswd=6.9e-13
+ jswgs=6.9e-13             jswgd=6.9e-13             njs=1
+ njd=1                     ijthsfwd=0.01             ijthdfwd=0.01
+ ijthsrev=0.01             ijthdrev=0.01             bvs=10
+ bvd=10                    xjbvs=1                   xjbvd=1
+ pbs=0.613                 pbd=0.613                 cjs=cjn_18
+ cjd=cjn_18                mjs=0.279                 mjd=0.279
+ pbsws=0.613               pbswd=0.613               cjsws=cjswn_18
+ cjswd=cjswn_18            mjsws=0.01                mjswd=0.01
+ pbswgs=0.952              pbswgd=0.952              cjswgs=cjswgn_18
+ cjswgd=cjswgn_18          mjswgs=0.541              mjswgd=0.541
+ tpb=0.00133               tcj=0.000766              tpbsw=0.00133
+ tcjsw=0.0001              tpbswg=0.00133            tcjswg=0.00088
+ xtis=3                    xtid=3                    jtsswgs=1.000e-08
+ jtsswgd=1.000e-08         njtsswg=40.31             xtsswgs=0.4558
+ xtsswgd=0.4558            tnjtsswg=1                dmcg=1.255e-007
+ dmci=1.255e-007           dmdg=0                    dmcgt=0
+ dwj=0                     xgw=0                     xgl=0
+ rshg=1                    gbmin=1e-012              rbpb=50
+ rbpd=50                   rbps=50                   rbdb=50
+ rbsb=50                   ngcon=1                   lvth0=0+dlvthn_18
+ wvth0=0+dwvthn_18         saref=0.82e-6             sbref=0.82e-6
+ kvsat=0.40                wlod=0.15e-6              tku0=0.1
+ ku0=-7.0e-8               llodku0=1                 wlodku0=1
+ lku0=2.0e-7               wku0=0.2e-6               pku0=0.5e-13
+ kvth0=4e-9                stk2=0                    steta0=0
+ lkvth0=-4.68e-11          wkvth0=7e-7               pkvth0=0
+ llodvth=1                 wlodvth=1                 lodk2=1
+ lodeta0=1                 fnoimod=1                 noia=5.3e+41
+ noib=1.0e+20              noic=1.0e+7               em=1.00e+07
+ ef=0.92                   tnoimod=0                 ud=0
+ wpemod=wpeflag_18         kvth0we=4.5e-3            lkvth0we=0.0e-11
+ wkvth0we=0                pkvth0we=0                ku0we=-2e-4
+ lku0we=0                  wku0we=0                  pku0we=0
+ k2we=0.0                  wk2we=0                   web=0
+ wec=0                     scref=1e-6                lvsat=0+dlvsatn_18
+ lpclm=0+dlpclmn_18        lnfactor=0+dlnfactorn_18  minr=1e-3

     12: type=n
+ lmin=1.2e-006-dxln_18     lmax=1e-005-dxln_18       wmin=6e-007-dxwn_18
+ wmax=1e-006-dxwn_18       version=4.5               binunit=2
+ paramchk=1                mobmod=0                  capmod=2
+ igcmod=0                  igbmod=0                  geomod=0
+ diomod=1                  rdsmod=0                  rbodymod=0
+ rgatemod=0                permod=1                  acnqsmod=0
+ trnqsmod=0                tempmod=0                 tnom=25
+ toxe=toxn_18              toxm=toxn_18              dtox=2.15e-010
+ epsrox=3.9                wint=1e-008               lint=6.25e-009
+ ll=0                      wl=0                      lln=1
+ wln=1                     lw=0                      ww=0
+ lwn=1                     wwn=1                     lwl=0
+ wwl=0                     llc=0                     wlc=0
+ lwc=0                     wwc=0                     lwlc=0
+ wwlc=0                    xl=-5.5e-08+dxln_18       xw=0+dxwn_18
+ dlc=dlcn_18               dwc=0                     xpart=1
+ toxref=3e-009             dlcig=6.25e-009           vth0=0.35251477+dvthn_18
+ lvth0=-5.1129801e-009+dlvthn_18                     k1=0.5288
+ k2=0.00076639347+dk2n_18  lk2=1.0117309e-008        wk2=2.2199492e-009
+ pk2=-1.2169787e-014       k3=-0.85                  k3b=0.9
+ w0=0                      dvt0=0                    dvt1=0
+ dvt2=0                    dvt0w=0                   dvt1w=0
+ dvt2w=0                   dsub=0.32                 minv=-0.3
+ voffl=0                   dvtp0=1.4e-006            dvtp1=0.06
+ lpe0=3.2e-008             lpeb=0                    xj=1.5e-007
+ ngate=4e+020              ndep=4.2e+017             nsd=1e+020
+ phin=0                    cdsc=0                    cdscb=0
+ cdscd=0                   cit=0.0004722223          lcit=2.9080074e-010
+ wcit=-1.0861365e-010      pcit=9.0819309e-017       voff=-0.11235328
+ lvoff=5.8927096e-009      wvoff=-1.5586029e-008     pvoff=-3.2694951e-015
+ nfactor=1.4               eta0=0.0453               weta0=-1.9894e-008
+ etab=-0.05                u0=0.040195               wu0=1.2789e-009
+ ua=-5.1151476e-013        lua=-2.019839e-016        wua=2.0892454e-016
+ pua=2.9162244e-023        ub=1.9409065e-018         lub=5.8661988e-026
+ wub=-1.2340152e-025       pub=9.5033325e-033        uc=1.7215185e-010
+ luc=5.5603659e-017        wuc=1.259119e-017         puc=-5.4491586e-023
+ vsat=92877.156            wvsat=0.0035512495        a0=1.8836068
+ la0=-1.7172495e-006       wa0=-3.5065131e-007       pa0=8.4304495e-013
+ ags=0.61901374            lags=4.019901e-008        wags=-6.5966772e-008
+ pags=1.8596689e-013       a1=0                      a2=0.8
+ b0=0                      b1=0                      keta=-0.034939602
+ lketa=-6.41679e-008       wketa=-1.4293968e-008     pketa=2.9062179e-014
+ dwg=0                     dwb=0                     pclm=0.17812216
+ lpclm=2.1730165e-007+dlpclmn_18                     pdiblc1=0
+ pdiblc2=-3.0696165e-005   lpdiblc2=5.5840134e-009   wpdiblc2=2.0850349e-010
+ ppdiblc2=-2.361302e-016   pdiblcb=0                 drout=0.56
+ pvag=0.8                  delta=0.012               pscbe1=7.506e+008
+ pscbe2=1e-020             fprout=0                  pdits=0
+ pditsd=0                  pditsl=0                  rsh=10.5
+ rdsw=150+drdswn_18        prwg=0                    prwb=0
+ wr=1                      alpha0=0                  alpha1=2.2950
+ beta0=17.8                agidl=2.56e-012           bgidl=8.66e+008
+ cgidl=0.25                egidl=0.2624              aigbacc=0.01213
+ bigbacc=0.006537          cigbacc=0.2809            nigbacc=4.05
+ aigbinv=0.35              bigbinv=0.03              cigbinv=0.006
+ eigbinv=1.1               nigbinv=1                 aigc=0.01
+ bigc=0.00144              cigc=1.515e-005           aigsd=0.008379
+ bigsd=0.0002699           cigsd=3.925e-020          nigc=1
+ poxedge=1                 pigcd=2.171               ntox=1
+ xrcrg1=12                 xrcrg2=1                  cgso=cgon_18
+ cgdo=cgon_18              cgbo=0                    cgdl=cgln_18
+ cgsl=cgln_18              clc=1e-007                cle=0.6
+ cf=cfn_18                 ckappas=0.6               ckappad=0.6
+ acde=0.4                  moin=5                    noff=1.695
+ voffcv=-0.07              kt1=-0.26030164           lkt1=3.0310385e-008
+ wkt1=1.1356798e-008       pkt1=-4.2230979e-014      kt1l=0
+ kt2=-0.02                 ute=-0.5197608            lute=2.6331848e-007
+ wute=-8.7757246e-007      pute=3.6327724e-014       ua1=7.330915e-009
+ lua1=-1.1294475e-015      wua1=-4.2364403e-015      pua1=1.4264135e-021
+ ub1=-6.8505892e-018       lub1=1.6415642e-024       wub1=3.0058498e-024
+ pub1=-1.7120239e-030      uc1=-1.5756072e-010       luc1=7.5096895e-017
+ wuc1=1.3715476e-017       puc1=-1.3622896e-022      prt=0
+ at=234568.07              lat=-0.14469734           wat=0.00073149205
+ pat=-7.2655447e-009       jss=2.85e-07              jsd=2.85e-07
+ jsws=6.9e-13              jswd=6.9e-13              jswgs=6.9e-13
+ jswgd=6.9e-13             njs=1                     njd=1
+ ijthsfwd=0.01             ijthdfwd=0.01             ijthsrev=0.01
+ ijthdrev=0.01             bvs=10                    bvd=10
+ xjbvs=1                   xjbvd=1                   pbs=0.613
+ pbd=0.613                 cjs=cjn_18                cjd=cjn_18
+ mjs=0.279                 mjd=0.279                 pbsws=0.613
+ pbswd=0.613               cjsws=cjswn_18            cjswd=cjswn_18
+ mjsws=0.01                mjswd=0.01                pbswgs=0.952
+ pbswgd=0.952              cjswgs=cjswgn_18          cjswgd=cjswgn_18
+ mjswgs=0.541              mjswgd=0.541              tpb=0.00133
+ tcj=0.000766              tpbsw=0.00133             tcjsw=0.0001
+ tpbswg=0.00133            tcjswg=0.00088            xtis=3
+ xtid=3                    jtsswgs=1.000e-08         jtsswgd=1.000e-08
+ njtsswg=40.31             xtsswgs=0.4558            xtsswgd=0.4558
+ tnjtsswg=1                dmcg=1.255e-007           dmci=1.255e-007
+ dmdg=0                    dmcgt=0                   dwj=0
+ xgw=0                     xgl=0                     rshg=1
+ gbmin=1e-012              rbpb=50                   rbpd=50
+ rbps=50                   rbdb=50                   rbsb=50
+ ngcon=1                   wvth0=0+dwvthn_18         saref=0.82e-6
+ sbref=0.82e-6             kvsat=0.40                wlod=0.15e-6
+ tku0=0.1                  ku0=-7.0e-8               llodku0=1
+ wlodku0=1                 lku0=2.0e-7               wku0=0.2e-6
+ pku0=0.5e-13              kvth0=4e-9                stk2=0
+ steta0=0                  lkvth0=-4.68e-11          wkvth0=7e-7
+ pkvth0=0                  llodvth=1                 wlodvth=1
+ lodk2=1                   lodeta0=1                 fnoimod=1
+ noia=5.3e+41              noib=1.0e+20              noic=1.0e+7
+ em=1.00e+07               ef=0.92                   tnoimod=0
+ ud=0                      wpemod=wpeflag_18         kvth0we=4.5e-3
+ lkvth0we=0.0e-11          wkvth0we=0                pkvth0we=0
+ ku0we=-2e-4               lku0we=0                  wku0we=0
+ pku0we=0                  k2we=0.0                  wk2we=0
+ web=0                     wec=0                     scref=1e-6
+ lvsat=0+dlvsatn_18        lnfactor=0+dlnfactorn_18  minr=1e-3

     13: type=n
+ lmin=7e-007-dxln_18       lmax=1.2e-006-dxln_18     wmin=6e-007-dxwn_18
+ wmax=1e-006-dxwn_18       version=4.5               binunit=2
+ paramchk=1                mobmod=0                  capmod=2
+ igcmod=0                  igbmod=0                  geomod=0
+ diomod=1                  rdsmod=0                  rbodymod=0
+ rgatemod=0                permod=1                  acnqsmod=0
+ trnqsmod=0                tempmod=0                 tnom=25
+ toxe=toxn_18              toxm=toxn_18              dtox=2.15e-010
+ epsrox=3.9                wint=1e-008               lint=6.25e-009
+ ll=0                      wl=0                      lln=1
+ wln=1                     lw=0                      ww=0
+ lwn=1                     wwn=1                     lwl=0
+ wwl=0                     llc=0                     wlc=0
+ lwc=0                     wwc=0                     lwlc=0
+ wwlc=0                    xl=-5.5e-08+dxln_18       xw=0+dxwn_18
+ dlc=dlcn_18               dwc=0                     xpart=1
+ toxref=3e-009             dlcig=6.25e-009           vth0=0.348+dvthn_18
+ k1=0.5288                 k2=0.01431725+dk2n_18     lk2=-5.2290356e-009
+ wk2=-3.133305e-009        pk2=-6.1072271e-015       k3=-0.85
+ k3b=0.9                   w0=0                      dvt0=0
+ dvt1=0                    dvt2=0                    dvt0w=0
+ dvt1w=0                   dvt2w=0                   dsub=0.32
+ minv=-0.3                 voffl=0                   dvtp0=1.4e-006
+ dvtp1=0.06                lpe0=3.2e-008             lpeb=0
+ xj=1.5e-007               ngate=4e+020              ndep=4.2e+017
+ nsd=1e+020                phin=0                    cdsc=0
+ cdscb=0                   cdscd=0                   cit=0.00032926
+ lcit=4.5270555e-010       wcit=1.153852e-010        pcit=-1.6285939e-016
+ voff=-0.10863637          lvoff=1.6833197e-009      wvoff=-1.5776653e-008
+ pvoff=-3.0536135e-015     nfactor=1.4               eta0=0.0453
+ weta0=-1.9894e-008        etab=-0.05                u0=0.040195
+ wu0=1.2789e-009           ua=-6.9429976e-011        lua=-1.2393374e-016
+ wua=2.7589681e-016        pua=-4.6683847e-023       ub=1.9156716e-018
+ lub=8.7240586e-026        wub=-5.4455484e-026       pub=-6.8578053e-032
+ uc=2.218825e-010          luc=-7.1630625e-019       wuc=-1.754935e-017
+ puc=-2.0357424e-023       vsat=92877.156            wvsat=0.0035512495
+ a0=0.21806401             la0=1.6897778e-007        wa0=7.0220738e-007
+ pa0=-3.4931751e-013       ags=0.37991983            lags=3.1097286e-007
+ wags=2.0500967e-007       pags=-1.2091394e-013      a1=0
+ a2=0.8                    b0=0                      b1=0
+ keta=-0.13379691          lketa=4.7787999e-008      wketa=3.5842207e-008
+ pketa=-2.7717039e-014     dwg=0                     dwb=0
+ pclm=0.3162375            lpclm=6.0886031e-008+dlpclmn_18
+ wpclm=8.987825e-008       ppclm=-1.0178712e-013     pdiblc1=0
+ pdiblc2=0.001358          lpdiblc2=4.011315e-009    pdiblcb=0
+ drout=0.56                pvag=0.8                  delta=0.012
+ pscbe1=7.506e+008         pscbe2=1e-020             fprout=0
+ pdits=0                   pditsd=0                  pditsl=0
+ rsh=10.5                  rdsw=150+drdswn_18        prwg=0
+ prwb=0                    wr=1                      alpha0=0
+ alpha1=2.2950             beta0=17.8                agidl=2.56e-012
+ bgidl=8.66e+008           cgidl=0.25                egidl=0.2624
+ aigbacc=0.01213           bigbacc=0.006537          cigbacc=0.2809
+ nigbacc=4.05              aigbinv=0.35              bigbinv=0.03
+ cigbinv=0.006             eigbinv=1.1               nigbinv=1
+ aigc=0.01                 bigc=0.00144              cigc=1.515e-005
+ aigsd=0.008379            bigsd=0.0002699           cigsd=3.925e-020
+ nigc=1                    poxedge=1                 pigcd=2.171
+ ntox=1                    xrcrg1=12                 xrcrg2=1
+ cgso=cgon_18              cgdo=cgon_18              cgbo=0
+ cgdl=cgln_18              cgsl=cgln_18              clc=1e-007
+ cle=0.6                   cf=cfn_18                 ckappas=0.6
+ ckappad=0.6               acde=0.4                  moin=5
+ noff=1.695                voffcv=-0.07              kt1=-0.22098554
+ lkt1=-1.4215098e-008      wkt1=-1.3440173e-008      pkt1=-1.4148409e-014
+ kt1l=0                    kt2=-0.02                 ute=-0.5251965
+ lute=2.6947441e-007       wute=-5.2552843e-007      pute=-3.6236214e-013
+ ua1=5.6628059e-009        lua1=7.5968604e-016       wua1=-1.8908324e-015
+ pua1=-1.2299874e-021      ub1=-5.4240696e-018       lub1=2.6030784e-026
+ wub1=1.1956379e-024       pub1=3.3804113e-031       uc1=2.101875e-011
+ luc1=-1.2714436e-016      wuc1=-2.4139238e-016      puc1=1.5268068e-022
+ prt=0                     at=178652                 lat=-0.08137239
+ wat=-0.01287426           pat=8.1429694e-009        jss=2.85e-07
+ jsd=2.85e-07              jsws=6.9e-13              jswd=6.9e-13
+ jswgs=6.9e-13             jswgd=6.9e-13             njs=1
+ njd=1                     ijthsfwd=0.01             ijthdfwd=0.01
+ ijthsrev=0.01             ijthdrev=0.01             bvs=10
+ bvd=10                    xjbvs=1                   xjbvd=1
+ pbs=0.613                 pbd=0.613                 cjs=cjn_18
+ cjd=cjn_18                mjs=0.279                 mjd=0.279
+ pbsws=0.613               pbswd=0.613               cjsws=cjswn_18
+ cjswd=cjswn_18            mjsws=0.01                mjswd=0.01
+ pbswgs=0.952              pbswgd=0.952              cjswgs=cjswgn_18
+ cjswgd=cjswgn_18          mjswgs=0.541              mjswgd=0.541
+ tpb=0.00133               tcj=0.000766              tpbsw=0.00133
+ tcjsw=0.0001              tpbswg=0.00133            tcjswg=0.00088
+ xtis=3                    xtid=3                    jtsswgs=1.000e-08
+ jtsswgd=1.000e-08         njtsswg=40.31             xtsswgs=0.4558
+ xtsswgd=0.4558            tnjtsswg=1                dmcg=1.255e-007
+ dmci=1.255e-007           dmdg=0                    dmcgt=0
+ dwj=0                     xgw=0                     xgl=0
+ rshg=1                    gbmin=1e-012              rbpb=50
+ rbpd=50                   rbps=50                   rbdb=50
+ rbsb=50                   ngcon=1                   lvth0=0+dlvthn_18
+ saref=0.82e-6             sbref=0.82e-6             kvsat=0.40
+ wlod=0.15e-6              tku0=0.1                  ku0=-7.0e-8
+ llodku0=1                 wlodku0=1                 lku0=2.0e-7
+ wku0=0.2e-6               pku0=0.5e-13              kvth0=4e-9
+ stk2=0                    steta0=0                  lkvth0=-4.68e-11
+ wkvth0=7e-7               pkvth0=0                  llodvth=1
+ wlodvth=1                 lodk2=1                   lodeta0=1
+ fnoimod=1                 noia=5.3e+41              noib=1.0e+20
+ noic=1.0e+7               em=1.00e+07               ef=0.92
+ tnoimod=0                 ud=0                      wpemod=wpeflag_18
+ kvth0we=4.5e-3            lkvth0we=0.0e-11          wkvth0we=0
+ pkvth0we=0                ku0we=-2e-4               lku0we=0
+ wku0we=0                  pku0we=0                  k2we=0.0
+ wk2we=0                   web=0                     wec=0
+ scref=1e-6                wvth0=0+dwvthn_18         lvsat=0+dlvsatn_18
+ lnfactor=0+dlnfactorn_18  minr=1e-3

     14: type=n
+ lmin=4e-007-dxln_18       lmax=7e-007-dxln_18       wmin=6e-007-dxwn_18
+ wmax=1e-006-dxwn_18       version=4.5               binunit=2
+ paramchk=1                mobmod=0                  capmod=2
+ igcmod=0                  igbmod=0                  geomod=0
+ diomod=1                  rdsmod=0                  rbodymod=0
+ rgatemod=0                permod=1                  acnqsmod=0
+ trnqsmod=0                tempmod=0                 tnom=25
+ toxe=toxn_18              toxm=toxn_18              dtox=2.15e-010
+ epsrox=3.9                wint=1e-008               lint=6.25e-009
+ ll=0                      wl=0                      lln=1
+ wln=1                     lw=0                      ww=0
+ lwn=1                     wwn=1                     lwl=0
+ wwl=0                     llc=0                     wlc=0
+ lwc=0                     wwc=0                     lwlc=0
+ wwlc=0                    xl=-5.5e-08+dxln_18       xw=0+dxwn_18
+ dlc=dlcn_18               dwc=0                     xpart=1
+ toxref=3e-009             dlcig=6.25e-009           vth0=0.35575833+dvthn_18
+ lvth0=-4.9071458e-009+dlvthn_18                     k1=0.5288
+ k2=0.03860175+dk2n_18     lk2=-2.0588982e-008       wk2=-2.9483382e-008
+ pk2=1.0559196e-014        k3=-0.85                  k3b=0.9
+ w0=0                      dvt0=0                    dvt1=0
+ dvt2=0                    dvt0w=0                   dvt1w=0
+ dvt2w=0                   dsub=0.32                 minv=-0.3
+ voffl=0                   dvtp0=1.4e-006            dvtp1=0.06
+ lpe0=3.2e-008             lpeb=0                    xj=1.5e-007
+ ngate=4e+020              ndep=4.2e+017             nsd=1e+020
+ phin=0                    cdsc=0                    cdscb=0
+ cdscd=0                   cit=0.00060166667         lcit=2.8040833e-010
+ wcit=-1.421e-010          pcit=-2.7972651e-030      voff=-0.10428479
+ lvoff=-1.0690568e-009     wvoff=-2.7691737e-008     pvoff=4.4826777e-015
+ nfactor=1.4               eta0=0.0453               weta0=-1.9894e-008
+ etab=-0.05                u0=0.040195               wu0=1.2789e-009
+ ua=-4.3990846e-010        lua=1.103939e-016         wua=3.837073e-016
+ pua=-1.1487399e-022       ub=2.5906365e-018         lub=-3.396747e-025
+ wub=-5.0280052e-025       pub=2.1500018e-031        uc=3.0470625e-010
+ luc=-5.3102328e-017       wuc=-1.0485796e-016       puc=3.4865271e-023
+ vsat=92876.83             lvsat=2.0610013e-007+dlvsatn_18
+ wvsat=0.0035514385        pvsat=-1.1953807e-013     a0=0.58179739
+ la0=-6.1083591e-008       wa0=3.3789286e-007        pa0=-1.1888858e-013
+ ags=1.0650044             lags=-1.2234312e-007      wags=9.6729943e-008
+ pags=-5.2427008e-014      a1=0                      a2=0.8
+ b0=0                      b1=0                      keta=-0.10810974
+ lketa=3.1540862e-008      wketa=6.8013134e-009      pketa=-9.3486742e-015
+ dwg=0                     dwb=0                     pclm=0.37315417
+ lpclm=2.488624e-008+dlpclmn_18                      wpclm=-8.6799417e-008
+ ppclm=9.961506e-015       pdiblc1=0                 pdiblc2=0.004291875
+ lpdiblc2=2.1556391e-009   wpdiblc2=-7.8747083e-010  ppdiblc2=4.980753e-016
+ pdiblcb=0.60404166        lpdiblcb=-3.8205635e-007  wpdiblcb=-1.5749417e-007
+ ppdiblcb=9.961506e-014    drout=0.56                pvag=0.8
+ delta=0.012               pscbe1=7.506e+008         pscbe2=1e-020
+ fprout=0                  pdits=0                   pditsd=0
+ pditsl=0                  rsh=10.5                  rdsw=150+drdswn_18
+ prwg=0                    prwb=0                    wr=1
+ alpha0=0                  alpha1=2.2950             beta0=17.8
+ agidl=2.56e-012           bgidl=8.66e+008           cgidl=0.25
+ egidl=0.2624              aigbacc=0.01213           bigbacc=0.006537
+ cigbacc=0.2809            nigbacc=4.05              aigbinv=0.35
+ bigbinv=0.03              cigbinv=0.006             eigbinv=1.1
+ nigbinv=1                 aigc=0.01                 bigc=0.00144
+ cigc=1.515e-005           aigsd=0.008379            bigsd=0.0002699
+ cigsd=3.925e-020          nigc=1                    poxedge=1
+ pigcd=2.171               ntox=1                    xrcrg1=12
+ xrcrg2=1                  cgso=cgon_18              cgdo=cgon_18
+ cgbo=0                    cgdl=cgln_18              cgsl=cgln_18
+ clc=1e-007                cle=0.6                   cf=cfn_18
+ ckappas=0.6               ckappad=0.6               acde=0.4
+ moin=5                    noff=1.695                voffcv=-0.07
+ kt1=-0.16859042           lkt1=-4.7355009e-008      wkt1=-7.6867929e-008
+ pkt1=2.5969646e-014       kt1l=0                    kt2=-0.02
+ ute=0.69649479            lute=-5.0324533e-007      wute=-2.1150578e-006
+ pute=6.4301521e-013       ua1=9.829963e-009         lua1=-1.8760408e-015
+ wua1=-7.6891052e-015      pua1=2.4374201e-021       ub1=-6.9151675e-018
+ lub1=9.6915023e-025       wub1=3.7619477e-024       pub1=-1.2851498e-030
+ uc1=-2.4539167e-010       luc1=4.1360229e-017       wuc1=3.1498833e-017
+ puc1=-1.9923012e-023      prt=0                     at=83250
+ lat=-0.021030625          jss=2.85e-07              jsd=2.85e-07
+ jsws=6.9e-13              jswd=6.9e-13              jswgs=6.9e-13
+ jswgd=6.9e-13             njs=1                     njd=1
+ ijthsfwd=0.01             ijthdfwd=0.01             ijthsrev=0.01
+ ijthdrev=0.01             bvs=10                    bvd=10
+ xjbvs=1                   xjbvd=1                   pbs=0.613
+ pbd=0.613                 cjs=cjn_18                cjd=cjn_18
+ mjs=0.279                 mjd=0.279                 pbsws=0.613
+ pbswd=0.613               cjsws=cjswn_18            cjswd=cjswn_18
+ mjsws=0.01                mjswd=0.01                pbswgs=0.952
+ pbswgd=0.952              cjswgs=cjswgn_18          cjswgd=cjswgn_18
+ mjswgs=0.541              mjswgd=0.541              tpb=0.00133
+ tcj=0.000766              tpbsw=0.00133             tcjsw=0.0001
+ tpbswg=0.00133            tcjswg=0.00088            xtis=3
+ xtid=3                    jtsswgs=1.000e-08         jtsswgd=1.000e-08
+ njtsswg=40.31             xtsswgs=0.4558            xtsswgd=0.4558
+ tnjtsswg=1                dmcg=1.255e-007           dmci=1.255e-007
+ dmdg=0                    dmcgt=0                   dwj=0
+ xgw=0                     xgl=0                     rshg=1
+ gbmin=1e-012              rbpb=50                   rbpd=50
+ rbps=50                   rbdb=50                   rbsb=50
+ ngcon=1                   wvth0=0+dwvthn_18         saref=0.82e-6
+ sbref=0.82e-6             kvsat=0.40                wlod=0.15e-6
+ tku0=0.1                  ku0=-7.0e-8               llodku0=1
+ wlodku0=1                 lku0=2.0e-7               wku0=0.2e-6
+ pku0=0.5e-13              kvth0=4e-9                stk2=0
+ steta0=0                  lkvth0=-4.68e-11          wkvth0=7e-7
+ pkvth0=0                  llodvth=1                 wlodvth=1
+ lodk2=1                   lodeta0=1                 fnoimod=1
+ noia=5.3e+41              noib=1.0e+20              noic=1.0e+7
+ em=1.00e+07               ef=0.92                   tnoimod=0
+ ud=0                      wpemod=wpeflag_18         kvth0we=4.5e-3
+ lkvth0we=0.0e-11          wkvth0we=0                pkvth0we=0
+ ku0we=-2e-4               lku0we=0                  wku0we=0
+ pku0we=0                  k2we=0.0                  wk2we=0
+ web=0                     wec=0                     scref=1e-6
+ lnfactor=0+dlnfactorn_18  minr=1e-3

     15: type=n
+ lmin=2e-07                lmax=4e-007-dxln_18       wmin=6e-007-dxwn_18
+ wmax=1e-006-dxwn_18       version=4.5               binunit=2
+ paramchk=1                mobmod=0                  capmod=2
+ igcmod=0                  igbmod=0                  geomod=0
+ diomod=1                  rdsmod=0                  rbodymod=0
+ rgatemod=0                permod=1                  acnqsmod=0
+ trnqsmod=0                tempmod=0                 tnom=25
+ toxe=toxn_18              toxm=toxn_18              dtox=2.15e-010
+ epsrox=3.9                wint=1e-008               lint=6.25e-009
+ ll=0                      wl=0                      lln=1
+ wln=1                     lw=0                      ww=0
+ lwn=1                     wwn=1                     lwl=0
+ wwl=0                     llc=0                     wlc=0
+ lwc=0                     wwc=0                     lwlc=0
+ wwlc=0                    xl=-5.5e-08+dxln_18       xw=0+dxwn_18
+ dlc=dlcn_18               dwc=0                     xpart=1
+ toxref=3e-009             dlcig=6.25e-009           vth0=0.34707844+dvthn_18
+ lvth0=-2.0210805e-009+dlvthn_18                     wvth0=-1.4121187e-009+dwvthn_18
+ pvth0=4.6952948e-016      k1=0.5288                 k2=-0.0003279375+dk2n_18
+ lk2=-7.6448608e-009       wk2=-4.5649625e-010       pk2=9.07757e-016
+ k3=-0.85                  k3b=0.9                   w0=0
+ dvt0=0                    dvt1=0                    dvt2=0
+ dvt0w=0                   dvt1w=0                   dvt2w=0
+ dsub=0.32                 minv=-0.3                 voffl=0
+ dvtp0=1.4e-006            dvtp1=0.06                lpe0=3.2e-008
+ lpeb=0                    xj=1.5e-007               ngate=4e+020
+ ndep=4.2e+017             nsd=1e+020                phin=0
+ cdsc=0                    cdscb=0                   cdscd=0
+ cit=0.0011213025          lcit=1.0762942e-010       wcit=1.1019855e-010
+ pcit=-8.3889268e-017      voff=-0.10849508          lvoff=3.3086244e-010
+ wvoff=-2.1975765e-009     pvoff=-3.9941308e-015     nfactor=1.4
+ eta0=0.0453               weta0=-1.9894e-008        etab=-0.05
+ u0=0.04417                lu0=-1.3216875e-009       wu0=1.2789e-009
+ pu0=2.175622e-029         ua=4.3700029e-010         lua=-1.8117826e-016
+ wua=-2.7985953e-016       pua=1.0576199e-022        ub=1.2132026e-018
+ lub=1.1832207e-025        wub=5.4949193e-025        pub=-1.3488706e-031
+ uc=1.5377812e-010         luc=-2.9187266e-018       wuc=1.4121188e-017
+ puc=-4.6952948e-024       vsat=92877.45             wvsat=0.003551079
+ a0=0.38708532             la0=3.6581722e-009        wa0=8.822521e-008
+ pa0=-3.5874087e-014       ags=3.7454662             lags=-1.0135967e-006
+ wags=-2.7011263e-006      pags=8.7786018e-013       a1=0
+ a2=0.8                    b0=0                      b1=0
+ keta=-0.062109375         lketa=1.6245742e-008      wketa=-7.1938125e-009
+ pketa=-4.6952948e-015     dwg=0                     dwb=0
+ pclm=0.322125             lpclm=4.1853437e-008+dlpclmn_18
+ wpclm=-5.684e-008         ppclm=1.7404976e-028      pdiblc1=0
+ pdiblc2=0.0105259         lpdiblc2=8.282575e-011    wpdiblc2=-3.43882e-010
+ ppdiblc2=3.5058202e-016   pdiblcb=-0.9060625        lpdiblcb=1.2005328e-007
+ wpdiblcb=2.3624125e-007   ppdiblcb=-3.1301966e-014  drout=0.56
+ pvag=0.8                  delta=0.012               pscbe1=7.506e+008
+ pscbe2=1e-020             fprout=0                  pdits=0
+ pditsd=0                  pditsl=0                  rsh=10.5
+ rdsw=150+drdswn_18        prwg=0                    prwb=0
+ wr=1                      alpha0=0                  alpha1=2.2950
+ beta0=17.8                agidl=2.56e-012           bgidl=8.66e+008
+ cgidl=0.25                egidl=0.2624              aigbacc=0.01213
+ bigbacc=0.006537          cigbacc=0.2809            nigbacc=4.05
+ aigbinv=0.35              bigbinv=0.03              cigbinv=0.006
+ eigbinv=1.1               nigbinv=1                 aigc=0.01
+ bigc=0.00144              cigc=1.515e-005           aigsd=0.008379
+ bigsd=0.0002699           cigsd=3.925e-020          nigc=1
+ poxedge=1                 pigcd=2.171               ntox=1
+ xrcrg1=12                 xrcrg2=1                  cgso=cgon_18
+ cgdo=cgon_18              cgbo=0                    cgdl=cgln_18
+ cgsl=cgln_18              clc=1e-007                cle=0.6
+ cf=cfn_18                 ckappas=0.6               ckappad=0.6
+ acde=0.4                  moin=5                    noff=1.695
+ voffcv=-0.07              kt1=-0.3297735            lkt1=6.238365e-009
+ wkt1=2.383017e-008        pkt1=-7.5124717e-015      kt1l=0
+ kt2=-0.02                 ute=-0.70703344           lute=-3.6572195e-008
+ wute=-1.1574933e-007      pute=-2.1754866e-014      ua1=4.8687055e-009
+ lua1=-2.2642269e-016      wua1=-7.2792857e-016      pua1=1.2282891e-022
+ ub1=-4.5441504e-018       lub1=1.8078702e-025       wub1=5.4998739e-025
+ pub1=-2.1717304e-031      uc1=-1.017875e-010        luc1=-6.3881563e-018
+ wuc1=-4.724825e-017       puc1=6.2603931e-024       prt=0
+ at=16687.5                lat=0.0011014063          jss=2.85e-07
+ jsd=2.85e-07              jsws=6.9e-13              jswd=6.9e-13
+ jswgs=6.9e-13             jswgd=6.9e-13             njs=1
+ njd=1                     ijthsfwd=0.01             ijthdfwd=0.01
+ ijthsrev=0.01             ijthdrev=0.01             bvs=10
+ bvd=10                    xjbvs=1                   xjbvd=1
+ pbs=0.613                 pbd=0.613                 cjs=cjn_18
+ cjd=cjn_18                mjs=0.279                 mjd=0.279
+ pbsws=0.613               pbswd=0.613               cjsws=cjswn_18
+ cjswd=cjswn_18            mjsws=0.01                mjswd=0.01
+ pbswgs=0.952              pbswgd=0.952              cjswgs=cjswgn_18
+ cjswgd=cjswgn_18          mjswgs=0.541              mjswgd=0.541
+ tpb=0.00133               tcj=0.000766              tpbsw=0.00133
+ tcjsw=0.0001              tpbswg=0.00133            tcjswg=0.00088
+ xtis=3                    xtid=3                    jtsswgs=1.000e-08
+ jtsswgd=1.000e-08         njtsswg=40.31             xtsswgs=0.4558
+ xtsswgd=0.4558            tnjtsswg=1                dmcg=1.255e-007
+ dmci=1.255e-007           dmdg=0                    dmcgt=0
+ dwj=0                     xgw=0                     xgl=0
+ rshg=1                    gbmin=1e-012              rbpb=50
+ rbpd=50                   rbps=50                   rbdb=50
+ rbsb=50                   ngcon=1                   lvsat=0+dlvsatn_18
+ saref=0.82e-6             sbref=0.82e-6             kvsat=0.40
+ wlod=0.15e-6              tku0=0.1                  ku0=-7.0e-8
+ llodku0=1                 wlodku0=1                 lku0=2.0e-7
+ wku0=0.2e-6               pku0=0.5e-13              kvth0=4e-9
+ stk2=0                    steta0=0                  lkvth0=-4.68e-11
+ wkvth0=7e-7               pkvth0=0                  llodvth=1
+ wlodvth=1                 lodk2=1                   lodeta0=1
+ fnoimod=1                 noia=5.3e+41              noib=1.0e+20
+ noic=1.0e+7               em=1.00e+07               ef=0.92
+ tnoimod=0                 ud=0                      wpemod=wpeflag_18
+ kvth0we=4.5e-3            lkvth0we=0.0e-11          wkvth0we=0
+ pkvth0we=0                ku0we=-2e-4               lku0we=0
+ wku0we=0                  pku0we=0                  k2we=0.0
+ wk2we=0                   web=0                     wec=0
+ scref=1e-6                lnfactor=0+dlnfactorn_18  minr=1e-3

     16: type=n
+ lmin=1e-005-dxln_18       lmax=0.0009001            wmin=4e-07
+ wmax=6e-007-dxwn_18       version=4.5               binunit=2
+ paramchk=1                mobmod=0                  capmod=2
+ igcmod=0                  igbmod=0                  geomod=0
+ diomod=1                  rdsmod=0                  rbodymod=0
+ rgatemod=0                permod=1                  acnqsmod=0
+ trnqsmod=0                tempmod=0                 tnom=25
+ toxe=toxn_18              toxm=toxn_18              dtox=2.15e-010
+ epsrox=3.9                wint=1e-008               lint=6.25e-009
+ ll=0                      wl=0                      lln=1
+ wln=1                     lw=0                      ww=0
+ lwn=1                     wwn=1                     lwl=0
+ wwl=0                     llc=0                     wlc=0
+ lwc=0                     wwc=0                     lwlc=0
+ wwlc=0                    xl=-5.5e-08+dxln_18       xw=0+dxwn_18
+ dlc=dlcn_18               dwc=0                     xpart=1
+ toxref=3e-009             dlcig=6.25e-009           vth0=0.352+dvthn_18
+ k1=0.5288                 k2=0.01585+dk2n_18        wk2=-7.163e-009
+ k3=-0.85                  k3b=0.9                   w0=0
+ dvt0=0                    dvt1=0                    dvt2=0
+ dvt0w=0                   dvt1w=0                   dvt2w=0
+ dsub=0.32                 minv=-0.3                 voffl=0
+ dvtp0=1.4e-006            dvtp1=0.06                lpe0=3.2e-008
+ lpeb=0                    xj=1.5e-007               ngate=4e+020
+ ndep=4.2e+017             nsd=1e+020                phin=0
+ cdsc=0                    cdscb=0                   cdscd=0
+ cit=0.000102              wcit=1.3224e-010          voff=-0.12286
+ wvoff=-9.4772e-009        nfactor=1.4               eta0=0.0148
+ weta0=-2.204e-009         etab=-0.05                u0=0.03822
+ wu0=2.4244e-009           ua=3.628618e-011          wua=1.7872324e-016
+ ub=1.6944577e-018         wub=2.3921114e-026        uc=1.805e-010
+ wuc=5.51e-018             vsat=99000                a0=1.2691052
+ wa0=-9.640296e-009        ags=0.51789468            wags=1.375274e-008
+ a1=0                      a2=0.8                    b0=0
+ b1=0                      keta=-0.061               dwg=0
+ dwb=0                     pclm=0.2                  pdiblc1=0
+ pdiblc2=0.000185          wpdiblc2=3.857e-010       pdiblcb=0
+ drout=0.56                pvag=0.8                  delta=0.012
+ pscbe1=7.506e+008         pscbe2=1e-020             fprout=0
+ pdits=0                   pditsd=0                  pditsl=0
+ rsh=10.5                  rdsw=150+drdswn_18        prwg=0
+ prwb=0                    wr=1                      alpha0=0
+ alpha1=2.2950             beta0=17.8                agidl=2.56e-012
+ bgidl=8.66e+008           cgidl=0.25                egidl=0.2624
+ aigbacc=0.01213           bigbacc=0.006537          cigbacc=0.2809
+ nigbacc=4.05              aigbinv=0.35              bigbinv=0.03
+ cigbinv=0.006             eigbinv=1.1               nigbinv=1
+ aigc=0.01                 bigc=0.00144              cigc=1.515e-005
+ aigsd=0.008379            bigsd=0.0002699           cigsd=3.925e-020
+ nigc=1                    poxedge=1                 pigcd=2.171
+ ntox=1                    xrcrg1=12                 xrcrg2=1
+ cgso=cgon_18              cgdo=cgon_18              cgbo=0
+ cgdl=cgln_18              cgsl=cgln_18              clc=1e-007
+ cle=0.6                   cf=cfn_18                 ckappas=0.6
+ ckappad=0.6               acde=0.4                  moin=5
+ noff=1.695                voffcv=-0.07              kt1=-0.245
+ kt1l=0                    kt2=-0.02                 ute=-2.0855
+ wute=4.959e-008           ua1=-4.0769e-010          wua1=3.296082e-016
+ ub1=-1.0459926e-018       wub1=-4.3732429e-025      uc1=-1.5e-010
+ prt=0                     at=220000                 jss=2.85e-07
+ jsd=2.85e-07              jsws=6.9e-13              jswd=6.9e-13
+ jswgs=6.9e-13             jswgd=6.9e-13             njs=1
+ njd=1                     ijthsfwd=0.01             ijthdfwd=0.01
+ ijthsrev=0.01             ijthdrev=0.01             bvs=10
+ bvd=10                    xjbvs=1                   xjbvd=1
+ pbs=0.613                 pbd=0.613                 cjs=cjn_18
+ cjd=cjn_18                mjs=0.279                 mjd=0.279
+ pbsws=0.613               pbswd=0.613               cjsws=cjswn_18
+ cjswd=cjswn_18            mjsws=0.01                mjswd=0.01
+ pbswgs=0.952              pbswgd=0.952              cjswgs=cjswgn_18
+ cjswgd=cjswgn_18          mjswgs=0.541              mjswgd=0.541
+ tpb=0.00133               tcj=0.000766              tpbsw=0.00133
+ tcjsw=0.0001              tpbswg=0.00133            tcjswg=0.00088
+ xtis=3                    xtid=3                    jtsswgs=1.000e-08
+ jtsswgd=1.000e-08         njtsswg=40.31             xtsswgs=0.4558
+ xtsswgd=0.4558            tnjtsswg=1                dmcg=1.255e-007
+ dmci=1.255e-007           dmdg=0                    dmcgt=0
+ dwj=0                     xgw=0                     xgl=0
+ rshg=1                    gbmin=1e-012              rbpb=50
+ rbpd=50                   rbps=50                   rbdb=50
+ rbsb=50                   ngcon=1                   lvth0=0+dlvthn_18
+ wvth0=0+dwvthn_18         saref=0.82e-6             sbref=0.82e-6
+ kvsat=0.40                wlod=0.15e-6              tku0=0.1
+ ku0=-7.0e-8               llodku0=1                 wlodku0=1
+ lku0=2.0e-7               wku0=0.2e-6               pku0=0.5e-13
+ kvth0=4e-9                stk2=0                    steta0=0
+ lkvth0=-4.68e-11          wkvth0=7e-7               pkvth0=0
+ llodvth=1                 wlodvth=1                 lodk2=1
+ lodeta0=1                 fnoimod=1                 noia=5.3e+41
+ noib=1.0e+20              noic=1.0e+7               em=1.00e+07
+ ef=0.92                   tnoimod=0                 ud=0
+ wpemod=wpeflag_18         kvth0we=4.5e-3            lkvth0we=0.0e-11
+ wkvth0we=0                pkvth0we=0                ku0we=-2e-4
+ lku0we=0                  wku0we=0                  pku0we=0
+ k2we=0.0                  wk2we=0                   web=0
+ wec=0                     scref=1e-6                lvsat=0+dlvsatn_18
+ lpclm=0+dlpclmn_18        lnfactor=0+dlnfactorn_18  minr=1e-3

     17: type=n
+ lmin=1.2e-006-dxln_18     lmax=1e-005-dxln_18       wmin=4e-07
+ wmax=6e-007-dxwn_18       version=4.5               binunit=2
+ paramchk=1                mobmod=0                  capmod=2
+ igcmod=0                  igbmod=0                  geomod=0
+ diomod=1                  rdsmod=0                  rbodymod=0
+ rgatemod=0                permod=1                  acnqsmod=0
+ trnqsmod=0                tempmod=0                 tnom=25
+ toxe=toxn_18              toxm=toxn_18              dtox=2.15e-010
+ epsrox=3.9                wint=1e-008               lint=6.25e-009
+ ll=0                      wl=0                      lln=1
+ wln=1                     lw=0                      ww=0
+ lwn=1                     wwn=1                     lwl=0
+ wwl=0                     llc=0                     wlc=0
+ lwc=0                     wwc=0                     lwlc=0
+ wwlc=0                    xl=-5.5e-08+dxln_18       xw=0+dxwn_18
+ dlc=dlcn_18               dwc=0                     xpart=1
+ toxref=3e-009             dlcig=6.25e-009           vth0=0.35251477+dvthn_18
+ lvth0=-5.1129801e-009+dlvthn_18                     k1=0.5288
+ k2=0.016210341+dk2n_18    lk2=-3.5790861e-009       wk2=-6.7375403e-009
+ pk2=-4.2258781e-015       k3=-0.85                  k3b=0.9
+ w0=0                      dvt0=0                    dvt1=0
+ dvt2=0                    dvt0w=0                   dvt1w=0
+ dvt2w=0                   dsub=0.32                 minv=-0.3
+ voffl=0                   dvtp0=1.4e-006            dvtp1=0.06
+ lpe0=3.2e-008             lpeb=0                    xj=1.5e-007
+ ngate=4e+020              ndep=4.2e+017             nsd=1e+020
+ phin=0                    cdsc=0                    cdscb=0
+ cdscd=0                   cit=2.027983e-005         lcit=8.1168559e-010
+ wcit=1.5351298e-010       pcit=-2.112939e-016       voff=-0.12396161
+ lvoff=1.0941777e-008      wvoff=-8.8531925e-009     pvoff=-6.1979545e-015
+ nfactor=1.4               eta0=0.0148               weta0=-2.204e-009
+ etab=-0.05                u0=0.03822                wu0=2.4244e-009
+ ua=4.1565988e-011         lua=-5.244169e-017        wua=1.8451959e-016
+ pua=-5.7572236e-023       ub=1.6687202e-018         lub=2.5563776e-025
+ wub=3.4466557e-026        pub=-1.0474261e-031       uc=1.758027e-010
+ luc=4.6655944e-017        wuc=1.0473696e-017        puc=-4.9301911e-023
+ vsat=99000                a0=1.2643919              la0=4.6814484e-008
+ wa0=8.4933194e-009        pa0=-1.8011214e-013       ags=0.46793705
+ lags=4.9620417e-007       wags=2.1657709e-008       pags=-7.851611e-014
+ a1=0                      a2=0.8                    b0=0
+ b1=0                      keta=-0.059584375         lketa=-1.4060695e-008
+ dwg=0                     dwb=0                     pclm=0.17567699
+ lpclm=2.4158831e-007+dlpclmn_18                     wpclm=1.4181989e-009
+ ppclm=-1.408626e-014      pdiblc1=0                 pdiblc2=-0.00088637074
+ lpdiblc2=1.064139e-008    wpdiblc2=7.0479474e-010   ppdiblc2=-3.1694085e-015
+ pdiblcb=0                 drout=0.56                pvag=0.8
+ delta=0.012               pscbe1=7.506e+008         pscbe2=1e-020
+ fprout=0                  pdits=0                   pditsd=0
+ pditsl=0                  rsh=10.5                  rdsw=150+drdswn_18
+ prwg=0                    prwb=0                    wr=1
+ alpha0=0                  alpha1=2.2950             beta0=17.8
+ agidl=2.56e-012           bgidl=8.66e+008           cgidl=0.25
+ egidl=0.2624              aigbacc=0.01213           bigbacc=0.006537
+ cigbacc=0.2809            nigbacc=4.05              aigbinv=0.35
+ bigbinv=0.03              cigbinv=0.006             eigbinv=1.1
+ nigbinv=1                 aigc=0.01                 bigc=0.00144
+ cigc=1.515e-005           aigsd=0.008379            bigsd=0.0002699
+ cigsd=3.925e-020          nigc=1                    poxedge=1
+ pigcd=2.171               ntox=1                    xrcrg1=12
+ xrcrg2=1                  cgso=cgon_18              cgdo=cgon_18
+ cgbo=0                    cgdl=cgln_18              cgsl=cgln_18
+ clc=1e-007                cle=0.6                   cf=cfn_18
+ ckappas=0.6               ckappad=0.6               acde=0.4
+ moin=5                    noff=1.695                voffcv=-0.07
+ kt1=-0.24331283           lkt1=-1.6757792e-008      wkt1=1.5032908e-009
+ pkt1=-1.4931436e-014      kt1l=0                    kt2=-0.02
+ ute=-2.1743112            lute=8.8211689e-007       wute=8.2066754e-008
+ pute=-3.2257536e-013      ua1=-7.8539278e-010       lua1=3.7515328e-015
+ wua1=4.7101823e-016       pua1=-1.4045551e-021      ub1=-7.5129584e-019
+ lub1=-2.9270755e-024      wub1=-5.3174031e-025      pub1=9.3778714e-031
+ uc1=-1.3391335e-010       luc1=-1.5978063e-016      prt=0
+ at=235829.26              lat=-0.15722414           jss=2.85e-07
+ jsd=2.85e-07              jsws=6.9e-13              jswd=6.9e-13
+ jswgs=6.9e-13             jswgd=6.9e-13             njs=1
+ njd=1                     ijthsfwd=0.01             ijthdfwd=0.01
+ ijthsrev=0.01             ijthdrev=0.01             bvs=10
+ bvd=10                    xjbvs=1                   xjbvd=1
+ pbs=0.613                 pbd=0.613                 cjs=cjn_18
+ cjd=cjn_18                mjs=0.279                 mjd=0.279
+ pbsws=0.613               pbswd=0.613               cjsws=cjswn_18
+ cjswd=cjswn_18            mjsws=0.01                mjswd=0.01
+ pbswgs=0.952              pbswgd=0.952              cjswgs=cjswgn_18
+ cjswgd=cjswgn_18          mjswgs=0.541              mjswgd=0.541
+ tpb=0.00133               tcj=0.000766              tpbsw=0.00133
+ tcjsw=0.0001              tpbswg=0.00133            tcjswg=0.00088
+ xtis=3                    xtid=3                    jtsswgs=1.000e-08
+ jtsswgd=1.000e-08         njtsswg=40.31             xtsswgs=0.4558
+ xtsswgd=0.4558            tnjtsswg=1                dmcg=1.255e-007
+ dmci=1.255e-007           dmdg=0                    dmcgt=0
+ dwj=0                     xgw=0                     xgl=0
+ rshg=1                    gbmin=1e-012              rbpb=50
+ rbpd=50                   rbps=50                   rbdb=50
+ rbsb=50                   ngcon=1                   saref=0.82e-6
+ sbref=0.82e-6             kvsat=0.40                wlod=0.15e-6
+ tku0=0.1                  ku0=-7.0e-8               llodku0=1
+ wlodku0=1                 lku0=2.0e-7               wku0=0.2e-6
+ pku0=0.5e-13              kvth0=4e-9                stk2=0
+ steta0=0                  lkvth0=-4.68e-11          wkvth0=7e-7
+ pkvth0=0                  llodvth=1                 wlodvth=1
+ lodk2=1                   lodeta0=1                 fnoimod=1
+ noia=5.3e+41              noib=1.0e+20              noic=1.0e+7
+ em=1.00e+07               ef=0.92                   tnoimod=0
+ ud=0                      wpemod=wpeflag_18         kvth0we=4.5e-3
+ lkvth0we=0.0e-11          wkvth0we=0                pkvth0we=0
+ ku0we=-2e-4               lku0we=0                  wku0we=0
+ pku0we=0                  k2we=0.0                  wk2we=0
+ web=0                     wec=0                     scref=1e-6
+ wvth0=0+dwvthn_18         lvsat=0+dlvsatn_18        lnfactor=0+dlnfactorn_18
+ minr=1e-3

     18: type=n
+ lmin=7e-007-dxln_18       lmax=1.2e-006-dxln_18     wmin=4e-07
+ wmax=6e-007-dxwn_18       version=4.5               binunit=2
+ paramchk=1                mobmod=0                  capmod=2
+ igcmod=0                  igbmod=0                  geomod=0
+ diomod=1                  rdsmod=0                  rbodymod=0
+ rgatemod=0                permod=1                  acnqsmod=0
+ trnqsmod=0                tempmod=0                 tnom=25
+ toxe=toxn_18              toxm=toxn_18              dtox=2.15e-010
+ epsrox=3.9                wint=1e-008               lint=6.25e-009
+ ll=0                      wl=0                      lln=1
+ wln=1                     lw=0                      ww=0
+ lwn=1                     wwn=1                     lwl=0
+ wwl=0                     llc=0                     wlc=0
+ lwc=0                     wwc=0                     lwlc=0
+ wwlc=0                    xl=-5.5e-08+dxln_18       xw=0+dxwn_18
+ dlc=dlcn_18               dwc=0                     xpart=1
+ toxref=3e-009             dlcig=6.25e-009           vth0=0.348+dvthn_18
+ k1=0.5288                 k2=0.04979825+dk2n_18     lk2=-4.1617393e-008
+ wk2=-2.3712285e-008       pk2=1.499802e-014         k3=-0.85
+ k3b=0.9                   w0=0                      dvt0=0
+ dvt1=0                    dvt2=0                    dvt0w=0
+ dvt1w=0                   dvt2w=0                   dsub=0.32
+ minv=-0.3                 voffl=0                   dvtp0=1.4e-006
+ dvtp1=0.06                lpe0=3.2e-008             lpeb=0
+ xj=1.5e-007               ngate=4e+020              ndep=4.2e+017
+ nsd=1e+020                phin=0                    cdsc=0
+ cdscb=0                   cdscd=0                   cit=0.00048906
+ lcit=2.8079205e-010       wcit=2.27012e-011         pcit=-6.3149559e-017
+ voff=-0.118348            lvoff=4.58436e-009        wvoff=-1.014391e-008
+ pvoff=-4.7362169e-015     nfactor=1.4               eta0=0.0148
+ weta0=-2.204e-009         etab=-0.05                u0=0.03822
+ wu0=2.4244e-009           ua=-4.7874091e-011        lua=4.88492e-017
+ wua=2.6339439e-016        pua=-1.4689795e-022       ub=2.3771027e-018
+ lub=-5.4660542e-025       wub=-3.2208553e-025       pub=2.9905263e-031
+ uc=3.375545e-010          luc=-1.3652797e-016       wuc=-8.463911e-017
+ puc=5.8413342e-023        vsat=99000                a0=2.0579033
+ la0=-8.5183709e-007       wa0=-3.648994e-007        pa0=2.4275511e-013
+ ags=0.99599958            lags=-1.0182664e-007      wags=-1.5231658e-007
+ pags=1.1850978e-013       a1=0                      a2=0.8
+ b0=0                      b1=0                      keta=-0.062386
+ lketa=-1.0887855e-008     wketa=-5.57612e-009       pketa=6.3149559e-015
+ dwg=0                     dwb=0                     pclm=0.514235
+ lpclm=-1.4182864e-007+dlpclmn_18                    wpclm=-2.49603e-008
+ ppclm=1.578739e-014       pdiblc1=0                 pdiblc2=0.0030452
+ lpdiblc2=6.188886e-009    wpdiblc2=-9.78576e-010    ppdiblc2=-1.2629912e-015
+ pdiblcb=0                 drout=0.56                pvag=0.8
+ delta=0.012               pscbe1=7.506e+008         pscbe2=1e-020
+ fprout=0                  pdits=0                   pditsd=0
+ pditsl=0                  rsh=10.5                  rdsw=150+drdswn_18
+ prwg=0                    prwb=0                    wr=1
+ alpha0=0                  alpha1=2.2950             beta0=17.8
+ agidl=2.56e-012           bgidl=8.66e+008           cgidl=0.25
+ egidl=0.2624              aigbacc=0.01213           bigbacc=0.006537
+ cigbacc=0.2809            nigbacc=4.05              aigbinv=0.35
+ bigbinv=0.03              cigbinv=0.006             eigbinv=1.1
+ nigbinv=1                 aigc=0.01                 bigc=0.00144
+ cigc=1.515e-005           aigsd=0.008379            bigsd=0.0002699
+ cigsd=3.925e-020          nigc=1                    poxedge=1
+ pigcd=2.171               ntox=1                    xrcrg1=12
+ xrcrg2=1                  cgso=cgon_18              cgdo=cgon_18
+ cgbo=0                    cgdl=cgln_18              cgsl=cgln_18
+ clc=1e-007                cle=0.6                   cf=cfn_18
+ ckappas=0.6               ckappad=0.6               acde=0.4
+ moin=5                    noff=1.695                voffcv=-0.07
+ kt1=-0.20382885           lkt1=-6.1473402e-008      wkt1=-2.3391052e-008
+ pkt1=1.3261407e-014       kt1l=0                    kt2=-0.02
+ ute=-0.3808194            lute=-1.1490125e-006      wute=-6.0926715e-007
+ pute=4.6036029e-013       ua1=6.4647048e-009        lua1=-4.4592027e-015
+ wua1=-2.3559338e-015      pua1=1.7969681e-021       ub1=-5.7006757e-018
+ lub1=2.6780972e-024       wub1=1.3560694e-024       pub1=-1.2001574e-030
+ uc1=-5.033325e-010        luc1=2.5858656e-016       wuc1=6.273135e-017
+ puc1=-7.1043254e-023      prt=0                     at=156455
+ lat=-0.067332788          jss=2.85e-07              jsd=2.85e-07
+ jsws=6.9e-13              jswd=6.9e-13              jswgs=6.9e-13
+ jswgd=6.9e-13             njs=1                     njd=1
+ ijthsfwd=0.01             ijthdfwd=0.01             ijthsrev=0.01
+ ijthdrev=0.01             bvs=10                    bvd=10
+ xjbvs=1                   xjbvd=1                   pbs=0.613
+ pbd=0.613                 cjs=cjn_18                cjd=cjn_18
+ mjs=0.279                 mjd=0.279                 pbsws=0.613
+ pbswd=0.613               cjsws=cjswn_18            cjswd=cjswn_18
+ mjsws=0.01                mjswd=0.01                pbswgs=0.952
+ pbswgd=0.952              cjswgs=cjswgn_18          cjswgd=cjswgn_18
+ mjswgs=0.541              mjswgd=0.541              tpb=0.00133
+ tcj=0.000766              tpbsw=0.00133             tcjsw=0.0001
+ tpbswg=0.00133            tcjswg=0.00088            xtis=3
+ xtid=3                    jtsswgs=1.000e-08         jtsswgd=1.000e-08
+ njtsswg=40.31             xtsswgs=0.4558            xtsswgd=0.4558
+ tnjtsswg=1                dmcg=1.255e-007           dmci=1.255e-007
+ dmdg=0                    dmcgt=0                   dwj=0
+ xgw=0                     xgl=0                     rshg=1
+ gbmin=1e-012              rbpb=50                   rbpd=50
+ rbps=50                   rbdb=50                   rbsb=50
+ ngcon=1                   lvth0=0+dlvthn_18         saref=0.82e-6
+ sbref=0.82e-6             kvsat=0.40                wlod=0.15e-6
+ tku0=0.1                  ku0=-7.0e-8               llodku0=1
+ wlodku0=1                 lku0=2.0e-7               wku0=0.2e-6
+ pku0=0.5e-13              kvth0=4e-9                stk2=0
+ steta0=0                  lkvth0=-4.68e-11          wkvth0=7e-7
+ pkvth0=0                  llodvth=1                 wlodvth=1
+ lodk2=1                   lodeta0=1                 fnoimod=1
+ noia=5.3e+41              noib=1.0e+20              noic=1.0e+7
+ em=1.00e+07               ef=0.92                   tnoimod=0
+ ud=0                      wpemod=wpeflag_18         kvth0we=4.5e-3
+ lkvth0we=0.0e-11          wkvth0we=0                pkvth0we=0
+ ku0we=-2e-4               lku0we=0                  wku0we=0
+ pku0we=0                  k2we=0.0                  wk2we=0
+ web=0                     wec=0                     scref=1e-6
+ wvth0=0+dwvthn_18         lvsat=0+dlvsatn_18        lnfactor=0+dlnfactorn_18
+ minr=1e-3

     19: type=n
+ lmin=4e-007-dxln_18       lmax=7e-007-dxln_18       wmin=4e-07
+ wmax=6e-007-dxwn_18       version=4.5               binunit=2
+ paramchk=1                mobmod=0                  capmod=2
+ igcmod=0                  igbmod=0                  geomod=0
+ diomod=1                  rdsmod=0                  rbodymod=0
+ rgatemod=0                permod=1                  acnqsmod=0
+ trnqsmod=0                tempmod=0                 tnom=25
+ toxe=toxn_18              toxm=toxn_18              dtox=2.15e-010
+ epsrox=3.9                wint=1e-008               lint=6.25e-009
+ ll=0                      wl=0                      lln=1
+ wln=1                     lw=0                      ww=0
+ lwn=1                     wwn=1                     lwl=0
+ wwl=0                     llc=0                     wlc=0
+ lwc=0                     wwc=0                     lwlc=0
+ wwlc=0                    xl=-5.5e-08+dxln_18       xw=0+dxwn_18
+ dlc=dlcn_18               dwc=0                     xpart=1
+ toxref=3e-009             dlcig=6.25e-009           vth0=0.35575833+dvthn_18
+ lvth0=-4.9071458e-009+dlvthn_18                     k1=0.5288
+ k2=-0.010547+dk2n_18      lk2=-3.4490225e-009       wk2=-9.7710667e-010
+ pk2=6.1801997e-016        k3=-0.85                  k3b=0.9
+ w0=0                      dvt0=0                    dvt1=0
+ dvt2=0                    dvt0w=0                   dvt1w=0
+ dvt2w=0                   dsub=0.32                 minv=-0.3
+ voffl=0                   dvtp0=1.4e-006            dvtp1=0.06
+ lpe0=3.2e-008             lpeb=0                    xj=1.5e-007
+ ngate=4e+020              ndep=4.2e+017             nsd=1e+020
+ phin=0                    cdsc=0                    cdscb=0
+ cdscd=0                   cit=0.00021590833         lcit=4.5356048e-010
+ wcit=8.1639833e-011       pcit=-1.0042824e-016      voff=-0.11320583
+ lvoff=1.3319396e-009      wvoff=-2.2517533e-008     pvoff=3.0900998e-015
+ nfactor=1.4               eta0=0.0148               weta0=-2.204e-009
+ etab=-0.05                u0=0.03822                wu0=2.4244e-009
+ ua=9.1610601e-010         lua=-5.6086821e-016       wua=-4.0278109e-016
+ pua=2.7445804e-022        ub=5.3145174e-019         lub=6.2076881e-025
+ wub=6.9152662e-025        pub=-3.4205706e-031       uc=8.5346667e-011
+ luc=2.2993483e-017        wuc=2.23706e-017          puc=-9.2702995e-024
+ vsat=99000                a0=0.53934008             la0=1.0865412e-007
+ wa0=3.6251811e-007        pa0=-2.1733646e-013       ags=0.10222336
+ lags=4.6348681e-007       wags=6.5514294e-007       pags=-3.9220837e-013
+ a1=0                      a2=0.8                    b0=0
+ b1=0                      keta=-0.10608917          lketa=1.6754398e-008
+ wketa=5.6293833e-009      pketa=-7.7252496e-016     dwg=0
+ dwb=0                     pclm=0.2235               lpclm=4.206125e-008+dlpclmn_18
+ pdiblc1=0                 pdiblc2=0.016698083       lpdiblc2=-2.4465627e-009
+ wpdiblc2=-7.9830717e-009  ppdiblc2=3.1673523e-015   pdiblcb=0.3325
+ lpdiblcb=-2.1030625e-007  drout=0.56                pvag=0.8
+ delta=0.012               pscbe1=7.506e+008         pscbe2=1e-020
+ fprout=0                  pdits=0                   pditsd=0
+ pditsl=0                  rsh=10.5                  rdsw=150+drdswn_18
+ prwg=0                    prwb=0                    wr=1
+ alpha0=0                  alpha1=2.2950             beta0=17.8
+ agidl=2.56e-012           bgidl=8.66e+008           cgidl=0.25
+ egidl=0.2624              aigbacc=0.01213           bigbacc=0.006537
+ cigbacc=0.2809            nigbacc=4.05              aigbinv=0.35
+ bigbinv=0.03              cigbinv=0.006             eigbinv=1.1
+ nigbinv=1                 aigc=0.01                 bigc=0.00144
+ cigc=1.515e-005           aigsd=0.008379            bigsd=0.0002699
+ cigsd=3.925e-020          nigc=1                    poxedge=1
+ pigcd=2.171               ntox=1                    xrcrg1=12
+ xrcrg2=1                  cgso=cgon_18              cgdo=cgon_18
+ cgbo=0                    cgdl=cgln_18              cgsl=cgln_18
+ clc=1e-007                cle=0.6                   cf=cfn_18
+ ckappas=0.6               ckappad=0.6               acde=0.4
+ moin=5                    noff=1.695                voffcv=-0.07
+ kt1=-0.31107148           lkt1=6.3575579e-009       wkt1=5.7710822e-009
+ pkt1=-5.1836425e-015      kt1l=0                    kt2=-0.02
+ ute=-3.3613895            lute=7.3619806e-007       wute=2.3851504e-007
+ pute=-7.5861951e-014      ua1=-5.190563e-009        lua1=2.9127542e-015
+ wua1=1.0227998e-015       pua1=-3.4008094e-022      ub1=1.5390151e-018
+ lub1=-1.9010073e-024      wub1=-1.1414782e-024      pub1=3.7954151e-031
+ uc1=-1.0820833e-011       luc1=-5.2927073e-017      wuc1=-1.0455225e-016
+ puc1=3.4763623e-023       prt=0                     at=83250
+ lat=-0.021030625          jss=2.85e-07              jsd=2.85e-07
+ jsws=6.9e-13              jswd=6.9e-13              jswgs=6.9e-13
+ jswgd=6.9e-13             njs=1                     njd=1
+ ijthsfwd=0.01             ijthdfwd=0.01             ijthsrev=0.01
+ ijthdrev=0.01             bvs=10                    bvd=10
+ xjbvs=1                   xjbvd=1                   pbs=0.613
+ pbd=0.613                 cjs=cjn_18                cjd=cjn_18
+ mjs=0.279                 mjd=0.279                 pbsws=0.613
+ pbswd=0.613               cjsws=cjswn_18            cjswd=cjswn_18
+ mjsws=0.01                mjswd=0.01                pbswgs=0.952
+ pbswgd=0.952              cjswgs=cjswgn_18          cjswgd=cjswgn_18
+ mjswgs=0.541              mjswgd=0.541              tpb=0.00133
+ tcj=0.000766              tpbsw=0.00133             tcjsw=0.0001
+ tpbswg=0.00133            tcjswg=0.00088            xtis=3
+ xtid=3                    jtsswgs=1.000e-08         jtsswgd=1.000e-08
+ njtsswg=40.31             xtsswgs=0.4558            xtsswgd=0.4558
+ tnjtsswg=1                dmcg=1.255e-007           dmci=1.255e-007
+ dmdg=0                    dmcgt=0                   dwj=0
+ xgw=0                     xgl=0                     rshg=1
+ gbmin=1e-012              rbpb=50                   rbpd=50
+ rbps=50                   rbdb=50                   rbsb=50
+ ngcon=1                   wvth0=0+dwvthn_18         lvsat=0+dlvsatn_18
+ saref=0.82e-6             sbref=0.82e-6             kvsat=0.40
+ wlod=0.15e-6              tku0=0.1                  ku0=-7.0e-8
+ llodku0=1                 wlodku0=1                 lku0=2.0e-7
+ wku0=0.2e-6               pku0=0.5e-13              kvth0=4e-9
+ stk2=0                    steta0=0                  lkvth0=-4.68e-11
+ wkvth0=7e-7               pkvth0=0                  llodvth=1
+ wlodvth=1                 lodk2=1                   lodeta0=1
+ fnoimod=1                 noia=5.3e+41              noib=1.0e+20
+ noic=1.0e+7               em=1.00e+07               ef=0.92
+ tnoimod=0                 ud=0                      wpemod=wpeflag_18
+ kvth0we=4.5e-3            lkvth0we=0.0e-11          wkvth0we=0
+ pkvth0we=0                ku0we=-2e-4               lku0we=0
+ wku0we=0                  pku0we=0                  k2we=0.0
+ wk2we=0                   web=0                     wec=0
+ scref=1e-6                lnfactor=0+dlnfactorn_18  minr=1e-3

     20: type=n
+ lmin=2e-07                lmax=4e-007-dxln_18       wmin=4e-07
+ wmax=6e-007-dxwn_18       version=4.5               binunit=2
+ paramchk=1                mobmod=0                  capmod=2
+ igcmod=0                  igbmod=0                  geomod=0
+ diomod=1                  rdsmod=0                  rbodymod=0
+ rgatemod=0                permod=1                  acnqsmod=0
+ trnqsmod=0                tempmod=0                 tnom=25
+ toxe=toxn_18              toxm=toxn_18              dtox=2.15e-010
+ epsrox=3.9                wint=1e-008               lint=6.25e-009
+ ll=0                      wl=0                      lln=1
+ wln=1                     lw=0                      ww=0
+ lwn=1                     wwn=1                     lwl=0
+ wwl=0                     llc=0                     wlc=0
+ lwc=0                     wwc=0                     lwlc=0
+ wwlc=0                    xl=-5.5e-08+dxln_18       xw=0+dxwn_18
+ dlc=dlcn_18               dwc=0                     xpart=1
+ toxref=3e-009             dlcig=6.25e-009           vth0=0.34275562+dvthn_18
+ lvth0=-5.8374531e-010+dlvthn_18                     wvth0=1.0951125e-009+dwvthn_18
+ pvth0=-3.6412491e-016     k1=0.5288                 k2=-0.00238325+dk2n_18
+ lk2=-6.1634694e-009       wk2=7.35585e-010          pk2=4.8549988e-017
+ k3=-0.85                  k3b=0.9                   w0=0
+ dvt0=0                    dvt1=0                    dvt2=0
+ dvt0w=0                   dvt1w=0                   dvt2w=0
+ dsub=0.32                 minv=-0.3                 voffl=0
+ dvtp0=1.4e-006            dvtp1=0.06                lpe0=3.2e-008
+ lpeb=0                    xj=1.5e-007               ngate=4e+020
+ ndep=4.2e+017             nsd=1e+020                phin=0
+ cdsc=0                    cdscb=0                   cdscd=0
+ cit=0.00190277            lcit=-1.0732103e-010      wcit=-3.430526e-010
+ pcit=4.0781989e-017       voff=-0.085380475         lvoff=-7.9199921e-009
+ wvoff=-1.5604044e-008     pvoff=7.913648e-016       nfactor=1.4
+ eta0=0.0148               weta0=-2.204e-009         etab=-0.05
+ u0=0.04143975             lu0=-1.0705669e-009       wu0=2.862445e-009
+ pu0=-1.4564996e-016       ua=-1.1190715e-009        lua=1.1582829e-016
+ wua=6.2266208e-016        pua=-6.6501814e-023       ub=3.1385188e-018
+ lub=-2.4608099e-025       wub=-5.6719149e-025       pub=7.6466716e-032
+ uc=2.0398875e-010         luc=-1.6455009e-017       wuc=-1.5000975e-017
+ puc=3.1557492e-024        vsat=99000                a0=1.3736735
+ la0=-1.6876174e-007       wa0=-4.8399592e-007       pa0=6.412946e-014
+ ags=7.5799578             lags=-2.0228599e-006      wags=-4.9251314e-006
+ pags=1.4632329e-012       a1=0                      a2=0.8
+ b0=0                      b1=0                      keta=-0.08650625
+ lketa=1.0243078e-008      wketa=6.956375e-009       pketa=-1.2137497e-015
+ dwg=0                     dwb=0                     pclm=0.224125
+ lpclm=4.1853438e-008+dlpclmn_18                     pdiblc1=0
+ pdiblc2=0.004226825       lpdiblc2=1.7001307e-009   wpdiblc2=3.3095815e-009
+ ppdiblc2=-5.8745485e-016  pdiblcb=-0.49875          lpdiblcb=6.6084375e-008
+ drout=0.56                pvag=0.8                  delta=0.012
+ pscbe1=7.506e+008         pscbe2=1e-020             fprout=0
+ pdits=0                   pditsd=0                  pditsl=0
+ rsh=10.5                  rdsw=150+drdswn_18        prwg=0
+ prwb=0                    wr=1                      alpha0=0
+ alpha1=2.2950             beta0=17.8                agidl=2.56e-012
+ bgidl=8.66e+008           cgidl=0.25                egidl=0.2624
+ aigbacc=0.01213           bigbacc=0.006537          cigbacc=0.2809
+ nigbacc=4.05              aigbinv=0.35              bigbinv=0.03
+ cigbinv=0.006             eigbinv=1.1               nigbinv=1
+ aigc=0.01                 bigc=0.00144              cigc=1.515e-005
+ aigsd=0.008379            bigsd=0.0002699           cigsd=3.925e-020
+ nigc=1                    poxedge=1                 pigcd=2.171
+ ntox=1                    xrcrg1=12                 xrcrg2=1
+ cgso=cgon_18              cgdo=cgon_18              cgbo=0
+ cgdl=cgln_18              cgsl=cgln_18              clc=1e-007
+ cle=0.6                   cf=cfn_18                 ckappas=0.6
+ ckappad=0.6               acde=0.4                  moin=5
+ noff=1.695                voffcv=-0.07              kt1=-0.25631314
+ lkt1=-1.1849589e-008      wkt1=-1.877684e-008       pkt1=2.9785417e-015
+ kt1l=0                    kt2=-0.02                 ute=-0.67485112
+ lute=-1.5707595e-007      wute=-1.3441507e-007      pute=4.8137313e-014
+ ua1=4.3962211e-009        lua1=-2.7485152e-016      wua1=-4.5388763e-016
+ pua1=1.5091764e-022       ub1=-3.9401644e-018       lub1=-7.9180095e-026
+ wub1=1.9967551e-025       pub1=-6.6392108e-032      uc1=-1.8325e-010
+ luc1=4.405625e-018        prt=0                     at=16687.5
+ lat=0.0011014063          jss=2.85e-07              jsd=2.85e-07
+ jsws=6.9e-13              jswd=6.9e-13              jswgs=6.9e-13
+ jswgd=6.9e-13             njs=1                     njd=1
+ ijthsfwd=0.01             ijthdfwd=0.01             ijthsrev=0.01
+ ijthdrev=0.01             bvs=10                    bvd=10
+ xjbvs=1                   xjbvd=1                   pbs=0.613
+ pbd=0.613                 cjs=cjn_18                cjd=cjn_18
+ mjs=0.279                 mjd=0.279                 pbsws=0.613
+ pbswd=0.613               cjsws=cjswn_18            cjswd=cjswn_18
+ mjsws=0.01                mjswd=0.01                pbswgs=0.952
+ pbswgd=0.952              cjswgs=cjswgn_18          cjswgd=cjswgn_18
+ mjswgs=0.541              mjswgd=0.541              tpb=0.00133
+ tcj=0.000766              tpbsw=0.00133             tcjsw=0.0001
+ tpbswg=0.00133            tcjswg=0.00088            xtis=3
+ xtid=3                    jtsswgs=1.000e-08         jtsswgd=1.000e-08
+ njtsswg=40.31             xtsswgs=0.4558            xtsswgd=0.4558
+ tnjtsswg=1                dmcg=1.255e-007           dmci=1.255e-007
+ dmdg=0                    dmcgt=0                   dwj=0
+ xgw=0                     xgl=0                     rshg=1
+ gbmin=1e-012              rbpb=50                   rbpd=50
+ rbps=50                   rbdb=50                   rbsb=50
+ ngcon=1                   lvsat=0+dlvsatn_18        saref=0.82e-6
+ sbref=0.82e-6             kvsat=0.40                wlod=0.15e-6
+ tku0=0.1                  ku0=-7.0e-8               llodku0=1
+ wlodku0=1                 lku0=2.0e-7               wku0=0.2e-6
+ pku0=0.5e-13              kvth0=4e-9                stk2=0
+ steta0=0                  lkvth0=-4.68e-11          wkvth0=7e-7
+ pkvth0=0                  llodvth=1                 wlodvth=1
+ lodk2=1                   lodeta0=1                 fnoimod=1
+ noia=5.3e+41              noib=1.0e+20              noic=1.0e+7
+ em=1.00e+07               ef=0.92                   tnoimod=0
+ ud=0                      wpemod=wpeflag_18         kvth0we=4.5e-3
+ lkvth0we=0.0e-11          wkvth0we=0                pkvth0we=0
+ ku0we=-2e-4               lku0we=0                  wku0we=0
+ pku0we=0                  k2we=0.0                  wk2we=0
+ web=0                     wec=0                     scref=1e-6
+ lnfactor=0+dlnfactorn_18  minr=1e-3

//  ********************************************************************************************
//
//                *
//                                    1.8V PMOS DEVICE MODELS
//                  *
//
//                *
//  ********************************************************************************************

     }
model pch_18 bsim4  {
     1: type=p
+ lmin=1e-005-dxlp_18       lmax=0.0009001            wmin=1e-005-dxwp_18
+ wmax=0.0009001            version=4.5               binunit=2
+ paramchk=1                mobmod=0                  capmod=2
+ igcmod=0                  igbmod=0                  geomod=0
+ diomod=1                  rdsmod=0                  rbodymod=0
+ rgatemod=0                permod=1                  acnqsmod=0
+ trnqsmod=0                tempmod=0                 tnom=25
+ toxe=toxp_18              toxm=toxp_18              dtox=3.312e-010
+ epsrox=3.9                wint=1e-008               lint=6.36e-009
+ ll=0                      wl=0                      lln=1
+ wln=1                     lw=0                      ww=0
+ lwn=1                     wwn=1                     lwl=0
+ wwl=0                     llc=0                     wlc=0
+ lwc=0                     wwc=0                     lwlc=0
+ wwlc=0                    xl=-5.5e-08+dxlp_18       xw=0+dxwp_18
+ dlc=dlcp_18               dwc=0                     xpart=1
+ toxref=3e-009             dlcig=6.95e-008           vth0=-0.402+dvthp_18
+ k1=0.47                   k2=-0.0377+dk2p_18        k3=-2.181735
+ k3b=1.642093              w0=0                      dvt0=0.02355
+ dvt1=0.04408725           dvt2=0.3556108            dvt0w=0
+ dvt1w=0                   dvt2w=0                   dsub=0.0468373
+ minv=-0.3                 voffl=0                   dvtp0=0
+ dvtp1=0                   lpe0=9.321426e-008        lpeb=1.240401e-007
+ xj=1.8e-007               ngate=2.68e+020           ndep=8.4e+017
+ nsd=1e+020                phin=0                    cdsc=0
+ cdscb=0                   cdscd=0                   cit=0.00024
+ voff=-0.115               nfactor=0.691             eta0=0.00191
+ etab=-0.0011              u0=0.01276511             ua=1.183717e-009
+ ub=1.091966e-018          uc=-1e-012                vsat=70000
+ a0=1.441297               ags=0.521892              a1=0
+ a2=0.99                   b0=0                      b1=0
+ keta=-0.04597             dwg=0                     dwb=0
+ pclm=0.71                 pdiblc1=0                 pdiblc2=0.0025934
+ pdiblcb=0                 drout=0                   pvag=0
+ delta=0.007               pscbe1=8.564e+008         pscbe2=1e-020
+ fprout=0                  pdits=0                   pditsd=0
+ pditsl=0                  rsh=9.68                  rdsw=456.4
+ prwg=0                    prwb=0                    wr=1
+ alpha0=0                  alpha1=0.09               beta0=17
+ agidl=1.56e-012           bgidl=8.66e+008           cgidl=0.25
+ egidl=0.2624              aigbacc=0.01213           bigbacc=0.006537
+ cigbacc=0.2809            nigbacc=4.05              aigbinv=0.35
+ bigbinv=0.03              cigbinv=0.006             eigbinv=1.1
+ nigbinv=1                 aigc=0.01                 bigc=0.00144
+ cigc=1.515e-005           aigsd=0.008379            bigsd=0.0002699
+ cigsd=3.925e-020          nigc=1                    poxedge=1
+ pigcd=2.171               ntox=1                    xrcrg1=12
+ xrcrg2=1                  cgso=cgop_18              cgdo=cgop_18
+ cgbo=0                    cgdl=cglp_18              cgsl=cglp_18
+ clc=1e-007                cle=0.6                   cf=cfp_18
+ ckappas=0.6               ckappad=0.6               acde=0.4
+ moin=5                    noff=1.9                  voffcv=-0.044
+ kt1=-0.199                kt1l=0                    kt2=-0.03
+ ute=-0.7496562            ua1=3.632596e-009         ub1=-3.896104e-018
+ uc1=-7.413638e-011        prt=0                     at=60325
+ jss=1.9e-07               jsd=1.9e-07               jsws=1e-12
+ jswd=1e-12                jswgs=1e-12               jswgd=1e-12
+ njs=1                     njd=1                     ijthsfwd=0.01
+ ijthdfwd=0.01             ijthsrev=0.01             ijthdrev=0.01
+ bvs=10                    bvd=10                    xjbvs=1
+ xjbvd=1                   pbs=0.752                 pbd=0.752
+ cjs=cjp_18                cjd=cjp_18                mjs=0.335
+ mjd=0.335                 pbsws=0.752               pbswd=0.752
+ cjsws=cjswp_18            cjswd=cjswp_18            mjsws=0.01
+ mjswd=0.01                pbswgs=0.952              pbswgd=0.952
+ cjswgs=cjswgp_18          cjswgd=cjswgp_18          mjswgs=0.68
+ mjswgd=0.68               tpb=0.00174               tcj=0.000859
+ tpbsw=0.00137             tcjsw=0.0001              tpbswg=0.00289
+ tcjswg=0.000931           xtis=3                    xtid=3
+ jtsswgs=1.000e-08         jtsswgd=1.000e-08         njtsswg=40.31
+ xtsswgs=0.4558            xtsswgd=0.4558            tnjtsswg=1
+ dmcg=1.255e-007           dmci=1.255e-007           dmdg=0
+ dmcgt=0                   dwj=0                     xgw=0
+ xgl=0                     rshg=1                    gbmin=1e-012
+ rbpb=50                   rbpd=50                   rbps=50
+ rbdb=50                   rbsb=50                   ngcon=1
+ lvth0=0+dlvthp_18         wvth0=0+dwvthp_18         lvsat=0+dlvsatp_18
+ lpclm=0+dlpclmp_18        saref=0.82e-6             sbref=0.82e-6
+ kvsat=-0.450              wlod=8e-7                 tku0=0.3
+ ku0=1.6e-7                llodku0=1                 wlodku0=1
+ lku0=7.43e-8              wku0=7.0e-7               pku0=0
+ kvth0=0                   stk2=0                    steta0=0
+ lkvth0=0                  wkvth0=0                  pkvth0=0
+ llodvth=1                 wlodvth=1                 lodk2=1
+ lodeta0=1                 fnoimod=1                 noia=2.0e+42
+ noib=2.2e+20              noic=5.0e+08              em=3.0e+07
+ ef=1.2e+00                tnoimod=0                 lintnoi=-2.0e-8
+ ud=0                      wpemod=wpeflag_18         kvth0we=-4.0e-3
+ lkvth0we=0.0e-11          wkvth0we=0                pkvth0we=0
+ ku0we=-0.8e-3             lku0we=0                  wku0we=0
+ pku0we=0                  k2we=0                    wk2we=0
+ web=0                     wec=0                     scref=1e-6
+ lnfactor=0+dlnfactorp_18  wnfactor=0+dwnfactorp_18  minr=1e-3

     2: type=p
+ lmin=1.2e-006-dxlp_18     lmax=1e-005-dxlp_18       wmin=1e-005-dxwp_18
+ wmax=0.0009001            version=4.5               binunit=2
+ paramchk=1                mobmod=0                  capmod=2
+ igcmod=0                  igbmod=0                  geomod=0
+ diomod=1                  rdsmod=0                  rbodymod=0
+ rgatemod=0                permod=1                  acnqsmod=0
+ trnqsmod=0                tempmod=0                 tnom=25
+ toxe=toxp_18              toxm=toxp_18              dtox=3.312e-010
+ epsrox=3.9                wint=1e-008               lint=6.36e-009
+ ll=0                      wl=0                      lln=1
+ wln=1                     lw=0                      ww=0
+ lwn=1                     wwn=1                     lwl=0
+ wwl=0                     llc=0                     wlc=0
+ lwc=0                     wwc=0                     lwlc=0
+ wwlc=0                    xl=-5.5e-08+dxlp_18       xw=0+dxwp_18
+ dlc=dlcp_18               dwc=0                     xpart=1
+ toxref=3e-009             dlcig=6.95e-008           vth0=-0.40251467+dvthp_18
+ lvth0=5.1118736e-009+dlvthp_18                      k1=0.47
+ k2=-0.037056659+dk2p_18   lk2=-6.389842e-009        k3=-2.181735
+ k3b=1.642093              w0=0                      dvt0=0.02355
+ dvt1=0.04408725           dvt2=0.3556108            dvt0w=0
+ dvt1w=0                   dvt2w=0                   dsub=0.0468373
+ minv=-0.3                 voffl=0                   dvtp0=0
+ dvtp1=0                   lpe0=9.321426e-008        lpeb=1.240401e-007
+ xj=1.8e-007               ngate=2.68e+020           ndep=8.4e+017
+ nsd=1e+020                phin=0                    cdsc=0
+ cdscb=0                   cdscd=0                   cit=0.00026624831
+ lcit=-2.6070556e-010      voff=-0.11615801          lvoff=1.1501716e-008
+ nfactor=0.691             eta0=0.00191              etab=-0.0011
+ u0=0.012771762            lu0=-6.6070967e-011       ua=1.2384032e-009
+ lua=-5.431583e-016        ub=1.0690587e-018         lub=2.2752183e-025
+ uc=-1e-012                vsat=70000                a0=1.4409815
+ la0=3.1335785e-009        ags=0.49497647            lags=2.6733259e-007
+ a1=0                      a2=0.99                   b0=0
+ b1=0                      keta=-0.041308756         lketa=-4.6296783e-008
+ dwg=0                     dwb=0                     pclm=0.71
+ pdiblc1=0                 pdiblc2=0.0022460474      lpdiblc2=3.4500035e-009
+ pdiblcb=0.0074627545      lpdiblcb=-7.4122168e-008  drout=0
+ pvag=0                    delta=0.007               pscbe1=8.564e+008
+ pscbe2=1e-020             fprout=0                  pdits=0
+ pditsd=0                  pditsl=0                  rsh=9.68
+ rdsw=456.4                prwg=0                    prwb=0
+ wr=1                      alpha0=0                  alpha1=0.09
+ beta0=17                  agidl=1.56e-012           bgidl=8.66e+008
+ cgidl=0.25                egidl=0.2624              aigbacc=0.01213
+ bigbacc=0.006537          cigbacc=0.2809            nigbacc=4.05
+ aigbinv=0.35              bigbinv=0.03              cigbinv=0.006
+ eigbinv=1.1               nigbinv=1                 aigc=0.01
+ bigc=0.00144              cigc=1.515e-005           aigsd=0.008379
+ bigsd=0.0002699           cigsd=3.925e-020          nigc=1
+ poxedge=1                 pigcd=2.171               ntox=1
+ xrcrg1=12                 xrcrg2=1                  cgso=cgop_18
+ cgdo=cgop_18              cgbo=0                    cgdl=cglp_18
+ cgsl=cglp_18              clc=1e-007                cle=0.6
+ cf=cfp_18                 ckappas=0.6               ckappad=0.6
+ acde=0.4                  moin=5                    noff=1.9
+ voffcv=-0.044             kt1=-0.19979577           lkt1=7.9038512e-009
+ kt1l=0                    kt2=-0.03                 ute=-0.76997287
+ lute=2.0179083e-007       ua1=3.6382266e-009        lua1=-5.5925176e-017
+ ub1=-3.9157595e-018       lub1=1.9522373e-025       uc1=-7.413638e-011
+ prt=0                     at=55287.641              lat=0.050032463
+ jss=1.9e-07               jsd=1.9e-07               jsws=1e-12
+ jswd=1e-12                jswgs=1e-12               jswgd=1e-12
+ njs=1                     njd=1                     ijthsfwd=0.01
+ ijthdfwd=0.01             ijthsrev=0.01             ijthdrev=0.01
+ bvs=10                    bvd=10                    xjbvs=1
+ xjbvd=1                   pbs=0.752                 pbd=0.752
+ cjs=cjp_18                cjd=cjp_18                mjs=0.335
+ mjd=0.335                 pbsws=0.752               pbswd=0.752
+ cjsws=cjswp_18            cjswd=cjswp_18            mjsws=0.01
+ mjswd=0.01                pbswgs=0.952              pbswgd=0.952
+ cjswgs=cjswgp_18          cjswgd=cjswgp_18          mjswgs=0.68
+ mjswgd=0.68               tpb=0.00174               tcj=0.000859
+ tpbsw=0.00137             tcjsw=0.0001              tpbswg=0.00289
+ tcjswg=0.000931           xtis=3                    xtid=3
+ jtsswgs=1.000e-08         jtsswgd=1.000e-08         njtsswg=40.31
+ xtsswgs=0.4558            xtsswgd=0.4558            tnjtsswg=1
+ dmcg=1.255e-007           dmci=1.255e-007           dmdg=0
+ dmcgt=0                   dwj=0                     xgw=0
+ xgl=0                     rshg=1                    gbmin=1e-012
+ rbpb=50                   rbpd=50                   rbps=50
+ rbdb=50                   rbsb=50                   ngcon=1
+ wvth0=0+dwvthp_18         lvsat=0+dlvsatp_18        lpclm=0+dlpclmp_18
+ lnfactor=0+dlnfactorp_18  saref=0.82e-6             sbref=0.82e-6
+ kvsat=-0.450              wlod=8e-7                 tku0=0.3
+ ku0=1.6e-7                llodku0=1                 wlodku0=1
+ lku0=7.43e-8              wku0=7.0e-7               pku0=0
+ kvth0=0                   stk2=0                    steta0=0
+ lkvth0=0                  wkvth0=0                  pkvth0=0
+ llodvth=1                 wlodvth=1                 lodk2=1
+ lodeta0=1                 fnoimod=1                 noia=2.0e+42
+ noib=2.2e+20              noic=5.0e+08              em=3.0e+07
+ ef=1.2e+00                tnoimod=0                 lintnoi=-2.0e-8
+ ud=0                      wpemod=wpeflag_18         kvth0we=-4.0e-3
+ lkvth0we=0.0e-11          wkvth0we=0                pkvth0we=0
+ ku0we=-0.8e-3             lku0we=0                  wku0we=0
+ pku0we=0                  k2we=0                    wk2we=0
+ web=0                     wec=0                     scref=1e-6
+ wnfactor=0+dwnfactorp_18  minr=1e-3

     3: type=p
+ lmin=7e-007-dxlp_18       lmax=1.2e-006-dxlp_18     wmin=1e-005-dxwp_18
+ wmax=0.0009001            version=4.5               binunit=2
+ paramchk=1                mobmod=0                  capmod=2
+ igcmod=0                  igbmod=0                  geomod=0
+ diomod=1                  rdsmod=0                  rbodymod=0
+ rgatemod=0                permod=1                  acnqsmod=0
+ trnqsmod=0                tempmod=0                 tnom=25
+ toxe=toxp_18              toxm=toxp_18              dtox=3.312e-010
+ epsrox=3.9                wint=1e-008               lint=6.36e-009
+ ll=0                      wl=0                      lln=1
+ wln=1                     lw=0                      ww=0
+ lwn=1                     wwn=1                     lwl=0
+ wwl=0                     llc=0                     wlc=0
+ lwc=0                     wwc=0                     lwlc=0
+ wwlc=0                    xl=-5.5e-08+dxlp_18       xw=0+dxwp_18
+ dlc=dlcp_18               dwc=0                     xpart=1
+ toxref=3e-009             dlcig=6.95e-008           vth0=-0.40179368+dvthp_18
+ lvth0=4.295508e-009+dlvthp_18                       k1=0.47
+ k2=-0.039348916+dk2p_18   lk2=-3.7943654e-009       k3=-2.181735
+ k3b=1.642093              w0=0                      dvt0=0.02355
+ dvt1=0.04408725           dvt2=0.3556108            dvt0w=0
+ dvt1w=0                   dvt2w=0                   dsub=0.0468373
+ minv=-0.3                 voffl=0                   dvtp0=0
+ dvtp1=0                   lpe0=9.321426e-008        lpeb=1.240401e-007
+ xj=1.8e-007               ngate=2.68e+020           ndep=8.4e+017
+ nsd=1e+020                phin=0                    cdsc=0
+ cdscb=0                   cdscd=0                   cit=-0.0010110557
+ lcit=1.1855602e-009       voff=-0.10979368          lvoff=4.295508e-009
+ nfactor=0.691             eta0=0.00191              etab=-0.0011
+ u0=0.012717722            lu0=-4.8825607e-012       ua=9.1474797e-010
+ lua=-1.7668999e-016       ub=1.3111513e-018         lub=-4.6594807e-026
+ uc=-1.4151424e-011        luc=1.4891094e-017        vsat=70000
+ a0=1.3201952              la0=1.3989754e-007        ags=0.49940199
+ lags=2.6232166e-007       a1=0                      a2=0.99
+ b0=0                      b1=0                      keta=-0.065018533
+ lketa=-1.9450676e-008     dwg=0                     dwb=0
+ pclm=0.71                 pdiblc1=0                 pdiblc2=0.00402844
+ lpdiblc2=1.431836e-009    pdiblcb=0.48070256        lpdiblcb=-6.0996213e-007
+ drout=0                   pvag=0                    delta=0.007
+ pscbe1=8.564e+008         pscbe2=1e-020             fprout=0
+ pdits=0                   pditsd=0                  pditsl=0
+ rsh=9.68                  rdsw=456.4                prwg=0
+ prwb=0                    wr=1                      alpha0=0
+ alpha1=0.09               beta0=17                  agidl=1.56e-012
+ bgidl=8.66e+008           cgidl=0.25                egidl=0.2624
+ aigbacc=0.01213           bigbacc=0.006537          cigbacc=0.2809
+ nigbacc=4.05              aigbinv=0.35              bigbinv=0.03
+ cigbinv=0.006             eigbinv=1.1               nigbinv=1
+ aigc=0.01                 bigc=0.00144              cigc=1.515e-005
+ aigsd=0.008379            bigsd=0.0002699           cigsd=3.925e-020
+ nigc=1                    poxedge=1                 pigcd=2.171
+ ntox=1                    xrcrg1=12                 xrcrg2=1
+ cgso=cgop_18              cgdo=cgop_18              cgbo=0
+ cgdl=cglp_18              cgsl=cglp_18              clc=1e-007
+ cle=0.6                   cf=cfp_18                 ckappas=0.6
+ ckappad=0.6               acde=0.4                  moin=5
+ noff=1.9                  voffcv=-0.044             kt1=-0.18271817
+ lkt1=-1.1432781e-008      kt1l=0                    kt2=-0.03
+ ute=-0.5917565            ua1=3.588835e-009         ub1=-3.743343e-018
+ uc1=-7.413638e-011        prt=0                     at=143832.88
+ lat=-0.050225542          jss=1.9e-07               jsd=1.9e-07
+ jsws=1e-12                jswd=1e-12                jswgs=1e-12
+ jswgd=1e-12               njs=1                     njd=1
+ ijthsfwd=0.01             ijthdfwd=0.01             ijthsrev=0.01
+ ijthdrev=0.01             bvs=10                    bvd=10
+ xjbvs=1                   xjbvd=1                   pbs=0.752
+ pbd=0.752                 cjs=cjp_18                cjd=cjp_18
+ mjs=0.335                 mjd=0.335                 pbsws=0.752
+ pbswd=0.752               cjsws=cjswp_18            cjswd=cjswp_18
+ mjsws=0.01                mjswd=0.01                pbswgs=0.952
+ pbswgd=0.952              cjswgs=cjswgp_18          cjswgd=cjswgp_18
+ mjswgs=0.68               mjswgd=0.68               tpb=0.00174
+ tcj=0.000859              tpbsw=0.00137             tcjsw=0.0001
+ tpbswg=0.00289            tcjswg=0.000931           xtis=3
+ xtid=3                    jtsswgs=1.000e-08         jtsswgd=1.000e-08
+ njtsswg=40.31             xtsswgs=0.4558            xtsswgd=0.4558
+ tnjtsswg=1                dmcg=1.255e-007           dmci=1.255e-007
+ dmdg=0                    dmcgt=0                   dwj=0
+ xgw=0                     xgl=0                     rshg=1
+ gbmin=1e-012              rbpb=50                   rbpd=50
+ rbps=50                   rbdb=50                   rbsb=50
+ ngcon=1                   wvth0=0+dwvthp_18         lvsat=0+dlvsatp_18
+ lpclm=0+dlpclmp_18        saref=0.82e-6             sbref=0.82e-6
+ kvsat=-0.450              wlod=8e-7                 tku0=0.3
+ ku0=1.6e-7                llodku0=1                 wlodku0=1
+ lku0=7.43e-8              wku0=7.0e-7               pku0=0
+ kvth0=0                   stk2=0                    steta0=0
+ lkvth0=0                  wkvth0=0                  pkvth0=0
+ llodvth=1                 wlodvth=1                 lodk2=1
+ lodeta0=1                 fnoimod=1                 noia=2.0e+42
+ noib=2.2e+20              noic=5.0e+08              em=3.0e+07
+ ef=1.2e+00                tnoimod=0                 lintnoi=-2.0e-8
+ ud=0                      wpemod=wpeflag_18         kvth0we=-4.0e-3
+ lkvth0we=0.0e-11          wkvth0we=0                pkvth0we=0
+ ku0we=-0.8e-3             lku0we=0                  wku0we=0
+ pku0we=0                  k2we=0                    wk2we=0
+ web=0                     wec=0                     scref=1e-6
+ lnfactor=0+dlnfactorp_18  wnfactor=0+dwnfactorp_18  minr=1e-3

     4: type=p
+ lmin=4e-007-dxlp_18       lmax=7e-007-dxlp_18       wmin=1e-005-dxwp_18
+ wmax=0.0009001            version=4.5               binunit=2
+ paramchk=1                mobmod=0                  capmod=2
+ igcmod=0                  igbmod=0                  geomod=0
+ diomod=1                  rdsmod=0                  rbodymod=0
+ rgatemod=0                permod=1                  acnqsmod=0
+ trnqsmod=0                tempmod=0                 tnom=25
+ toxe=toxp_18              toxm=toxp_18              dtox=3.312e-010
+ epsrox=3.9                wint=1e-008               lint=6.36e-009
+ ll=0                      wl=0                      lln=1
+ wln=1                     lw=0                      ww=0
+ lwn=1                     wwn=1                     lwl=0
+ wwl=0                     llc=0                     wlc=0
+ lwc=0                     wwc=0                     lwlc=0
+ wwlc=0                    xl=-5.5e-08+dxlp_18       xw=0+dxwp_18
+ dlc=dlcp_18               dwc=0                     xpart=1
+ toxref=3e-009             dlcig=6.95e-008           vth0=-0.4038608+dvthp_18
+ lvth0=5.6025066e-009+dlvthp_18                      k1=0.47
+ k2=-0.02912366+dk2p_18    lk2=-1.025959e-008        k3=-2.181735
+ k3b=1.642093              w0=0                      dvt0=0.02355
+ dvt1=0.04408725           dvt2=0.3556108            dvt0w=0
+ dvt1w=0                   dvt2w=0                   dsub=0.0468373
+ minv=-0.3                 voffl=0                   dvtp0=0
+ dvtp1=0                   lpe0=9.321426e-008        lpeb=1.240401e-007
+ xj=1.8e-007               ngate=2.68e+020           ndep=8.4e+017
+ nsd=1e+020                phin=0                    cdsc=0
+ cdscb=0                   cdscd=0                   cit=0.0012117864
+ lcit=-2.1989838e-010      voff=-0.099200932         lvoff=-2.4020747e-009
+ nfactor=0.691             eta0=0.00191              etab=-0.0011
+ u0=0.01271                ua=8.0045844e-010         lua=-1.0442701e-016
+ ub=1.2602513e-018         lub=-1.4411748e-026       uc=1.1165869e-011
+ luc=-1.1165235e-018       vsat=70000                a0=1.6128189
+ la0=-4.5122588e-008       ags=0.49953564            lags=2.6223716e-007
+ a1=0                      a2=0.99                   b0=0
+ b1=0                      keta=-0.091108647         lketa=-2.9544188e-009
+ dwg=0                     dwb=0                     pclm=0.71
+ pdiblc1=0                 pdiblc2=0.006293          pdiblcb=-0.81072871
+ lpdiblcb=2.0658403e-007   drout=0                   pvag=0
+ delta=0.007               pscbe1=8.564e+008         pscbe2=1e-020
+ fprout=0                  pdits=0                   pditsd=0
+ pditsl=0                  rsh=9.68                  rdsw=456.4
+ prwg=0                    prwb=0                    wr=1
+ alpha0=0                  alpha1=0.09               beta0=17
+ agidl=1.56e-012           bgidl=8.66e+008           cgidl=0.25
+ egidl=0.2624              aigbacc=0.01213           bigbacc=0.006537
+ cigbacc=0.2809            nigbacc=4.05              aigbinv=0.35
+ bigbinv=0.03              cigbinv=0.006             eigbinv=1.1
+ nigbinv=1                 aigc=0.01                 bigc=0.00144
+ cigc=1.515e-005           aigsd=0.008379            bigsd=0.0002699
+ cigsd=3.925e-020          nigc=1                    poxedge=1
+ pigcd=2.171               ntox=1                    xrcrg1=12
+ xrcrg2=1                  cgso=cgop_18              cgdo=cgop_18
+ cgbo=0                    cgdl=cglp_18              cgsl=cglp_18
+ clc=1e-007                cle=0.6                   cf=cfp_18
+ ckappas=0.6               ckappad=0.6               acde=0.4
+ moin=5                    noff=1.9                  voffcv=-0.044
+ kt1=-0.206338             lkt1=3.5015666e-009       kt1l=0
+ kt2=-0.03                 ute=-0.071803095          lute=-3.2875614e-007
+ ua1=6.3099324e-009        lua1=-1.7204955e-015      ub1=-5.6561294e-018
+ lub1=1.2094166e-024       uc1=-7.413638e-011        prt=0
+ at=110248.91              lat=-0.028991067          jss=1.9e-07
+ jsd=1.9e-07               jsws=1e-12                jswd=1e-12
+ jswgs=1e-12               jswgd=1e-12               njs=1
+ njd=1                     ijthsfwd=0.01             ijthdfwd=0.01
+ ijthsrev=0.01             ijthdrev=0.01             bvs=10
+ bvd=10                    xjbvs=1                   xjbvd=1
+ pbs=0.752                 pbd=0.752                 cjs=cjp_18
+ cjd=cjp_18                mjs=0.335                 mjd=0.335
+ pbsws=0.752               pbswd=0.752               cjsws=cjswp_18
+ cjswd=cjswp_18            mjsws=0.01                mjswd=0.01
+ pbswgs=0.952              pbswgd=0.952              cjswgs=cjswgp_18
+ cjswgd=cjswgp_18          mjswgs=0.68               mjswgd=0.68
+ tpb=0.00174               tcj=0.000859              tpbsw=0.00137
+ tcjsw=0.0001              tpbswg=0.00289            tcjswg=0.000931
+ xtis=3                    xtid=3                    jtsswgs=1.000e-08
+ jtsswgd=1.000e-08         njtsswg=40.31             xtsswgs=0.4558
+ xtsswgd=0.4558            tnjtsswg=1                dmcg=1.255e-007
+ dmci=1.255e-007           dmdg=0                    dmcgt=0
+ dwj=0                     xgw=0                     xgl=0
+ rshg=1                    gbmin=1e-012              rbpb=50
+ rbpd=50                   rbps=50                   rbdb=50
+ rbsb=50                   ngcon=1                   wvth0=0+dwvthp_18
+ lvsat=0+dlvsatp_18        saref=0.82e-6             sbref=0.82e-6
+ kvsat=-0.450              wlod=8e-7                 tku0=0.3
+ ku0=1.6e-7                llodku0=1                 wlodku0=1
+ lku0=7.43e-8              wku0=7.0e-7               pku0=0
+ kvth0=0                   stk2=0                    steta0=0
+ lkvth0=0                  wkvth0=0                  pkvth0=0
+ llodvth=1                 wlodvth=1                 lodk2=1
+ lodeta0=1                 fnoimod=1                 noia=2.0e+42
+ noib=2.2e+20              noic=5.0e+08              em=3.0e+07
+ ef=1.2e+00                tnoimod=0                 lintnoi=-2.0e-8
+ ud=0                      wpemod=wpeflag_18         kvth0we=-4.0e-3
+ lkvth0we=0.0e-11          wkvth0we=0                pkvth0we=0
+ ku0we=-0.8e-3             lku0we=0                  wku0we=0
+ pku0we=0                  k2we=0                    wk2we=0
+ web=0                     wec=0                     scref=1e-6
+ lpclm=0+dlpclmp_18        lnfactor=0+dlnfactorp_18  wnfactor=0+dwnfactorp_18
+ minr=1e-3

     5: type=p
+ lmin=2e-07                lmax=4e-007-dxlp_18       wmin=1e-005-dxwp_18
+ wmax=0.0009001            version=4.5               binunit=2
+ paramchk=1                mobmod=0                  capmod=2
+ igcmod=0                  igbmod=0                  geomod=0
+ diomod=1                  rdsmod=0                  rbodymod=0
+ rgatemod=0                permod=1                  acnqsmod=0
+ trnqsmod=0                tempmod=0                 tnom=25
+ toxe=toxp_18              toxm=toxp_18              dtox=3.312e-010
+ epsrox=3.9                wint=1e-008               lint=6.36e-009
+ ll=0                      wl=0                      lln=1
+ wln=1                     lw=0                      ww=0
+ lwn=1                     wwn=1                     lwl=0
+ wwl=0                     llc=0                     wlc=0
+ lwc=0                     wwc=0                     lwlc=0
+ wwlc=0                    xl=-5.5e-08+dxlp_18       xw=0+dxwp_18
+ dlc=dlcp_18               dwc=0                     xpart=1
+ toxref=3e-009             dlcig=6.95e-008           vth0=-0.3784018+dvthp_18
+ lvth0=-2.8570099e-009+dlvthp_18                     k1=0.47
+ k2=-0.03063384+dk2p_18    lk2=-9.7577876e-009       k3=-2.181735
+ k3b=1.642093              w0=0                      dvt0=0.02355
+ dvt1=0.04408725           dvt2=0.3556108            dvt0w=0
+ dvt1w=0                   dvt2w=0                   dsub=0.0468373
+ minv=-0.3                 voffl=0                   dvtp0=0
+ dvtp1=0                   lpe0=9.321426e-008        lpeb=1.240401e-007
+ xj=1.8e-007               ngate=2.68e+020           ndep=8.4e+017
+ nsd=1e+020                phin=0                    cdsc=0
+ cdscb=0                   cdscd=0                   cit=0.00055
+ voff=-0.084094522         lvoff=-7.4216326e-009     nfactor=0.691
+ eta0=0.00191              etab=-0.0011              u0=0.01271
+ ua=4.633027e-010          lua=7.6030967e-018        ub=1.3277158e-018
+ lub=-3.6828835e-026       uc=6.7016857e-012         luc=3.6683524e-019
+ vsat=70000                a0=1.196603               la0=9.3177642e-008
+ ags=0.6066663             lags=2.2663978e-007       a1=0
+ a2=0.99                   b0=0                      b1=0
+ keta=-0.10416682          lketa=1.3845509e-009      dwg=0
+ dwb=0                     pclm=0.85828588           lpclm=-4.9272432e-008+dlpclmp_18
+ pdiblc1=0                 pdiblc2=0.0082343413      lpdiblc2=-6.4506888e-010
+ pdiblcb=-0.31402454       lpdiblcb=4.1539166e-008   drout=0
+ pvag=0                    delta=0.007               pscbe1=8.564e+008
+ pscbe2=1e-020             fprout=0                  pdits=0
+ pditsd=0                  pditsl=0                  rsh=9.68
+ rdsw=456.4                prwg=0                    prwb=0
+ wr=1                      alpha0=0                  alpha1=0.09
+ beta0=17                  agidl=1.56e-012           bgidl=8.66e+008
+ cgidl=0.25                egidl=0.2624              aigbacc=0.01213
+ bigbacc=0.006537          cigbacc=0.2809            nigbacc=4.05
+ aigbinv=0.35              bigbinv=0.03              cigbinv=0.006
+ eigbinv=1.1               nigbinv=1                 aigc=0.01
+ bigc=0.00144              cigc=1.515e-005           aigsd=0.008379
+ bigsd=0.0002699           cigsd=3.925e-020          nigc=1
+ poxedge=1                 pigcd=2.171               ntox=1
+ xrcrg1=12                 xrcrg2=1                  cgso=cgop_18
+ cgdo=cgop_18              cgbo=0                    cgdl=cglp_18
+ cgsl=cglp_18              clc=1e-007                cle=0.6
+ cf=cfp_18                 ckappas=0.6               ckappad=0.6
+ acde=0.4                  moin=5                    noff=1.9
+ voffcv=-0.044             kt1=-0.19589921           lkt1=3.2965499e-011
+ kt1l=0                    kt2=-0.03                 ute=-1.0875204
+ lute=8.7464061e-009       ua1=9.0944618e-010        lua1=7.3978096e-017
+ ub1=-1.6551729e-018       lub1=-1.2002123e-025      uc1=-7.4136631e-011
+ luc1=8.3512597e-023       prt=0                     at=25645.6
+ lat=-0.00087907997        jss=1.9e-07               jsd=1.9e-07
+ jsws=1e-12                jswd=1e-12                jswgs=1e-12
+ jswgd=1e-12               njs=1                     njd=1
+ ijthsfwd=0.01             ijthdfwd=0.01             ijthsrev=0.01
+ ijthdrev=0.01             bvs=10                    bvd=10
+ xjbvs=1                   xjbvd=1                   pbs=0.752
+ pbd=0.752                 cjs=cjp_18                cjd=cjp_18
+ mjs=0.335                 mjd=0.335                 pbsws=0.752
+ pbswd=0.752               cjsws=cjswp_18            cjswd=cjswp_18
+ mjsws=0.01                mjswd=0.01                pbswgs=0.952
+ pbswgd=0.952              cjswgs=cjswgp_18          cjswgd=cjswgp_18
+ mjswgs=0.68               mjswgd=0.68               tpb=0.00174
+ tcj=0.000859              tpbsw=0.00137             tcjsw=0.0001
+ tpbswg=0.00289            tcjswg=0.000931           xtis=3
+ xtid=3                    jtsswgs=1.000e-08         jtsswgd=1.000e-08
+ njtsswg=40.31             xtsswgs=0.4558            xtsswgd=0.4558
+ tnjtsswg=1                dmcg=1.255e-007           dmci=1.255e-007
+ dmdg=0                    dmcgt=0                   dwj=0
+ xgw=0                     xgl=0                     rshg=1
+ gbmin=1e-012              rbpb=50                   rbpd=50
+ rbps=50                   rbdb=50                   rbsb=50
+ ngcon=1                   wvth0=0+dwvthp_18         lvsat=0+dlvsatp_18
+ saref=0.82e-6             sbref=0.82e-6             kvsat=-0.450
+ wlod=8e-7                 tku0=0.3                  ku0=1.6e-7
+ llodku0=1                 wlodku0=1                 lku0=7.43e-8
+ wku0=7.0e-7               pku0=0                    kvth0=0
+ stk2=0                    steta0=0                  lkvth0=0
+ wkvth0=0                  pkvth0=0                  llodvth=1
+ wlodvth=1                 lodk2=1                   lodeta0=1
+ fnoimod=1                 noia=2.0e+42              noib=2.2e+20
+ noic=5.0e+08              em=3.0e+07                ef=1.2e+00
+ tnoimod=0                 lintnoi=-2.0e-8           ud=0
+ wpemod=wpeflag_18         kvth0we=-4.0e-3           lkvth0we=0.0e-11
+ wkvth0we=0                pkvth0we=0                ku0we=-0.8e-3
+ lku0we=0                  wku0we=0                  pku0we=0
+ k2we=0                    wk2we=0                   web=0
+ wec=0                     scref=1e-6                lnfactor=0+dlnfactorp_18
+ wnfactor=0+dwnfactorp_18  minr=1e-3

     6: type=p
+ lmin=1e-005-dxlp_18       lmax=0.0009001            wmin=1e-006-dxwp_18
+ wmax=1e-005-dxwp_18       version=4.5               binunit=2
+ paramchk=1                mobmod=0                  capmod=2
+ igcmod=0                  igbmod=0                  geomod=0
+ diomod=1                  rdsmod=0                  rbodymod=0
+ rgatemod=0                permod=1                  acnqsmod=0
+ trnqsmod=0                tempmod=0                 tnom=25
+ toxe=toxp_18              toxm=toxp_18              dtox=3.312e-010
+ epsrox=3.9                wint=1e-008               lint=6.36e-009
+ ll=0                      wl=0                      lln=1
+ wln=1                     lw=0                      ww=0
+ lwn=1                     wwn=1                     lwl=0
+ wwl=0                     llc=0                     wlc=0
+ lwc=0                     wwc=0                     lwlc=0
+ wwlc=0                    xl=-5.5e-08+dxlp_18       xw=0+dxwp_18
+ dlc=dlcp_18               dwc=0                     xpart=1
+ toxref=3e-009             dlcig=6.95e-008           vth0=-0.40091111+dvthp_18
+ wvth0=-1.0867111e-008+dwvthp_18                     k1=0.47
+ k2=-0.037373333+dk2p_18   wk2=-3.2601333e-009       k3=-2.181735
+ k3b=1.642093              w0=0                      dvt0=0.02355
+ dvt1=0.04408725           dvt2=0.3556108            dvt0w=0
+ dvt1w=0                   dvt2w=0                   dsub=0.0468373
+ minv=-0.3                 voffl=0                   dvtp0=0
+ dvtp1=0                   lpe0=9.321426e-008        lpeb=1.240401e-007
+ xj=1.8e-007               ngate=2.68e+020           ndep=8.4e+017
+ nsd=1e+020                phin=0                    cdsc=0
+ cdscb=0                   cdscd=0                   cit=0.00019611778
+ wcit=4.3794458e-010       voff=-0.11206             wvoff=-2.93412e-008
+ nfactor=0.691             eta0=0.0019470222         weta0=-3.6948178e-010
+ etab=-0.0011              u0=0.01276511             ua=1.1401925e-009
+ wua=4.3437473e-016        ub=1.1167603e-018         wub=-2.4744711e-025
+ uc=-6.7333333e-013        wuc=-3.2601333e-018       vsat=70000
+ a0=1.461256               wa0=-1.9919089e-007       ags=0.5245493
+ wags=-2.6519881e-008      a1=0                      a2=0.99
+ b0=0                      b1=0                      keta=-0.046468541
+ wketa=4.9754416e-009      dwg=0                     dwb=0
+ pclm=0.71                 pdiblc1=0                 pdiblc2=0.0025977991
+ wpdiblc2=-4.3903129e-011  pdiblcb=0                 drout=0
+ pvag=0                    delta=0.007               pscbe1=8.564e+008
+ pscbe2=1e-020             fprout=0                  pdits=0
+ pditsd=0                  pditsl=0                  rsh=9.68
+ rdsw=456.4                prwg=0                    prwb=0
+ wr=1                      alpha0=0                  alpha1=0.09
+ beta0=17                  agidl=1.56e-012           bgidl=8.66e+008
+ cgidl=0.25                egidl=0.2624              aigbacc=0.01213
+ bigbacc=0.006537          cigbacc=0.2809            nigbacc=4.05
+ aigbinv=0.35              bigbinv=0.03              cigbinv=0.006
+ eigbinv=1.1               nigbinv=1                 aigc=0.01
+ bigc=0.00144              cigc=1.515e-005           aigsd=0.008379
+ bigsd=0.0002699           cigsd=3.925e-020          nigc=1
+ poxedge=1                 pigcd=2.171               ntox=1
+ xrcrg1=12                 xrcrg2=1                  cgso=cgop_18
+ cgdo=cgop_18              cgbo=0                    cgdl=cglp_18
+ cgsl=cglp_18              clc=1e-007                cle=0.6
+ cf=cfp_18                 ckappas=0.6               ckappad=0.6
+ acde=0.4                  moin=5                    noff=1.9
+ voffcv=-0.044             kt1=-0.19998              wkt1=9.7804e-009
+ kt1l=0                    kt2=-0.03                 ute=-0.7496562
+ ua1=3.632596e-009         ub1=-3.8743375e-018       wub1=-2.172292e-025
+ uc1=-7.413638e-011        prt=0                     at=62538.167
+ wat=-0.022087403          jss=1.9e-07               jsd=1.9e-07
+ jsws=1e-12                jswd=1e-12                jswgs=1e-12
+ jswgd=1e-12               njs=1                     njd=1
+ ijthsfwd=0.01             ijthdfwd=0.01             ijthsrev=0.01
+ ijthdrev=0.01             bvs=10                    bvd=10
+ xjbvs=1                   xjbvd=1                   pbs=0.752
+ pbd=0.752                 cjs=cjp_18                cjd=cjp_18
+ mjs=0.335                 mjd=0.335                 pbsws=0.752
+ pbswd=0.752               cjsws=cjswp_18            cjswd=cjswp_18
+ mjsws=0.01                mjswd=0.01                pbswgs=0.952
+ pbswgd=0.952              cjswgs=cjswgp_18          cjswgd=cjswgp_18
+ mjswgs=0.68               mjswgd=0.68               tpb=0.00174
+ tcj=0.000859              tpbsw=0.00137             tcjsw=0.0001
+ tpbswg=0.00289            tcjswg=0.000931           xtis=3
+ xtid=3                    jtsswgs=1.000e-08         jtsswgd=1.000e-08
+ njtsswg=40.31             xtsswgs=0.4558            xtsswgd=0.4558
+ tnjtsswg=1                dmcg=1.255e-007           dmci=1.255e-007
+ dmdg=0                    dmcgt=0                   dwj=0
+ xgw=0                     xgl=0                     rshg=1
+ gbmin=1e-012              rbpb=50                   rbpd=50
+ rbps=50                   rbdb=50                   rbsb=50
+ ngcon=1                   lvth0=0+dlvthp_18         lvsat=0+dlvsatp_18
+ lpclm=0+dlpclmp_18        saref=0.82e-6             sbref=0.82e-6
+ kvsat=-0.450              wlod=8e-7                 tku0=0.3
+ ku0=1.6e-7                llodku0=1                 wlodku0=1
+ lku0=7.43e-8              wku0=7.0e-7               pku0=0
+ kvth0=0                   stk2=0                    steta0=0
+ lkvth0=0                  wkvth0=0                  pkvth0=0
+ llodvth=1                 wlodvth=1                 lodk2=1
+ lodeta0=1                 fnoimod=1                 noia=2.0e+42
+ noib=2.2e+20              noic=5.0e+08              em=3.0e+07
+ ef=1.2e+00                tnoimod=0                 lintnoi=-2.0e-8
+ ud=0                      wpemod=wpeflag_18         kvth0we=-4.0e-3
+ lkvth0we=0.0e-11          wkvth0we=0                pkvth0we=0
+ ku0we=-0.8e-3             lku0we=0                  wku0we=0
+ pku0we=0                  k2we=0                    wk2we=0
+ web=0                     wec=0                     scref=1e-6
+ lnfactor=0+dlnfactorp_18  wnfactor=0+dwnfactorp_18  minr=1e-3

     7: type=p
+ lmin=1.2e-006-dxlp_18     lmax=1e-005-dxlp_18       wmin=1e-006-dxwp_18
+ wmax=1e-005-dxwp_18       version=4.5               binunit=2
+ paramchk=1                mobmod=0                  capmod=2
+ igcmod=0                  igbmod=0                  geomod=0
+ diomod=1                  rdsmod=0                  rbodymod=0
+ rgatemod=0                permod=1                  acnqsmod=0
+ trnqsmod=0                tempmod=0                 tnom=25
+ toxe=toxp_18              toxm=toxp_18              dtox=3.312e-010
+ epsrox=3.9                wint=1e-008               lint=6.36e-009
+ ll=0                      wl=0                      lln=1
+ wln=1                     lw=0                      ww=0
+ lwn=1                     wwn=1                     lwl=0
+ wwl=0                     llc=0                     wlc=0
+ lwc=0                     wwc=0                     lwlc=0
+ wwlc=0                    xl=-5.5e-08+dxlp_18       xw=0+dxwp_18
+ dlc=dlcp_18               dwc=0                     xpart=1
+ toxref=3e-009             dlcig=6.95e-008           vth0=-0.4013137+dvthp_18
+ lvth0=3.9986212e-009+dlvthp_18                      wvth0=-1.1985712e-008+dwvthp_18
+ pvth0=1.111026e-014       k1=0.47                   k2=-0.03665994+dk2p_18
+ lk2=-7.0856248e-009       wk2=-3.959259e-009        pk2=6.9439123e-015
+ k3=-2.181735              k3b=1.642093              w0=0
+ dvt0=0.02355              dvt1=0.04408725           dvt2=0.3556108
+ dvt0w=0                   dvt1w=0                   dvt2w=0
+ dsub=0.0468373            minv=-0.3                 voffl=0
+ dvtp0=0                   dvtp1=0                   lpe0=9.321426e-008
+ lpeb=1.240401e-007        xj=1.8e-007               ngate=2.68e+020
+ ndep=8.4e+017             nsd=1e+020                phin=0
+ cdsc=0                    cdscb=0                   cdscd=0
+ cit=0.0002189195          lcit=-2.2647304e-010      wcit=4.7234156e-010
+ pcit=-3.4164049e-016      voff=-0.11283973          lvoff=7.7444886e-009
+ wvoff=-3.3116479e-008     pvoff=3.7497127e-014      nfactor=0.691
+ eta0=0.0019470222         weta0=-3.6948178e-010     etab=-0.0011
+ u0=0.012771762            lu0=-6.6070967e-011       ua=1.1996279e-009
+ lua=-5.9032973e-016       wua=3.8697667e-016        pua=4.7077087e-022
+ ub=1.089646e-018          lub=2.6930646e-025        wub=-2.0546172e-025
+ pub=-4.1701066e-031       uc=-6.3130173e-013        luc=-4.1746968e-019
+ wuc=-3.6796088e-018       puc=4.1663474e-024        vsat=70000
+ a0=1.461851               la0=-5.9097888e-009       wa0=-2.082777e-007
+ pa0=9.0252806e-014        ags=0.49783613            lags=2.6532275e-007
+ wags=-2.8539375e-008      pags=2.0058185e-014       a1=0
+ a2=0.99                   b0=0                      b1=0
+ keta=-0.041724798         lketa=-4.7116187e-008     wketa=4.1521008e-009
+ pketa=8.1776511e-015      dwg=0                     dwb=0
+ pclm=0.71112084           lpclm=-1.1132525e-008+dlpclmp_18
+ wpclm=-1.1186011e-008     ppclm=1.111026e-013       pdiblc1=0
+ pdiblc2=0.0023100809      lpdiblc2=2.8576975e-009   wpdiblc2=-6.3905487e-010
+ ppdiblc2=5.9112137e-015   pdiblcb=0.0082753656      lpdiblcb=-8.2193248e-008
+ wpdiblcb=-8.1098583e-009  ppdiblcb=8.0549383e-014   drout=0
+ pvag=0                    delta=0.007               pscbe1=8.564e+008
+ pscbe2=1e-020             fprout=0                  pdits=0
+ pditsd=0                  pditsl=0                  rsh=9.68
+ rdsw=456.4                prwg=0                    prwb=0
+ wr=1                      alpha0=0                  alpha1=0.09
+ beta0=17                  agidl=1.56e-012           bgidl=8.66e+008
+ cgidl=0.25                egidl=0.2624              aigbacc=0.01213
+ bigbacc=0.006537          cigbacc=0.2809            nigbacc=4.05
+ aigbinv=0.35              bigbinv=0.03              cigbinv=0.006
+ eigbinv=1.1               nigbinv=1                 aigc=0.01
+ bigc=0.00144              cigc=1.515e-005           aigsd=0.008379
+ bigsd=0.0002699           cigsd=3.925e-020          nigc=1
+ poxedge=1                 pigcd=2.171               ntox=1
+ xrcrg1=12                 xrcrg2=1                  cgso=cgop_18
+ cgdo=cgop_18              cgbo=0                    cgdl=cglp_18
+ cgsl=cglp_18              clc=1e-007                cle=0.6
+ cf=cfp_18                 ckappas=0.6               ckappad=0.6
+ acde=0.4                  moin=5                    noff=1.9
+ voffcv=-0.044             kt1=-0.20094369           lkt1=9.5716008e-009
+ wkt1=1.1456162e-008       pkt1=-1.6644141e-014      kt1l=0
+ kt2=-0.03                 ute=-0.76997287           lute=2.0179083e-007
+ ua1=3.6382266e-009        lua1=-5.5925176e-017      ub1=-3.8911924e-018
+ lub1=1.6740689e-025       wub1=-2.4517969e-025      pub1=2.7761206e-031
+ uc1=-7.413638e-011        prt=0                     at=57729.599
+ lat=0.047760037           wat=-0.024370748          pat=2.2678818e-008
+ jss=1.9e-07               jsd=1.9e-07               jsws=1e-12
+ jswd=1e-12                jswgs=1e-12               jswgd=1e-12
+ njs=1                     njd=1                     ijthsfwd=0.01
+ ijthdfwd=0.01             ijthsrev=0.01             ijthdrev=0.01
+ bvs=10                    bvd=10                    xjbvs=1
+ xjbvd=1                   pbs=0.752                 pbd=0.752
+ cjs=cjp_18                cjd=cjp_18                mjs=0.335
+ mjd=0.335                 pbsws=0.752               pbswd=0.752
+ cjsws=cjswp_18            cjswd=cjswp_18            mjsws=0.01
+ mjswd=0.01                pbswgs=0.952              pbswgd=0.952
+ cjswgs=cjswgp_18          cjswgd=cjswgp_18          mjswgs=0.68
+ mjswgd=0.68               tpb=0.00174               tcj=0.000859
+ tpbsw=0.00137             tcjsw=0.0001              tpbswg=0.00289
+ tcjswg=0.000931           xtis=3                    xtid=3
+ jtsswgs=1.000e-08         jtsswgd=1.000e-08         njtsswg=40.31
+ xtsswgs=0.4558            xtsswgd=0.4558            tnjtsswg=1
+ dmcg=1.255e-007           dmci=1.255e-007           dmdg=0
+ dmcgt=0                   dwj=0                     xgw=0
+ xgl=0                     rshg=1                    gbmin=1e-012
+ rbpb=50                   rbpd=50                   rbps=50
+ rbdb=50                   rbsb=50                   ngcon=1
+ saref=0.82e-6             sbref=0.82e-6             kvsat=-0.450
+ wlod=8e-7                 tku0=0.3                  ku0=1.6e-7
+ llodku0=1                 wlodku0=1                 lku0=7.43e-8
+ wku0=7.0e-7               pku0=0                    kvth0=0
+ stk2=0                    steta0=0                  lkvth0=0
+ wkvth0=0                  pkvth0=0                  llodvth=1
+ wlodvth=1                 lodk2=1                   lodeta0=1
+ fnoimod=1                 noia=2.0e+42              noib=2.2e+20
+ noic=5.0e+08              em=3.0e+07                ef=1.2e+00
+ tnoimod=0                 lintnoi=-2.0e-8           ud=0
+ wpemod=wpeflag_18         kvth0we=-4.0e-3           lkvth0we=0.0e-11
+ wkvth0we=0                pkvth0we=0                ku0we=-0.8e-3
+ lku0we=0                  wku0we=0                  pku0we=0
+ k2we=0                    wk2we=0                   web=0
+ wec=0                     scref=1e-6                lvsat=0+dlvsatp_18
+ lnfactor=0+dlnfactorp_18  wnfactor=0+dwnfactorp_18  minr=1e-3

     8: type=p
+ lmin=7e-007-dxlp_18       lmax=1.2e-006-dxlp_18     wmin=1e-006-dxwp_18
+ wmax=1e-005-dxwp_18       version=4.5               binunit=2
+ paramchk=1                mobmod=0                  capmod=2
+ igcmod=0                  igbmod=0                  geomod=0
+ diomod=1                  rdsmod=0                  rbodymod=0
+ rgatemod=0                permod=1                  acnqsmod=0
+ trnqsmod=0                tempmod=0                 tnom=25
+ toxe=toxp_18              toxm=toxp_18              dtox=3.312e-010
+ epsrox=3.9                wint=1e-008               lint=6.36e-009
+ ll=0                      wl=0                      lln=1
+ wln=1                     lw=0                      ww=0
+ lwn=1                     wwn=1                     lwl=0
+ wwl=0                     llc=0                     wlc=0
+ lwc=0                     wwc=0                     lwlc=0
+ wwlc=0                    xl=-5.5e-08+dxlp_18       xw=0+dxwp_18
+ dlc=dlcp_18               dwc=0                     xpart=1
+ toxref=3e-009             dlcig=6.95e-008           vth0=-0.40198899+dvthp_18
+ lvth0=4.7632411e-009+dlvthp_18                      wvth0=1.949212e-009+dwvthp_18
+ pvth0=-4.6679763e-015     k1=0.47                   k2=-0.03930507+dk2p_18
+ lk2=-4.0905963e-009       wk2=-4.3757944e-010       pk2=2.956385e-015
+ k3=-2.181735              k3b=1.642093              w0=0
+ dvt0=0.02355              dvt1=0.04408725           dvt2=0.3556108
+ dvt0w=0                   dvt1w=0                   dvt2w=0
+ dsub=0.0468373            minv=-0.3                 voffl=0
+ dvtp0=0                   dvtp1=0                   lpe0=9.321426e-008
+ lpeb=1.240401e-007        xj=1.8e-007               ngate=2.68e+020
+ ndep=8.4e+017             nsd=1e+020                phin=0
+ cdsc=0                    cdscb=0                   cdscd=0
+ cit=-0.0010320067         lcit=1.1899257e-009       wcit=2.0909156e-010
+ pcit=-4.3567778e-017      voff=-0.10965598          lvoff=4.139597e-009
+ wvoff=-1.3742114e-009     pvoff=1.5559921e-015      nfactor=0.691
+ eta0=0.0019470222         weta0=-3.6948178e-010     etab=-0.0011
+ u0=0.012717722            lu0=-4.8825607e-012       ua=8.3613363e-010
+ lua=-1.7875238e-016       wua=7.8457108e-016        pua=2.0582663e-023
+ ub=1.3813436e-018         lub=-6.0976819e-026       wub=-7.0051871e-025
+ pub=1.4353248e-031        uc=-1.4978439e-011        luc=1.5827507e-017
+ wuc=8.2536071e-018        puc=-9.3453943e-024       vsat=70000
+ a0=1.3267217              la0=1.4709439e-007        wa0=-6.5135193e-008
+ pa0=-7.1824595e-014       ags=0.50447743            lags=2.5780294e-007
+ wags=-5.0652869e-008      pags=4.5096852e-014       a1=0
+ a2=0.99                   b0=0                      b1=0
+ keta=-0.066784017         lketa=-1.8742134e-008     wketa=1.7619533e-008
+ pketa=-7.0712527e-015     dwg=0                     dwb=0
+ pclm=0.69027317           lpclm=1.2472882e-008+dlpclmp_18
+ wpclm=1.968738e-007       ppclm=-1.2447937e-013     pdiblc1=0
+ pdiblc2=0.0032526624      lpdiblc2=1.7904314e-009   wpdiblc2=7.7422603e-009
+ ppdiblc2=-3.5787818e-015  pdiblcb=0.47218386        lpdiblcb=-6.0746756e-007
+ wpdiblcb=8.5016627e-008   ppdiblcb=-2.4895873e-014  drout=0
+ pvag=0                    delta=0.007               pscbe1=8.564e+008
+ pscbe2=1e-020             fprout=0                  pdits=0
+ pditsd=0                  pditsl=0                  rsh=9.68
+ rdsw=456.4                prwg=0                    prwb=0
+ wr=1                      alpha0=0                  alpha1=0.09
+ beta0=17                  agidl=1.56e-012           bgidl=8.66e+008
+ cgidl=0.25                egidl=0.2624              aigbacc=0.01213
+ bigbacc=0.006537          cigbacc=0.2809            nigbacc=4.05
+ aigbinv=0.35              bigbinv=0.03              cigbinv=0.006
+ eigbinv=1.1               nigbinv=1                 aigc=0.01
+ bigc=0.00144              cigc=1.515e-005           aigsd=0.008379
+ bigsd=0.0002699           cigsd=3.925e-020          nigc=1
+ poxedge=1                 pigcd=2.171               ntox=1
+ xrcrg1=12                 xrcrg2=1                  cgso=cgop_18
+ cgdo=cgop_18              cgbo=0                    cgdl=cglp_18
+ cgsl=cglp_18              clc=1e-007                cle=0.6
+ cf=cfp_18                 ckappas=0.6               ckappad=0.6
+ acde=0.4                  moin=5                    noff=1.9
+ voffcv=-0.044             kt1=-0.18198218           lkt1=-1.1898129e-008
+ wkt1=-7.3451154e-009      pkt1=4.6441696e-015       kt1l=0
+ kt2=-0.03                 ute=-0.63826571           lute=5.2661445e-008
+ wute=4.6416189e-007       pute=-5.2556122e-013      ua1=3.3038818e-009
+ lua1=3.2264681e-016       wua1=2.8438329e-015       pua1=-3.2200151e-021
+ ub1=-3.591613e-018        lub1=-1.7180086e-025      wub1=-1.5142655e-024
+ pub1=1.7145726e-030       uc1=-7.5293412e-011       luc1=1.3100845e-018
+ wuc1=1.1547182e-017       puc1=-1.3074644e-023      prt=0
+ at=148026.69              lat=-0.054481558          wat=-0.041854249
+ pat=4.2475036e-008        jss=1.9e-07               jsd=1.9e-07
+ jsws=1e-12                jswd=1e-12                jswgs=1e-12
+ jswgd=1e-12               njs=1                     njd=1
+ ijthsfwd=0.01             ijthdfwd=0.01             ijthsrev=0.01
+ ijthdrev=0.01             bvs=10                    bvd=10
+ xjbvs=1                   xjbvd=1                   pbs=0.752
+ pbd=0.752                 cjs=cjp_18                cjd=cjp_18
+ mjs=0.335                 mjd=0.335                 pbsws=0.752
+ pbswd=0.752               cjsws=cjswp_18            cjswd=cjswp_18
+ mjsws=0.01                mjswd=0.01                pbswgs=0.952
+ pbswgd=0.952              cjswgs=cjswgp_18          cjswgd=cjswgp_18
+ mjswgs=0.68               mjswgd=0.68               tpb=0.00174
+ tcj=0.000859              tpbsw=0.00137             tcjsw=0.0001
+ tpbswg=0.00289            tcjswg=0.000931           xtis=3
+ xtid=3                    jtsswgs=1.000e-08         jtsswgd=1.000e-08
+ njtsswg=40.31             xtsswgs=0.4558            xtsswgd=0.4558
+ tnjtsswg=1                dmcg=1.255e-007           dmci=1.255e-007
+ dmdg=0                    dmcgt=0                   dwj=0
+ xgw=0                     xgl=0                     rshg=1
+ gbmin=1e-012              rbpb=50                   rbpd=50
+ rbps=50                   rbdb=50                   rbsb=50
+ ngcon=1                   lvsat=0+dlvsatp_18        lnfactor=0+dlnfactorp_18
+ saref=0.82e-6             sbref=0.82e-6             kvsat=-0.450
+ wlod=8e-7                 tku0=0.3                  ku0=1.6e-7
+ llodku0=1                 wlodku0=1                 lku0=7.43e-8
+ wku0=7.0e-7               pku0=0                    kvth0=0
+ stk2=0                    steta0=0                  lkvth0=0
+ wkvth0=0                  pkvth0=0                  llodvth=1
+ wlodvth=1                 lodk2=1                   lodeta0=1
+ fnoimod=1                 noia=2.0e+42              noib=2.2e+20
+ noic=5.0e+08              em=3.0e+07                ef=1.2e+00
+ tnoimod=0                 lintnoi=-2.0e-8           ud=0
+ wpemod=wpeflag_18         kvth0we=-4.0e-3           lkvth0we=0.0e-11
+ wkvth0we=0                pkvth0we=0                ku0we=-0.8e-3
+ lku0we=0                  wku0we=0                  pku0we=0
+ k2we=0                    wk2we=0                   web=0
+ wec=0                     scref=1e-6                wnfactor=0+dwnfactorp_18
+ minr=1e-3

     9: type=p
+ lmin=4e-007-dxlp_18       lmax=7e-007-dxlp_18       wmin=1e-006-dxwp_18
+ wmax=1e-005-dxwp_18       version=4.5               binunit=2
+ paramchk=1                mobmod=0                  capmod=2
+ igcmod=0                  igbmod=0                  geomod=0
+ diomod=1                  rdsmod=0                  rbodymod=0
+ rgatemod=0                permod=1                  acnqsmod=0
+ trnqsmod=0                tempmod=0                 tnom=25
+ toxe=toxp_18              toxm=toxp_18              dtox=3.312e-010
+ epsrox=3.9                wint=1e-008               lint=6.36e-009
+ ll=0                      wl=0                      lln=1
+ wln=1                     lw=0                      ww=0
+ lwn=1                     wwn=1                     lwl=0
+ wwl=0                     llc=0                     wlc=0
+ lwc=0                     wwc=0                     lwlc=0
+ wwlc=0                    xl=-5.5e-08+dxlp_18       xw=0+dxwp_18
+ dlc=dlcp_18               dwc=0                     xpart=1
+ toxref=3e-009             dlcig=6.95e-008           vth0=-0.40522192+dvthp_18
+ lvth0=6.8073568e-009+dlvthp_18                      wvth0=1.3583976e-008+dwvthp_18
+ pvth0=-1.2024405e-014     k1=0.47                   k2=-0.030018687+dk2p_18
+ lk2=-9.9621905e-009       wk2=8.9323741e-009        pk2=-2.9680493e-015
+ k3=-2.181735              k3b=1.642093              w0=0
+ dvt0=0.02355              dvt1=0.04408725           dvt2=0.3556108
+ dvt0w=0                   dvt1w=0                   dvt2w=0
+ dsub=0.0468373            minv=-0.3                 voffl=0
+ dvtp0=0                   dvtp1=0                   lpe0=9.321426e-008
+ lpeb=1.240401e-007        xj=1.8e-007               ngate=2.68e+020
+ ndep=8.4e+017             nsd=1e+020                phin=0
+ cdsc=0                    cdscb=0                   cdscd=0
+ cit=0.0011818198          lcit=-2.0983255e-010      wcit=2.9906638e-010
+ pcit=-1.0045705e-016      voff=-0.10224897          lvoff=-5.4370771e-010
+ wvoff=3.0419448e-008      pvoff=-1.8546503e-014     nfactor=0.691
+ eta0=0.0019470222         weta0=-3.6948178e-010     etab=-0.0011
+ u0=0.01271                ua=7.176432e-010          lua=-1.0383326e-016
+ wua=8.2649608e-016        pua=-5.9256723e-024       ub=1.3260624e-018
+ lub=-2.6023638e-026       wub=-6.567947e-025        pub=1.1588666e-031
+ uc=7.8919713e-012         luc=1.3670038e-018        wuc=3.2673498e-017
+ puc=-2.4785603e-023       vsat=70000                a0=1.5965993
+ la0=-2.3543798e-008       wa0=1.6187141e-007        pa0=-2.1535633e-013
+ ags=0.53055462            lags=2.4131485e-007       wags=-3.0956945e-007
+ pags=2.0880463e-013       a1=0                      a2=0.99
+ b0=0                      b1=0                      keta=-0.092467774
+ lketa=-2.5028082e-009     wketa=1.3564085e-008      pketa=-4.5070741e-015
+ dwg=0                     dwb=0                     pclm=0.71
+ pdiblc1=0                 pdiblc2=0.0058532891      lpdiblc2=1.4610715e-010
+ wpdiblc2=4.3883151e-009   ppdiblc2=-1.4581493e-015  pdiblcb=-0.83881863
+ lpdiblcb=2.214531e-007    wpdiblcb=2.8033746e-007   ppdiblcb=-1.4839333e-013
+ drout=0                   pvag=0                    delta=0.007
+ pscbe1=8.564e+008         pscbe2=1e-020             fprout=0
+ pdits=0                   pditsd=0                  pditsl=0
+ rsh=9.68                  rdsw=456.4                prwg=0
+ prwb=0                    wr=1                      alpha0=0
+ alpha1=0.09               beta0=17                  agidl=1.56e-012
+ bgidl=8.66e+008           cgidl=0.25                egidl=0.2624
+ aigbacc=0.01213           bigbacc=0.006537          cigbacc=0.2809
+ nigbacc=4.05              aigbinv=0.35              bigbinv=0.03
+ cigbinv=0.006             eigbinv=1.1               nigbinv=1
+ aigc=0.01                 bigc=0.00144              cigc=1.515e-005
+ aigsd=0.008379            bigsd=0.0002699           cigsd=3.925e-020
+ nigc=1                    poxedge=1                 pigcd=2.171
+ ntox=1                    xrcrg1=12                 xrcrg2=1
+ cgso=cgop_18              cgdo=cgop_18              cgbo=0
+ cgdl=cglp_18              cgsl=cglp_18              clc=1e-007
+ cle=0.6                   cf=cfp_18                 ckappas=0.6
+ ckappad=0.6               acde=0.4                  moin=5
+ noff=1.9                  voffcv=-0.044             kt1=-0.20706163
+ lkt1=3.9591047e-009       wkt1=7.2218474e-009       pkt1=-4.5662296e-015
+ kt1l=0                    kt2=-0.03                 ute=0.01010337
+ lute=-3.5728936e-007      wute=-8.1742652e-007      pute=2.847615e-013
+ ua1=6.8286501e-009        lua1=-1.9059937e-015      wua1=-5.1768022e-015
+ pua1=1.851272e-021        ub1=-6.0216015e-018       lub1=1.3646323e-024
+ wub1=3.6474111e-024       pub1=-1.5490523e-030      uc1=-7.2207993e-011
+ luc1=-6.4076449e-019      wuc1=-1.9245304e-017      puc1=6.3948296e-024
+ prt=0                     at=106468.94              lat=-0.028205419
+ wat=0.037724103           pat=-7.8407643e-009       jss=1.9e-07
+ jsd=1.9e-07               jsws=1e-12                jswd=1e-12
+ jswgs=1e-12               jswgd=1e-12               njs=1
+ njd=1                     ijthsfwd=0.01             ijthdfwd=0.01
+ ijthsrev=0.01             ijthdrev=0.01             bvs=10
+ bvd=10                    xjbvs=1                   xjbvd=1
+ pbs=0.752                 pbd=0.752                 cjs=cjp_18
+ cjd=cjp_18                mjs=0.335                 mjd=0.335
+ pbsws=0.752               pbswd=0.752               cjsws=cjswp_18
+ cjswd=cjswp_18            mjsws=0.01                mjswd=0.01
+ pbswgs=0.952              pbswgd=0.952              cjswgs=cjswgp_18
+ cjswgd=cjswgp_18          mjswgs=0.68               mjswgd=0.68
+ tpb=0.00174               tcj=0.000859              tpbsw=0.00137
+ tcjsw=0.0001              tpbswg=0.00289            tcjswg=0.000931
+ xtis=3                    xtid=3                    jtsswgs=1.000e-08
+ jtsswgd=1.000e-08         njtsswg=40.31             xtsswgs=0.4558
+ xtsswgd=0.4558            tnjtsswg=1                dmcg=1.255e-007
+ dmci=1.255e-007           dmdg=0                    dmcgt=0
+ dwj=0                     xgw=0                     xgl=0
+ rshg=1                    gbmin=1e-012              rbpb=50
+ rbpd=50                   rbps=50                   rbdb=50
+ rbsb=50                   ngcon=1                   lvsat=0+dlvsatp_18
+ saref=0.82e-6             sbref=0.82e-6             kvsat=-0.450
+ wlod=8e-7                 tku0=0.3                  ku0=1.6e-7
+ llodku0=1                 wlodku0=1                 lku0=7.43e-8
+ wku0=7.0e-7               pku0=0                    kvth0=0
+ stk2=0                    steta0=0                  lkvth0=0
+ wkvth0=0                  pkvth0=0                  llodvth=1
+ wlodvth=1                 lodk2=1                   lodeta0=1
+ fnoimod=1                 noia=2.0e+42              noib=2.2e+20
+ noic=5.0e+08              em=3.0e+07                ef=1.2e+00
+ tnoimod=0                 lintnoi=-2.0e-8           ud=0
+ wpemod=wpeflag_18         kvth0we=-4.0e-3           lkvth0we=0.0e-11
+ wkvth0we=0                pkvth0we=0                ku0we=-0.8e-3
+ lku0we=0                  wku0we=0                  pku0we=0
+ k2we=0                    wk2we=0                   web=0
+ wec=0                     scref=1e-6                lpclm=0+dlpclmp_18
+ lnfactor=0+dlnfactorp_18  wnfactor=0+dwnfactorp_18  minr=1e-3

     10: type=p
+ lmin=2e-07                lmax=4e-007-dxlp_18       wmin=1e-006-dxwp_18
+ wmax=1e-005-dxwp_18       version=4.5               binunit=2
+ paramchk=1                mobmod=0                  capmod=2
+ igcmod=0                  igbmod=0                  geomod=0
+ diomod=1                  rdsmod=0                  rbodymod=0
+ rgatemod=0                permod=1                  acnqsmod=0
+ trnqsmod=0                tempmod=0                 tnom=25
+ toxe=toxp_18              toxm=toxp_18              dtox=3.312e-010
+ epsrox=3.9                wint=1e-008               lint=6.36e-009
+ ll=0                      wl=0                      lln=1
+ wln=1                     lw=0                      ww=0
+ lwn=1                     wwn=1                     lwl=0
+ wwl=0                     llc=0                     wlc=0
+ lwc=0                     wwc=0                     lwlc=0
+ wwlc=0                    xl=-5.5e-08+dxlp_18       xw=0+dxwp_18
+ dlc=dlcp_18               dwc=0                     xpart=1
+ toxref=3e-009             dlcig=6.95e-008           vth0=-0.37622333+dvthp_18
+ lvth0=-2.8282933e-009+dlvthp_18                     wvth0=-2.174109e-008+dwvthp_18
+ pvth0=-2.8659179e-016     k1=0.47                   k2=-0.030415795+dk2p_18
+ lk2=-9.8302397e-009       wk2=-2.1760897e-009       pk2=7.2307109e-016
+ k3=-2.181735              k3b=1.642093              w0=0
+ dvt0=0.02355              dvt1=0.04408725           dvt2=0.3556108
+ dvt0w=0                   dvt1w=0                   dvt2w=0
+ dsub=0.0468373            minv=-0.3                 voffl=0
+ dvtp0=0                   dvtp1=0                   lpe0=9.321426e-008
+ lpeb=1.240401e-007        xj=1.8e-007               ngate=2.68e+020
+ ndep=8.4e+017             nsd=1e+020                phin=0
+ cdsc=0                    cdscb=0                   cdscd=0
+ cit=0.00059879553         lcit=-1.6105233e-011      wcit=-4.8697937e-010
+ pcit=1.6073023e-016       voff=-0.079866702         lvoff=-7.9808887e-009
+ wvoff=-4.2193643e-008     pvoff=5.5813751e-015      nfactor=0.691
+ eta0=0.0019470222         weta0=-3.6948178e-010     etab=-0.0011
+ u0=0.01271                ua=3.9534457e-010         lua=3.2601327e-018
+ wua=6.7822217e-016        pua=4.3342781e-023        ub=1.3624809e-018
+ lub=-3.8124769e-026       wub=-3.4695587e-025       pub=1.2933415e-032
+ uc=1.1513718e-011         luc=1.6356991e-019        wuc=-4.8024078e-017
+ puc=2.0285879e-024        vsat=70000                a0=1.2563473
+ la0=8.9515149e-008        wa0=-5.9624827e-007       pa0=3.6551678e-014
+ ags=0.66072929            lags=1.9806041e-007       wags=-5.3954867e-007
+ pags=2.8522212e-013       a1=0                      a2=0.99
+ b0=0                      b1=0                      keta=-0.10462054
+ lketa=1.5353132e-009      wketa=4.5281296e-009      pketa=-1.5046069e-015
+ dwg=0                     dwb=0                     pclm=0.85828588
+ lpclm=-4.9272432e-008+dlpclmp_18                    pdiblc1=0
+ pdiblc2=0.0082343413      lpdiblc2=-6.4506888e-010  pdiblcb=-0.28634778
+ lpdiblcb=3.7878085e-008   wpdiblcb=-2.76214e-007    ppdiblcb=3.6537587e-014
+ drout=0                   pvag=0                    delta=0.007
+ pscbe1=8.564e+008         pscbe2=1e-020             fprout=0
+ pdits=0                   pditsd=0                  pditsl=0
+ rsh=9.68                  rdsw=456.4                prwg=0
+ prwb=0                    wr=1                      alpha0=0
+ alpha1=0.09               beta0=17                  agidl=1.56e-012
+ bgidl=8.66e+008           cgidl=0.25                egidl=0.2624
+ aigbacc=0.01213           bigbacc=0.006537          cigbacc=0.2809
+ nigbacc=4.05              aigbinv=0.35              bigbinv=0.03
+ cigbinv=0.006             eigbinv=1.1               nigbinv=1
+ aigc=0.01                 bigc=0.00144              cigc=1.515e-005
+ aigsd=0.008379            bigsd=0.0002699           cigsd=3.925e-020
+ nigc=1                    poxedge=1                 pigcd=2.171
+ ntox=1                    xrcrg1=12                 xrcrg2=1
+ cgso=cgop_18              cgdo=cgop_18              cgbo=0
+ cgdl=cglp_18              cgsl=cglp_18              clc=1e-007
+ cle=0.6                   cf=cfp_18                 ckappas=0.6
+ ckappad=0.6               acde=0.4                  moin=5
+ noff=1.9                  voffcv=-0.044             kt1=-0.19480368
+ lkt1=-1.1396783e-010      wkt1=-1.0933396e-008      pkt1=1.4663947e-015
+ kt1l=0                    kt2=-0.03                 ute=-1.0811703
+ lute=5.3190545e-009       wute=-6.3374133e-008      pute=3.4204969e-014
+ ua1=8.9131411e-010        lua1=6.6864321e-017       wua1=1.8095799e-016
+ pua1=7.0995474e-023       ub1=-1.5405419e-018       lub1=-1.2433422e-025
+ wub1=-1.1440179e-024      pub1=4.3043699e-032       uc1=-7.6951426e-011
+ luc1=9.3538357e-019       wuc1=2.8091653e-017       puc1=-9.3342946e-024
+ prt=0                     at=23077.739              lat=-0.0004961918
+ wat=0.025627256           pat=-3.8212239e-009       jss=1.9e-07
+ jsd=1.9e-07               jsws=1e-12                jswd=1e-12
+ jswgs=1e-12               jswgd=1e-12               njs=1
+ njd=1                     ijthsfwd=0.01             ijthdfwd=0.01
+ ijthsrev=0.01             ijthdrev=0.01             bvs=10
+ bvd=10                    xjbvs=1                   xjbvd=1
+ pbs=0.752                 pbd=0.752                 cjs=cjp_18
+ cjd=cjp_18                mjs=0.335                 mjd=0.335
+ pbsws=0.752               pbswd=0.752               cjsws=cjswp_18
+ cjswd=cjswp_18            mjsws=0.01                mjswd=0.01
+ pbswgs=0.952              pbswgd=0.952              cjswgs=cjswgp_18
+ cjswgd=cjswgp_18          mjswgs=0.68               mjswgd=0.68
+ tpb=0.00174               tcj=0.000859              tpbsw=0.00137
+ tcjsw=0.0001              tpbswg=0.00289            tcjswg=0.000931
+ xtis=3                    xtid=3                    jtsswgs=1.000e-08
+ jtsswgd=1.000e-08         njtsswg=40.31             xtsswgs=0.4558
+ xtsswgd=0.4558            tnjtsswg=1                dmcg=1.255e-007
+ dmci=1.255e-007           dmdg=0                    dmcgt=0
+ dwj=0                     xgw=0                     xgl=0
+ rshg=1                    gbmin=1e-012              rbpb=50
+ rbpd=50                   rbps=50                   rbdb=50
+ rbsb=50                   ngcon=1                   saref=0.82e-6
+ sbref=0.82e-6             kvsat=-0.450              wlod=8e-7
+ tku0=0.3                  ku0=1.6e-7                llodku0=1
+ wlodku0=1                 lku0=7.43e-8              wku0=7.0e-7
+ pku0=0                    kvth0=0                   stk2=0
+ steta0=0                  lkvth0=0                  wkvth0=0
+ pkvth0=0                  llodvth=1                 wlodvth=1
+ lodk2=1                   lodeta0=1                 fnoimod=1
+ noia=2.0e+42              noib=2.2e+20              noic=5.0e+08
+ em=3.0e+07                ef=1.2e+00                tnoimod=0
+ lintnoi=-2.0e-8           ud=0                      wpemod=wpeflag_18
+ kvth0we=-4.0e-3           lkvth0we=0.0e-11          wkvth0we=0
+ pkvth0we=0                ku0we=-0.8e-3             lku0we=0
+ wku0we=0                  pku0we=0                  k2we=0
+ wk2we=0                   web=0                     wec=0
+ scref=1e-6                lvsat=0+dlvsatp_18        lnfactor=0+dlnfactorp_18
+ wnfactor=0+dwnfactorp_18  minr=1e-3

     11: type=p
+ lmin=1e-005-dxlp_18       lmax=0.0009001            wmin=6e-007-dxwp_18
+ wmax=1e-006-dxwp_18       version=4.5               binunit=2
+ paramchk=1                mobmod=0                  capmod=2
+ igcmod=0                  igbmod=0                  geomod=0
+ diomod=1                  rdsmod=0                  rbodymod=0
+ rgatemod=0                permod=1                  acnqsmod=0
+ trnqsmod=0                tempmod=0                 tnom=25
+ toxe=toxp_18              toxm=toxp_18              dtox=3.312e-010
+ epsrox=3.9                wint=1e-008               lint=6.36e-009
+ ll=0                      wl=0                      lln=1
+ wln=1                     lw=0                      ww=0
+ lwn=1                     wwn=1                     lwl=0
+ wwl=0                     llc=0                     wlc=0
+ lwc=0                     wwc=0                     lwlc=0
+ wwlc=0                    xl=-5.5e-08+dxlp_18       xw=0+dxwp_18
+ dlc=dlcp_18               dwc=0                     xpart=1
+ toxref=3e-009             dlcig=6.95e-008           vth0=-0.41635+dvthp_18
+ wvth0=4.263e-009+dwvthp_18                          k1=0.47
+ k2=-0.0407+dk2p_18        k3=-2.181735              k3b=1.642093
+ w0=0                      dvt0=0.02355              dvt1=0.04408725
+ dvt2=0.3556108            dvt0w=0                   dvt1w=0
+ dvt2w=0                   dsub=0.0468373            minv=-0.3
+ voffl=0                   dvtp0=0                   dvtp1=0
+ lpe0=9.321426e-008        lpeb=1.240401e-007        xj=1.8e-007
+ ngate=2.68e+020           ndep=8.4e+017             nsd=1e+020
+ phin=0                    cdsc=0                    cdscb=0
+ cdscd=0                   cit=0.00101565            wcit=-3.65197e-010
+ voff=-0.1594              wvoff=1.7052e-008         nfactor=0.691
+ eta0=0.00157              etab=-0.00095355          wetab=-1.43521e-010
+ u0=0.012604377            wu0=1.5751785e-010        ua=1.4785854e-009
+ wua=1.0274967e-016        ub=1.1519581e-018         wub=-2.8194096e-025
+ uc=2.8056151e-011         wuc=-3.1415027e-017       vsat=70000
+ a0=1.0510647              wa0=2.0279659e-007        ags=0.48262309
+ wags=1.4567808e-008       a1=0                      a2=0.99
+ b0=0                      b1=0                      keta=-0.039599346
+ wketa=-1.7563702e-009     dwg=0                     dwb=0
+ pclm=0.71                 pdiblc1=0                 pdiblc2=0.002698
+ wpdiblc2=-1.421e-010      pdiblcb=0.0609            wpdiblcb=-5.9682e-008
+ drout=0                   pvag=0                    delta=0.007
+ pscbe1=8.564e+008         pscbe2=1e-020             fprout=0
+ pdits=0                   pditsd=0                  pditsl=0
+ rsh=9.68                  rdsw=456.4                prwg=0
+ prwb=0                    wr=1                      alpha0=0
+ alpha1=0.09               beta0=17                  agidl=1.56e-012
+ bgidl=8.66e+008           cgidl=0.25                egidl=0.2624
+ aigbacc=0.01213           bigbacc=0.006537          cigbacc=0.2809
+ nigbacc=4.05              aigbinv=0.35              bigbinv=0.03
+ cigbinv=0.006             eigbinv=1.1               nigbinv=1
+ aigc=0.01                 bigc=0.00144              cigc=1.515e-005
+ aigsd=0.008379            bigsd=0.0002699           cigsd=3.925e-020
+ nigc=1                    poxedge=1                 pigcd=2.171
+ ntox=1                    xrcrg1=12                 xrcrg2=1
+ cgso=cgop_18              cgdo=cgop_18              cgbo=0
+ cgdl=cglp_18              cgsl=cglp_18              clc=1e-007
+ cle=0.6                   cf=cfp_18                 ckappas=0.6
+ ckappad=0.6               acde=0.4                  moin=5
+ noff=1.9                  voffcv=-0.044             kt1=-0.18275
+ wkt1=-7.105e-009          kt1l=0                    kt2=-0.03
+ ute=-0.28691074           wute=-4.5349055e-007      ua1=6.0142312e-009
+ wua1=-2.3340024e-015      ub1=-5.4677e-018          wub1=1.344266e-024
+ uc1=-7.413638e-011        prt=0                     at=40000
+ jss=1.9e-07               jsd=1.9e-07               jsws=1e-12
+ jswd=1e-12                jswgs=1e-12               jswgd=1e-12
+ njs=1                     njd=1                     ijthsfwd=0.01
+ ijthdfwd=0.01             ijthsrev=0.01             ijthdrev=0.01
+ bvs=10                    bvd=10                    xjbvs=1
+ xjbvd=1                   pbs=0.752                 pbd=0.752
+ cjs=cjp_18                cjd=cjp_18                mjs=0.335
+ mjd=0.335                 pbsws=0.752               pbswd=0.752
+ cjsws=cjswp_18            cjswd=cjswp_18            mjsws=0.01
+ mjswd=0.01                pbswgs=0.952              pbswgd=0.952
+ cjswgs=cjswgp_18          cjswgd=cjswgp_18          mjswgs=0.68
+ mjswgd=0.68               tpb=0.00174               tcj=0.000859
+ tpbsw=0.00137             tcjsw=0.0001              tpbswg=0.00289
+ tcjswg=0.000931           xtis=3                    xtid=3
+ jtsswgs=1.000e-08         jtsswgd=1.000e-08         njtsswg=40.31
+ xtsswgs=0.4558            xtsswgd=0.4558            tnjtsswg=1
+ dmcg=1.255e-007           dmci=1.255e-007           dmdg=0
+ dmcgt=0                   dwj=0                     xgw=0
+ xgl=0                     rshg=1                    gbmin=1e-012
+ rbpb=50                   rbpd=50                   rbps=50
+ rbdb=50                   rbsb=50                   ngcon=1
+ lvth0=0+dlvthp_18         lvsat=0+dlvsatp_18        saref=0.82e-6
+ sbref=0.82e-6             kvsat=-0.450              wlod=8e-7
+ tku0=0.3                  ku0=1.6e-7                llodku0=1
+ wlodku0=1                 lku0=7.43e-8              wku0=7.0e-7
+ pku0=0                    kvth0=0                   stk2=0
+ steta0=0                  lkvth0=0                  wkvth0=0
+ pkvth0=0                  llodvth=1                 wlodvth=1
+ lodk2=1                   lodeta0=1                 fnoimod=1
+ noia=2.0e+42              noib=2.2e+20              noic=5.0e+08
+ em=3.0e+07                ef=1.2e+00                tnoimod=0
+ lintnoi=-2.0e-8           ud=0                      wpemod=wpeflag_18
+ kvth0we=-4.0e-3           lkvth0we=0.0e-11          wkvth0we=0
+ pkvth0we=0                ku0we=-0.8e-3             lku0we=0
+ wku0we=0                  pku0we=0                  k2we=0
+ wk2we=0                   web=0                     wec=0
+ scref=1e-6                lpclm=0+dlpclmp_18        lnfactor=0+dlnfactorp_18
+ wnfactor=0+dwnfactorp_18  minr=1e-3

     12: type=p
+ lmin=1.2e-006-dxlp_18     lmax=1e-005-dxlp_18       wmin=6e-007-dxwp_18
+ wmax=1e-006-dxwp_18       version=4.5               binunit=2
+ paramchk=1                mobmod=0                  capmod=2
+ igcmod=0                  igbmod=0                  geomod=0
+ diomod=1                  rdsmod=0                  rbodymod=0
+ rgatemod=0                permod=1                  acnqsmod=0
+ trnqsmod=0                tempmod=0                 tnom=25
+ toxe=toxp_18              toxm=toxp_18              dtox=3.312e-010
+ epsrox=3.9                wint=1e-008               lint=6.36e-009
+ ll=0                      wl=0                      lln=1
+ wln=1                     lw=0                      ww=0
+ lwn=1                     wwn=1                     lwl=0
+ wwl=0                     llc=0                     wlc=0
+ lwc=0                     wwc=0                     lwlc=0
+ wwlc=0                    xl=-5.5e-08+dxlp_18       xw=0+dxwp_18
+ dlc=dlcp_18               dwc=0                     xpart=1
+ toxref=3e-009             dlcig=6.95e-008           vth0=-0.41901343+dvthp_18
+ lvth0=2.6453946e-008+dlvthp_18                      wvth0=5.3600249e-009+dwvthp_18
+ pvth0=-1.0895959e-014     k1=0.47                   k2=-0.0407+dk2p_18
+ k3=-2.181735              k3b=1.642093              w0=0
+ dvt0=0.02355              dvt1=0.04408725           dvt2=0.3556108
+ dvt0w=0                   dvt1w=0                   dvt2w=0
+ dsub=0.0468373            minv=-0.3                 voffl=0
+ dvtp0=0                   dvtp1=0                   lpe0=9.321426e-008
+ lpeb=1.240401e-007        xj=1.8e-007               ngate=2.68e+020
+ ndep=8.4e+017             nsd=1e+020                phin=0
+ cdsc=0                    cdscb=0                   cdscd=0
+ cit=0.0011388498          lcit=-1.2236548e-009      wcit=-4.2919012e-010
+ pcit=6.3559759e-016       voff=-0.16739029          lvoff=7.9361838e-008
+ wvoff=2.0343075e-008      pvoff=-3.2687876e-014     nfactor=0.691
+ eta0=0.00157              etab=-0.00095355          wetab=-1.43521e-010
+ u0=0.012620675            lu0=-1.6187387e-010       wu0=1.4806515e-010
+ pu0=9.3886844e-017        ua=1.4790117e-009         lua=-4.2345483e-018
+ wua=1.1318055e-016        pua=-1.0360241e-022       ub=1.1815383e-018
+ lub=-2.9379879e-025       wub=-2.9551614e-025       pub=1.3483249e-031
+ uc=3.1608184e-011         luc=-3.5279788e-017       wuc=-3.5274304e-017
+ puc=3.833142e-023         vsat=70000                a0=1.0387432
+ la0=1.2238062e-007        wa0=2.0636796e-007        pa0=-3.5471793e-014
+ ags=0.45370928            lags=2.8718008e-007       wags=1.4704936e-008
+ pags=-1.3619948e-015      a1=0                      a2=0.99
+ b0=0                      b1=0                      keta=-0.034101785
+ lketa=-5.4603306e-008     wketa=-3.3184514e-009     pketa=1.5515028e-014
+ dwg=0                     dwb=0                     pclm=0.69970655
+ lpclm=1.0223747e-007+dlpclmp_18                     pdiblc1=0
+ pdiblc2=0.001821641       lpdiblc2=8.7042428e-009   wpdiblc2=-1.6038375e-010
+ ppdiblc2=1.8159931e-016   pdiblcb=0.068735891       lpdiblcb=-7.7828276e-008
+ wpdiblcb=-6.7361174e-008  ppdiblcb=7.6271711e-014   drout=0
+ pvag=0                    delta=0.007               pscbe1=8.564e+008
+ pscbe2=1e-020             fprout=0                  pdits=0
+ pditsd=0                  pditsl=0                  rsh=9.68
+ rdsw=456.4                prwg=0                    prwb=0
+ wr=1                      alpha0=0                  alpha1=0.09
+ beta0=17                  agidl=1.56e-012           bgidl=8.66e+008
+ cgidl=0.25                egidl=0.2624              aigbacc=0.01213
+ bigbacc=0.006537          cigbacc=0.2809            nigbacc=4.05
+ aigbinv=0.35              bigbinv=0.03              cigbinv=0.006
+ eigbinv=1.1               nigbinv=1                 aigc=0.01
+ bigc=0.00144              cigc=1.515e-005           aigsd=0.008379
+ bigsd=0.0002699           cigsd=3.925e-020          nigc=1
+ poxedge=1                 pigcd=2.171               ntox=1
+ xrcrg1=12                 xrcrg2=1                  cgso=cgop_18
+ cgdo=cgop_18              cgbo=0                    cgdl=cglp_18
+ cgsl=cglp_18              clc=1e-007                cle=0.6
+ cf=cfp_18                 ckappas=0.6               ckappad=0.6
+ acde=0.4                  moin=5                    noff=1.9
+ voffcv=-0.044             kt1=-0.18163059           lkt1=-1.1118325e-008
+ wkt1=-7.470675e-009       pkt1=3.6319862e-015       kt1l=0
+ kt2=-0.03                 ute=-0.24768679           lute=-3.8958325e-007
+ wute=-5.1184036e-007      pute=5.795466e-013        ua1=6.3263025e-009
+ lua1=-3.0995797e-015      wua1=-2.6343143e-015      pua1=2.9827814e-021
+ ub1=-5.6895699e-018       lub1=2.2036738e-024       wub1=1.5172303e-024
+ pub1=-1.7179295e-030      uc1=-7.413638e-011        prt=0
+ at=32861.489              lat=0.070901687           jss=1.9e-07
+ jsd=1.9e-07               jsws=1e-12                jswd=1e-12
+ jswgs=1e-12               jswgd=1e-12               njs=1
+ njd=1                     ijthsfwd=0.01             ijthdfwd=0.01
+ ijthsrev=0.01             ijthdrev=0.01             bvs=10
+ bvd=10                    xjbvs=1                   xjbvd=1
+ pbs=0.752                 pbd=0.752                 cjs=cjp_18
+ cjd=cjp_18                mjs=0.335                 mjd=0.335
+ pbsws=0.752               pbswd=0.752               cjsws=cjswp_18
+ cjswd=cjswp_18            mjsws=0.01                mjswd=0.01
+ pbswgs=0.952              pbswgd=0.952              cjswgs=cjswgp_18
+ cjswgd=cjswgp_18          mjswgs=0.68               mjswgd=0.68
+ tpb=0.00174               tcj=0.000859              tpbsw=0.00137
+ tcjsw=0.0001              tpbswg=0.00289            tcjswg=0.000931
+ xtis=3                    xtid=3                    jtsswgs=1.000e-08
+ jtsswgd=1.000e-08         njtsswg=40.31             xtsswgs=0.4558
+ xtsswgd=0.4558            tnjtsswg=1                dmcg=1.255e-007
+ dmci=1.255e-007           dmdg=0                    dmcgt=0
+ dwj=0                     xgw=0                     xgl=0
+ rshg=1                    gbmin=1e-012              rbpb=50
+ rbpd=50                   rbps=50                   rbdb=50
+ rbsb=50                   ngcon=1                   saref=0.82e-6
+ sbref=0.82e-6             kvsat=-0.450              wlod=8e-7
+ tku0=0.3                  ku0=1.6e-7                llodku0=1
+ wlodku0=1                 lku0=7.43e-8              wku0=7.0e-7
+ pku0=0                    kvth0=0                   stk2=0
+ steta0=0                  lkvth0=0                  wkvth0=0
+ pkvth0=0                  llodvth=1                 wlodvth=1
+ lodk2=1                   lodeta0=1                 fnoimod=1
+ noia=2.0e+42              noib=2.2e+20              noic=5.0e+08
+ em=3.0e+07                ef=1.2e+00                tnoimod=0
+ lintnoi=-2.0e-8           ud=0                      wpemod=wpeflag_18
+ kvth0we=-4.0e-3           lkvth0we=0.0e-11          wkvth0we=0
+ pkvth0we=0                ku0we=-0.8e-3             lku0we=0
+ wku0we=0                  pku0we=0                  k2we=0
+ wk2we=0                   web=0                     wec=0
+ scref=1e-6                lvsat=0+dlvsatp_18        lnfactor=0+dlnfactorp_18
+ wnfactor=0+dwnfactorp_18  minr=1e-3

     13: type=p
+ lmin=7e-007-dxlp_18       lmax=1.2e-006-dxlp_18     wmin=6e-007-dxwp_18
+ wmax=1e-006-dxwp_18       version=4.5               binunit=2
+ paramchk=1                mobmod=0                  capmod=2
+ igcmod=0                  igbmod=0                  geomod=0
+ diomod=1                  rdsmod=0                  rbodymod=0
+ rgatemod=0                permod=1                  acnqsmod=0
+ trnqsmod=0                tempmod=0                 tnom=25
+ toxe=toxp_18              toxm=toxp_18              dtox=3.312e-010
+ epsrox=3.9                wint=1e-008               lint=6.36e-009
+ ll=0                      wl=0                      lln=1
+ wln=1                     lw=0                      ww=0
+ lwn=1                     wwn=1                     lwl=0
+ wwl=0                     llc=0                     wlc=0
+ lwc=0                     wwc=0                     lwlc=0
+ wwlc=0                    xl=-5.5e-08+dxlp_18       xw=0+dxwp_18
+ dlc=dlcp_18               dwc=0                     xpart=1
+ toxref=3e-009             dlcig=6.95e-008           vth0=-0.40848528+dvthp_18
+ lvth0=1.4533135e-008+dlvthp_18                      wvth0=8.3155783e-009+dwvthp_18
+ pvth0=-1.4242473e-014     k1=0.47                   k2=-0.03058352+dk2p_18
+ lk2=-1.1454688e-008       wk2=-8.9846988e-009       pk2=1.0173195e-014
+ k3=-2.181735              k3b=1.642093              w0=0
+ dvt0=0.02355              dvt1=0.04408725           dvt2=0.3556108
+ dvt0w=0                   dvt1w=0                   dvt2w=0
+ dsub=0.0468373            minv=-0.3                 voffl=0
+ dvtp0=0                   dvtp1=0                   lpe0=9.321426e-008
+ lpeb=1.240401e-007        xj=1.8e-007               ngate=2.68e+020
+ ndep=8.4e+017             nsd=1e+020                phin=0
+ cdsc=0                    cdscb=0                   cdscd=0
+ cit=-0.0016612722         lcit=1.9468674e-009       wcit=8.2577175e-010
+ pcit=-7.8537064e-016      voff=-0.11519352          lvoff=2.0260479e-008
+ wvoff=4.0525783e-009      pvoff=-1.4242473e-014     nfactor=0.691
+ eta0=0.00157              etab=0.003450786          letab=-4.9869416e-009
+ wetab=-4.4597703e-009     petab=4.8872028e-015      u0=0.012488277
+ lu0=-1.1962274e-011       wu0=2.2485599e-010        pu0=6.9381188e-018
+ ua=1.8355774e-009         lua=-4.0796666e-016       wua=-1.9488376e-016
+ pua=2.4521265e-022        ub=6.8657207e-019         lub=2.6664158e-025
+ wub=-1.9642643e-026       pub=-1.7753356e-031       uc=-9.4959331e-012
+ luc=1.1261581e-017        wuc=2.8807516e-018        puc=-4.8707873e-024
+ vsat=70000                a0=0.2203019              la0=1.0490853e-006
+ wa0=1.0191562e-006        pa0=-9.5577572e-013       ags=0.47343726
+ lags=2.6484247e-007       wags=-2.023351e-008       pags=3.8198108e-014
+ a1=0                      a2=0.99                   b0=0
+ b1=0                      keta=-0.090583131         lketa=9.3493922e-009
+ wketa=4.0942664e-008      pketa=-3.4600948e-014     dwg=0
+ dwb=0                     pclm=0.8911648            lpclm=-1.1454688e-007+dlpclmp_18
+ pdiblc1=0                 pdiblc2=0.011152928       lpdiblc2=-1.8613868e-009
+ pdiblcb=0.42908279        lpdiblcb=-4.8584186e-007  wpdiblcb=1.2725568e-007
+ ppdiblcb=-1.4408906e-013  drout=0                   pvag=0
+ delta=0.007               pscbe1=8.564e+008         pscbe2=1e-020
+ fprout=0                  pdits=0                   pditsd=0
+ pditsl=0                  rsh=9.68                  rdsw=456.4
+ prwg=0                    prwb=0                    wr=1
+ alpha0=0                  alpha1=0.09               beta0=17
+ agidl=1.56e-012           bgidl=8.66e+008           cgidl=0.25
+ egidl=0.2624              aigbacc=0.01213           bigbacc=0.006537
+ cigbacc=0.2809            nigbacc=4.05              aigbinv=0.35
+ bigbinv=0.03              cigbinv=0.006             eigbinv=1.1
+ nigbinv=1                 aigc=0.01                 bigc=0.00144
+ cigc=1.515e-005           aigsd=0.008379            bigsd=0.0002699
+ cigsd=3.925e-020          nigc=1                    poxedge=1
+ pigcd=2.171               ntox=1                    xrcrg1=12
+ xrcrg2=1                  cgso=cgop_18              cgdo=cgop_18
+ cgbo=0                    cgdl=cglp_18              cgsl=cglp_18
+ clc=1e-007                cle=0.6                   cf=cfp_18
+ ckappas=0.6               ckappad=0.6               acde=0.4
+ moin=5                    noff=1.9                  voffcv=-0.044
+ kt1=-0.1671578            lkt1=-2.7505569e-008      wkt1=-2.187301e-008
+ pkt1=1.9939462e-014       kt1l=0                    kt2=-0.03
+ ute=-0.20342999           lute=-4.3969434e-007      wute=3.8022886e-008
+ pute=-4.3052553e-014      ua1=6.3875914e-009        lua1=-3.1689759e-015
+ wua1=-1.7820252e-016      pua1=2.0177514e-022       ub1=-5.791143e-018
+ lub1=2.318683e-024        wub1=6.4127389e-025       pub1=-7.261016e-031
+ uc1=-6.3510573e-011       luc1=-1.2031389e-017      prt=0
+ at=105318.28              lat=-0.011139684          jss=1.9e-07
+ jsd=1.9e-07               jsws=1e-12                jswd=1e-12
+ jswgs=1e-12               jswgd=1e-12               njs=1
+ njd=1                     ijthsfwd=0.01             ijthdfwd=0.01
+ ijthsrev=0.01             ijthdrev=0.01             bvs=10
+ bvd=10                    xjbvs=1                   xjbvd=1
+ pbs=0.752                 pbd=0.752                 cjs=cjp_18
+ cjd=cjp_18                mjs=0.335                 mjd=0.335
+ pbsws=0.752               pbswd=0.752               cjsws=cjswp_18
+ cjswd=cjswp_18            mjsws=0.01                mjswd=0.01
+ pbswgs=0.952              pbswgd=0.952              cjswgs=cjswgp_18
+ cjswgd=cjswgp_18          mjswgs=0.68               mjswgd=0.68
+ tpb=0.00174               tcj=0.000859              tpbsw=0.00137
+ tcjsw=0.0001              tpbswg=0.00289            tcjswg=0.000931
+ xtis=3                    xtid=3                    jtsswgs=1.000e-08
+ jtsswgd=1.000e-08         njtsswg=40.31             xtsswgs=0.4558
+ xtsswgd=0.4558            tnjtsswg=1                dmcg=1.255e-007
+ dmci=1.255e-007           dmdg=0                    dmcgt=0
+ dwj=0                     xgw=0                     xgl=0
+ rshg=1                    gbmin=1e-012              rbpb=50
+ rbpd=50                   rbps=50                   rbdb=50
+ rbsb=50                   ngcon=1                   lvsat=0+dlvsatp_18
+ saref=0.82e-6             sbref=0.82e-6             kvsat=-0.450
+ wlod=8e-7                 tku0=0.3                  ku0=1.6e-7
+ llodku0=1                 wlodku0=1                 lku0=7.43e-8
+ wku0=7.0e-7               pku0=0                    kvth0=0
+ stk2=0                    steta0=0                  lkvth0=0
+ wkvth0=0                  pkvth0=0                  llodvth=1
+ wlodvth=1                 lodk2=1                   lodeta0=1
+ fnoimod=1                 noia=2.0e+42              noib=2.2e+20
+ noic=5.0e+08              em=3.0e+07                ef=1.2e+00
+ tnoimod=0                 lintnoi=-2.0e-8           ud=0
+ wpemod=wpeflag_18         kvth0we=-4.0e-3           lkvth0we=0.0e-11
+ wkvth0we=0                pkvth0we=0                ku0we=-0.8e-3
+ lku0we=0                  wku0we=0                  pku0we=0
+ k2we=0                    wk2we=0                   web=0
+ wec=0                     scref=1e-6                lnfactor=0+dlnfactorp_18
+ wnfactor=0+dwnfactorp_18  minr=1e-3

     14: type=p
+ lmin=4e-007-dxlp_18       lmax=7e-007-dxlp_18       wmin=6e-007-dxwp_18
+ wmax=1e-006-dxwp_18       version=4.5               binunit=2
+ paramchk=1                mobmod=0                  capmod=2
+ igcmod=0                  igbmod=0                  geomod=0
+ diomod=1                  rdsmod=0                  rbodymod=0
+ rgatemod=0                permod=1                  acnqsmod=0
+ trnqsmod=0                tempmod=0                 tnom=25
+ toxe=toxp_18              toxm=toxp_18              dtox=3.312e-010
+ epsrox=3.9                wint=1e-008               lint=6.36e-009
+ ll=0                      wl=0                      lln=1
+ wln=1                     lw=0                      ww=0
+ lwn=1                     wwn=1                     lwl=0
+ wwl=0                     llc=0                     wlc=0
+ lwc=0                     wwc=0                     lwlc=0
+ wwlc=0                    xl=-5.5e-08+dxlp_18       xw=0+dxwp_18
+ dlc=dlcp_18               dwc=0                     xpart=1
+ toxref=3e-009             dlcig=6.95e-008           vth0=-0.3750941+dvthp_18
+ lvth0=-6.5794437e-009+dlvthp_18                     wvth0=-1.594129e-008+dwvthp_18
+ pvth0=1.0946598e-015      k1=0.47                   k2=-0.02976004+dk2p_18
+ lk2=-1.1975358e-008       wk2=8.6788996e-009        pk2=-9.9514524e-016
+ k3=-2.181735              k3b=1.642093              w0=0
+ dvt0=0.02355              dvt1=0.04408725           dvt2=0.3556108
+ dvt0w=0                   dvt1w=0                   dvt2w=0
+ dsub=0.0468373            minv=-0.3                 voffl=0
+ dvtp0=0                   dvtp1=0                   lpe0=9.321426e-008
+ lpeb=1.240401e-007        xj=1.8e-007               ngate=2.68e+020
+ ndep=8.4e+017             nsd=1e+020                phin=0
+ cdsc=0                    cdscb=0                   cdscd=0
+ cit=0.0024675225          lcit=-6.6368694e-010      wcit=-9.6092226e-010
+ pcit=3.4432025e-016       voff=-0.04432862          lvoff=-2.4545982e-008
+ wvoff=-2.6342498e-008     pvoff=4.9757262e-015      nfactor=0.691
+ eta0=0.00157              etab=-0.00829411          letab=2.4391213e-009
+ wetab=7.0502278e-009      petab=-2.3903389e-015     u0=0.012469358
+ wu0=2.3582916e-010        ua=1.2670267e-009         lua=-4.8483462e-017
+ wua=2.8810023e-016        pua=-6.0168471e-023       ub=1.1826297e-018
+ lub=-4.7005728e-026       wub=-5.1623066e-025       pub=1.3644911e-031
+ uc=7.0867076e-011         luc=-3.9550342e-017       wuc=-2.9042105e-017
+ puc=1.5313396e-023        vsat=70000                a0=2.9351881
+ la0=-6.6748292e-007       wa0=-1.1499456e-006       pa0=4.1570401e-013
+ ags=0.19732322            lags=4.3942386e-007       wags=1.699733e-008
+ pags=1.4657793e-014       a1=0                      a2=0.99
+ b0=0                      b1=0                      keta=-0.048988366
+ lketa=-1.6950146e-008     wketa=-2.9045734e-008     pketa=9.6513166e-015
+ dwg=0                     dwb=0                     pclm=0.71
+ pdiblc1=0                 pdiblc2=0.016299132       lpdiblc2=-5.1152286e-009
+ wpdiblc2=-5.8486109e-009  ppdiblc2=3.6979597e-015   pdiblcb=-0.090636988
+ lpdiblcb=-1.5723344e-007  wpdiblcb=-4.5288055e-007  ppdiblcb=2.2271948e-013
+ drout=0                   pvag=0                    delta=0.007
+ pscbe1=8.564e+008         pscbe2=1e-020             fprout=0
+ pdits=0                   pditsd=0                  pditsl=0
+ rsh=9.68                  rdsw=456.4                prwg=0
+ prwb=0                    wr=1                      alpha0=0
+ alpha1=0.09               beta0=17                  agidl=1.56e-012
+ bgidl=8.66e+008           cgidl=0.25                egidl=0.2624
+ aigbacc=0.01213           bigbacc=0.006537          cigbacc=0.2809
+ nigbacc=4.05              aigbinv=0.35              bigbinv=0.03
+ cigbinv=0.006             eigbinv=1.1               nigbinv=1
+ aigc=0.01                 bigc=0.00144              cigc=1.515e-005
+ aigsd=0.008379            bigsd=0.0002699           cigsd=3.925e-020
+ nigc=1                    poxedge=1                 pigcd=2.171
+ ntox=1                    xrcrg1=12                 xrcrg2=1
+ cgso=cgop_18              cgdo=cgop_18              cgbo=0
+ cgdl=cglp_18              cgsl=cglp_18              clc=1e-007
+ cle=0.6                   cf=cfp_18                 ckappas=0.6
+ ckappad=0.6               acde=0.4                  moin=5
+ noff=1.9                  voffcv=-0.044             kt1=-0.23010946
+ lkt1=1.2297502e-008       wkt1=2.9808715e-008       pkt1=-1.2737859e-014
+ kt1l=0                    kt2=-0.03                 ute=-0.80533215
+ lute=-5.9123645e-008      wute=-1.8299714e-008      pute=-7.4409e-015
+ ua1=1.2281604e-009        lua1=9.3229107e-017       wua1=3.1167766e-016
+ pua1=-1.0796629e-022      ub1=-1.3927984e-018       lub1=-4.6230235e-025
+ wub1=-8.8881597e-025      pub1=2.4134362e-031       uc1=-9.1846058e-011
+ luc1=5.8845718e-018       prt=0                     at=156205.06
+ lat=-0.043314379          wat=-0.011017297          pat=6.9660167e-009
+ jss=1.9e-07               jsd=1.9e-07               jsws=1e-12
+ jswd=1e-12                jswgs=1e-12               jswgd=1e-12
+ njs=1                     njd=1                     ijthsfwd=0.01
+ ijthdfwd=0.01             ijthsrev=0.01             ijthdrev=0.01
+ bvs=10                    bvd=10                    xjbvs=1
+ xjbvd=1                   pbs=0.752                 pbd=0.752
+ cjs=cjp_18                cjd=cjp_18                mjs=0.335
+ mjd=0.335                 pbsws=0.752               pbswd=0.752
+ cjsws=cjswp_18            cjswd=cjswp_18            mjsws=0.01
+ mjswd=0.01                pbswgs=0.952              pbswgd=0.952
+ cjswgs=cjswgp_18          cjswgd=cjswgp_18          mjswgs=0.68
+ mjswgd=0.68               tpb=0.00174               tcj=0.000859
+ tpbsw=0.00137             tcjsw=0.0001              tpbswg=0.00289
+ tcjswg=0.000931           xtis=3                    xtid=3
+ jtsswgs=1.000e-08         jtsswgd=1.000e-08         njtsswg=40.31
+ xtsswgs=0.4558            xtsswgd=0.4558            tnjtsswg=1
+ dmcg=1.255e-007           dmci=1.255e-007           dmdg=0
+ dmcgt=0                   dwj=0                     xgw=0
+ xgl=0                     rshg=1                    gbmin=1e-012
+ rbpb=50                   rbpd=50                   rbps=50
+ rbdb=50                   rbsb=50                   ngcon=1
+ lvsat=0+dlvsatp_18        lpclm=0+dlpclmp_18        lnfactor=0+dlnfactorp_18
+ saref=0.82e-6             sbref=0.82e-6             kvsat=-0.450
+ wlod=8e-7                 tku0=0.3                  ku0=1.6e-7
+ llodku0=1                 wlodku0=1                 lku0=7.43e-8
+ wku0=7.0e-7               pku0=0                    kvth0=0
+ stk2=0                    steta0=0                  lkvth0=0
+ wkvth0=0                  pkvth0=0                  llodvth=1
+ wlodvth=1                 lodk2=1                   lodeta0=1
+ fnoimod=1                 noia=2.0e+42              noib=2.2e+20
+ noic=5.0e+08              em=3.0e+07                ef=1.2e+00
+ tnoimod=0                 lintnoi=-2.0e-8           ud=0
+ wpemod=wpeflag_18         kvth0we=-4.0e-3           lkvth0we=0.0e-11
+ wkvth0we=0                pkvth0we=0                ku0we=-0.8e-3
+ lku0we=0                  wku0we=0                  pku0we=0
+ k2we=0                    wk2we=0                   web=0
+ wec=0                     scref=1e-6                wnfactor=0+dwnfactorp_18
+ minr=1e-3

     15: type=p
+ lmin=2e-07                lmax=4e-007-dxlp_18       wmin=6e-007-dxwp_18
+ wmax=1e-006-dxwp_18       version=4.5               binunit=2
+ paramchk=1                mobmod=0                  capmod=2
+ igcmod=0                  igbmod=0                  geomod=0
+ diomod=1                  rdsmod=0                  rbodymod=0
+ rgatemod=0                permod=1                  acnqsmod=0
+ trnqsmod=0                tempmod=0                 tnom=25
+ toxe=toxp_18              toxm=toxp_18              dtox=3.312e-010
+ epsrox=3.9                wint=1e-008               lint=6.36e-009
+ ll=0                      wl=0                      lln=1
+ wln=1                     lw=0                      ww=0
+ lwn=1                     wwn=1                     lwl=0
+ wwl=0                     llc=0                     wlc=0
+ lwc=0                     wwc=0                     lwlc=0
+ wwlc=0                    xl=-5.5e-08+dxlp_18       xw=0+dxwp_18
+ dlc=dlcp_18               dwc=0                     xpart=1
+ toxref=3e-009             dlcig=6.95e-008           vth0=-0.37696775+dvthp_18
+ lvth0=-5.9568656e-009+dlvthp_18                     wvth0=-2.101156e-008+dwvthp_18
+ pvth0=2.7794091e-015      k1=0.47                   k2=-0.035585674+dk2p_18
+ lk2=-1.0039616e-008       wk2=2.8903916e-009        pk2=9.2826018e-016
+ k3=-2.181735              k3b=1.642093              w0=0
+ dvt0=0.02355              dvt1=0.04408725           dvt2=0.3556108
+ dvt0w=0                   dvt1w=0                   dvt2w=0
+ dsub=0.0468373            minv=-0.3                 voffl=0
+ dvtp0=0                   dvtp1=0                   lpe0=9.321426e-008
+ lpeb=1.240401e-007        xj=1.8e-007               ngate=2.68e+020
+ ndep=8.4e+017             nsd=1e+020                phin=0
+ cdsc=0                    cdscb=0                   cdscd=0
+ cit=1.256041e-005         lcit=1.5204787e-010       wcit=8.7531042e-011
+ pcit=-4.0598111e-018      voff=-0.10269017          lvoff=-5.1536063e-009
+ wvoff=-1.9826645e-008     pvoff=2.8106384e-015      nfactor=0.691
+ eta0=0.00157              etab=-0.00095355          wetab=-1.43521e-010
+ u0=0.011846027            lu0=2.0712047e-010        wu0=8.4669368e-010
+ pu0=-2.0297806e-016       ua=1.0552929e-009         lua=2.1871455e-017
+ wua=3.1472821e-017        pua=2.5103686e-023        ub=9.0028197e-019
+ lub=4.6812771e-026        wub=1.0599904e-025        pub=-7.0305375e-032
+ uc=-6.7547315e-011        luc=6.4419915e-018        wuc=2.9455733e-017
+ puc=-4.1242652e-024       vsat=70000                a0=0.35364994
+ la0=1.9031058e-007        wa0=2.8839511e-007        pa0=-6.2227847e-014
+ ags=-0.029900902          lags=5.1492589e-007       wags=1.3726892e-007
+ pags=-2.5306052e-014      a1=0                      a2=0.99
+ b0=0                      b1=0                      keta=-0.1
+ dwg=0                     dwb=0                     pclm=0.85828588
+ lpclm=-4.9272432e-008+dlpclmp_18                    pdiblc1=0
+ pdiblc2=-0.0007176142     lpdiblc2=5.3909579e-010   wpdiblc2=8.7729164e-009
+ ppdiblc2=-1.1604814e-015  pdiblcb=-0.37206752       lpdiblcb=-6.3719701e-008
+ wpdiblcb=-1.9220865e-007  ppdiblcb=1.3610342e-013   drout=0
+ pvag=0                    delta=0.007               pscbe1=8.564e+008
+ pscbe2=1e-020             fprout=0                  pdits=0
+ pditsd=0                  pditsl=0                  rsh=9.68
+ rdsw=456.4                prwg=0                    prwb=0
+ wr=1                      alpha0=0                  alpha1=0.09
+ beta0=17                  agidl=1.56e-012           bgidl=8.66e+008
+ cgidl=0.25                egidl=0.2624              aigbacc=0.01213
+ bigbacc=0.006537          cigbacc=0.2809            nigbacc=4.05
+ aigbinv=0.35              bigbinv=0.03              cigbinv=0.006
+ eigbinv=1.1               nigbinv=1                 aigc=0.01
+ bigc=0.00144              cigc=1.515e-005           aigsd=0.008379
+ bigsd=0.0002699           cigsd=3.925e-020          nigc=1
+ poxedge=1                 pigcd=2.171               ntox=1
+ xrcrg1=12                 xrcrg2=1                  cgso=cgop_18
+ cgdo=cgop_18              cgbo=0                    cgdl=cglp_18
+ cgsl=cglp_18              clc=1e-007                cle=0.6
+ cf=cfp_18                 ckappas=0.6               ckappad=0.6
+ acde=0.4                  moin=5                    noff=1.9
+ voffcv=-0.044             kt1=-0.19080593           lkt1=-7.6227222e-010
+ wkt1=-1.4851186e-008      pkt1=2.101733e-015        kt1l=0
+ kt2=-0.03                 ute=-1.1465814            lute=5.4266672e-008
+ wute=7.2880561e-010       pute=-1.3763696e-014      ua1=6.2792439e-010
+ lua1=2.9267553e-016       wua1=4.3907992e-016       pua1=-1.5029951e-022
+ ub1=-2.1296711e-018       lub1=-2.1745429e-025      wub1=-5.6667122e-025
+ pub1=1.3430136e-031       uc1=-4.0758088e-011       luc1=-1.1090939e-017
+ wuc1=-7.3778178e-018      puc1=2.4515013e-024       prt=0
+ at=32364.79               lat=-0.0021647344         wat=0.016525946
+ pat=-2.1860521e-009       jss=1.9e-07               jsd=1.9e-07
+ jsws=1e-12                jswd=1e-12                jswgs=1e-12
+ jswgd=1e-12               njs=1                     njd=1
+ ijthsfwd=0.01             ijthdfwd=0.01             ijthsrev=0.01
+ ijthdrev=0.01             bvs=10                    bvd=10
+ xjbvs=1                   xjbvd=1                   pbs=0.752
+ pbd=0.752                 cjs=cjp_18                cjd=cjp_18
+ mjs=0.335                 mjd=0.335                 pbsws=0.752
+ pbswd=0.752               cjsws=cjswp_18            cjswd=cjswp_18
+ mjsws=0.01                mjswd=0.01                pbswgs=0.952
+ pbswgd=0.952              cjswgs=cjswgp_18          cjswgd=cjswgp_18
+ mjswgs=0.68               mjswgd=0.68               tpb=0.00174
+ tcj=0.000859              tpbsw=0.00137             tcjsw=0.0001
+ tpbswg=0.00289            tcjswg=0.000931           xtis=3
+ xtid=3                    jtsswgs=1.000e-08         jtsswgd=1.000e-08
+ njtsswg=40.31             xtsswgs=0.4558            xtsswgd=0.4558
+ tnjtsswg=1                dmcg=1.255e-007           dmci=1.255e-007
+ dmdg=0                    dmcgt=0                   dwj=0
+ xgw=0                     xgl=0                     rshg=1
+ gbmin=1e-012              rbpb=50                   rbpd=50
+ rbps=50                   rbdb=50                   rbsb=50
+ ngcon=1                   lvsat=0+dlvsatp_18        saref=0.82e-6
+ sbref=0.82e-6             kvsat=-0.450              wlod=8e-7
+ tku0=0.3                  ku0=1.6e-7                llodku0=1
+ wlodku0=1                 lku0=7.43e-8              wku0=7.0e-7
+ pku0=0                    kvth0=0                   stk2=0
+ steta0=0                  lkvth0=0                  wkvth0=0
+ pkvth0=0                  llodvth=1                 wlodvth=1
+ lodk2=1                   lodeta0=1                 fnoimod=1
+ noia=2.0e+42              noib=2.2e+20              noic=5.0e+08
+ em=3.0e+07                ef=1.2e+00                tnoimod=0
+ lintnoi=-2.0e-8           ud=0                      wpemod=wpeflag_18
+ kvth0we=-4.0e-3           lkvth0we=0.0e-11          wkvth0we=0
+ pkvth0we=0                ku0we=-0.8e-3             lku0we=0
+ wku0we=0                  pku0we=0                  k2we=0
+ wk2we=0                   web=0                     wec=0
+ scref=1e-6                lnfactor=0+dlnfactorp_18  wnfactor=0+dwnfactorp_18
+ minr=1e-3

     16: type=p
+ lmin=1e-005-dxlp_18       lmax=0.0009001            wmin=4e-07
+ wmax=6e-007-dxwp_18       version=4.5               binunit=2
+ paramchk=1                mobmod=0                  capmod=2
+ igcmod=0                  igbmod=0                  geomod=0
+ diomod=1                  rdsmod=0                  rbodymod=0
+ rgatemod=0                permod=1                  acnqsmod=0
+ trnqsmod=0                tempmod=0                 tnom=25
+ toxe=toxp_18              toxm=toxp_18              dtox=3.312e-010
+ epsrox=3.9                wint=1e-008               lint=6.36e-009
+ ll=0                      wl=0                      lln=1
+ wln=1                     lw=0                      ww=0
+ lwn=1                     wwn=1                     lwl=0
+ wwl=0                     llc=0                     wlc=0
+ lwc=0                     wwc=0                     lwlc=0
+ wwlc=0                    xl=-5.5e-08+dxlp_18       xw=0+dxwp_18
+ dlc=dlcp_18               dwc=0                     xpart=1
+ toxref=3e-009             dlcig=6.95e-008           vth0=-0.4128+dvthp_18
+ wvth0=2.204e-009+dwvthp_18                          k1=0.47
+ k2=-0.0464+dk2p_18        wk2=3.306e-009            k3=-2.181735
+ k3b=1.642093              w0=0                      dvt0=0.02355
+ dvt1=0.04408725           dvt2=0.3556108            dvt0w=0
+ dvt1w=0                   dvt2w=0                   dsub=0.0468373
+ minv=-0.3                 voffl=0                   dvtp0=0
+ dvtp1=0                   lpe0=9.321426e-008        lpeb=1.240401e-007
+ xj=1.8e-007               ngate=2.68e+020           ndep=8.4e+017
+ nsd=1e+020                phin=0                    cdsc=0
+ cdscb=0                   cdscd=0                   cit=0.0007527
+ wcit=-2.12686e-010        voff=-0.14786             wvoff=1.03588e-008
+ nfactor=0.691             eta0=0.001                weta0=3.306e-010
+ etab=-0.001201            u0=0.01287596             ua=1.830046e-009
+ wua=-1.0109748e-016       ub=1.0154826e-018         wub=-2.0278518e-025
+ uc=-5.5801194e-011        wuc=1.7222232e-017        vsat=70000
+ a0=1.4301279              wa0=-1.7060062e-008       ags=0.52822238
+ wags=-1.187978e-008       a1=0                      a2=0.99
+ b0=0                      b1=0                      keta=-0.049938846
+ wketa=4.2405401e-009      dwg=0                     dwb=0
+ pclm=0.71                 pdiblc1=0                 pdiblc2=0.002453
+ pdiblcb=-0.042            drout=0                   pvag=0
+ delta=0.007               pscbe1=8.564e+008         pscbe2=1e-020
+ fprout=0                  pdits=0                   pditsd=0
+ pditsl=0                  rsh=9.68                  rdsw=456.4
+ prwg=0                    prwb=0                    wr=1
+ alpha0=0                  alpha1=0.09               beta0=17
+ agidl=1.56e-012           bgidl=8.66e+008           cgidl=0.25
+ egidl=0.2624              aigbacc=0.01213           bigbacc=0.006537
+ cigbacc=0.2809            nigbacc=4.05              aigbinv=0.35
+ bigbinv=0.03              cigbinv=0.006             eigbinv=1.1
+ nigbinv=1                 aigc=0.01                 bigc=0.00144
+ cigc=1.515e-005           aigsd=0.008379            bigsd=0.0002699
+ cigsd=3.925e-020          nigc=1                    poxedge=1
+ pigcd=2.171               ntox=1                    xrcrg1=12
+ xrcrg2=1                  cgso=cgop_18              cgdo=cgop_18
+ cgbo=0                    cgdl=cglp_18              cgsl=cglp_18
+ clc=1e-007                cle=0.6                   cf=cfp_18
+ ckappas=0.6               ckappad=0.6               acde=0.4
+ moin=5                    noff=1.9                  voffcv=-0.044
+ kt1=-0.195                kt1l=0                    kt2=-0.03
+ ute=-0.9569057            wute=-6.4893474e-008      ua1=2.5629675e-009
+ wua1=-3.3226953e-016      ub1=-3.4472151e-018       wub1=1.7238476e-025
+ uc1=-7.413638e-011        prt=0                     at=43800
+ wat=-0.002204             jss=1.9e-07               jsd=1.9e-07
+ jsws=1e-12                jswd=1e-12                jswgs=1e-12
+ jswgd=1e-12               njs=1                     njd=1
+ ijthsfwd=0.01             ijthdfwd=0.01             ijthsrev=0.01
+ ijthdrev=0.01             bvs=10                    bvd=10
+ xjbvs=1                   xjbvd=1                   pbs=0.752
+ pbd=0.752                 cjs=cjp_18                cjd=cjp_18
+ mjs=0.335                 mjd=0.335                 pbsws=0.752
+ pbswd=0.752               cjsws=cjswp_18            cjswd=cjswp_18
+ mjsws=0.01                mjswd=0.01                pbswgs=0.952
+ pbswgd=0.952              cjswgs=cjswgp_18          cjswgd=cjswgp_18
+ mjswgs=0.68               mjswgd=0.68               tpb=0.00174
+ tcj=0.000859              tpbsw=0.00137             tcjsw=0.0001
+ tpbswg=0.00289            tcjswg=0.000931           xtis=3
+ xtid=3                    jtsswgs=1.000e-08         jtsswgd=1.000e-08
+ njtsswg=40.31             xtsswgs=0.4558            xtsswgd=0.4558
+ tnjtsswg=1                dmcg=1.255e-007           dmci=1.255e-007
+ dmdg=0                    dmcgt=0                   dwj=0
+ xgw=0                     xgl=0                     rshg=1
+ gbmin=1e-012              rbpb=50                   rbpd=50
+ rbps=50                   rbdb=50                   rbsb=50
+ ngcon=1                   lvth0=0+dlvthp_18         lvsat=0+dlvsatp_18
+ lpclm=0+dlpclmp_18        lnfactor=0+dlnfactorp_18  saref=0.82e-6
+ sbref=0.82e-6             kvsat=-0.450              wlod=8e-7
+ tku0=0.3                  ku0=1.6e-7                llodku0=1
+ wlodku0=1                 lku0=7.43e-8              wku0=7.0e-7
+ pku0=0                    kvth0=0                   stk2=0
+ steta0=0                  lkvth0=0                  wkvth0=0
+ pkvth0=0                  llodvth=1                 wlodvth=1
+ lodk2=1                   lodeta0=1                 fnoimod=1
+ noia=2.0e+42              noib=2.2e+20              noic=5.0e+08
+ em=3.0e+07                ef=1.2e+00                tnoimod=0
+ lintnoi=-2.0e-8           ud=0                      wpemod=wpeflag_18
+ kvth0we=-4.0e-3           lkvth0we=0.0e-11          wkvth0we=0
+ pkvth0we=0                ku0we=-0.8e-3             lku0we=0
+ wku0we=0                  pku0we=0                  k2we=0
+ wk2we=0                   web=0                     wec=0
+ scref=1e-6                wnfactor=0+dwnfactorp_18  minr=1e-3

     17: type=p
+ lmin=1.2e-006-dxlp_18     lmax=1e-005-dxlp_18       wmin=4e-07
+ wmax=6e-007-dxwp_18       version=4.5               binunit=2
+ paramchk=1                mobmod=0                  capmod=2
+ igcmod=0                  igbmod=0                  geomod=0
+ diomod=1                  rdsmod=0                  rbodymod=0
+ rgatemod=0                permod=1                  acnqsmod=0
+ trnqsmod=0                tempmod=0                 tnom=25
+ toxe=toxp_18              toxm=toxp_18              dtox=3.312e-010
+ epsrox=3.9                wint=1e-008               lint=6.36e-009
+ ll=0                      wl=0                      lln=1
+ wln=1                     lw=0                      ww=0
+ lwn=1                     wwn=1                     lwl=0
+ wwl=0                     llc=0                     wlc=0
+ lwc=0                     wwc=0                     lwlc=0
+ wwlc=0                    xl=-5.5e-08+dxlp_18       xw=0+dxwp_18
+ dlc=dlcp_18               dwc=0                     xpart=1
+ toxref=3e-009             dlcig=6.95e-008           vth0=-0.41503883+dvthp_18
+ lvth0=2.223665e-008+dlvthp_18                       wvth0=3.054754e-009+dwvthp_18
+ pvth0=-8.4499271e-015     k1=0.47                   k2=-0.047133409+dk2p_18
+ lk2=7.2844199e-009        wk2=3.731377e-009         pk2=-4.2249636e-015
+ k3=-2.181735              k3b=1.642093              w0=0
+ dvt0=0.02355              dvt1=0.04408725           dvt2=0.3556108
+ dvt0w=0                   dvt1w=0                   dvt2w=0
+ dsub=0.0468373            minv=-0.3                 voffl=0
+ dvtp0=0                   dvtp1=0                   lpe0=9.321426e-008
+ lpeb=1.240401e-007        xj=1.8e-007               ngate=2.68e+020
+ ndep=8.4e+017             nsd=1e+020                phin=0
+ cdsc=0                    cdscb=0                   cdscd=0
+ cit=0.00081617201         lcit=-6.3042182e-010      wcit=-2.4203701e-010
+ pcit=2.9152249e-016       voff=-0.15271851          lvoff=4.8256087e-008
+ wvoff=1.183344e-008       pvoff=-1.464654e-014      nfactor=0.691
+ eta0=0.001                weta0=3.306e-010          etab=-0.001201
+ u0=0.01287596             ua=1.8460329e-009         lua=-1.5878681e-016
+ wua=-9.9691751e-017       pua=-1.3962096e-023       ub=1.0328875e-018
+ lub=-1.7287049e-025       wub=-2.0929869e-025       pub=6.4694077e-032
+ uc=-6.6146269e-011        luc=1.0275019e-016        wuc=2.1423278e-017
+ puc=-4.1725965e-023       vsat=70000                a0=1.427497
+ la0=2.6130876e-008        wa0=-1.9109245e-008       pa0=2.0353058e-014
+ ags=0.49913055            lags=2.8894824e-007       wags=-1.16394e-008
+ pags=-2.3875269e-015      a1=0                      a2=0.99
+ b0=0                      b1=0                      keta=-0.0483214
+ lketa=-1.6064929e-008     wketa=4.9289249e-009      pketa=-6.8372304e-015
+ dwg=0                     dwb=0                     pclm=0.69970655
+ lpclm=1.0223747e-007+dlpclmp_18                     pdiblc1=0
+ pdiblc2=0.0015451173      lpdiblc2=9.0173451e-009   pdiblcb=-0.047404064
+ lpdiblcb=5.3674673e-008   drout=0                   pvag=0
+ delta=0.007               pscbe1=8.564e+008         pscbe2=1e-020
+ fprout=0                  pdits=0                   pditsd=0
+ pditsl=0                  rsh=9.68                  rdsw=456.4
+ prwg=0                    prwb=0                    wr=1
+ alpha0=0                  alpha1=0.09               beta0=17
+ agidl=1.56e-012           bgidl=8.66e+008           cgidl=0.25
+ egidl=0.2624              aigbacc=0.01213           bigbacc=0.006537
+ cigbacc=0.2809            nigbacc=4.05              aigbinv=0.35
+ bigbinv=0.03              cigbinv=0.006             eigbinv=1.1
+ nigbinv=1                 aigc=0.01                 bigc=0.00144
+ cigc=1.515e-005           aigsd=0.008379            bigsd=0.0002699
+ cigsd=3.925e-020          nigc=1                    poxedge=1
+ pigcd=2.171               ntox=1                    xrcrg1=12
+ xrcrg2=1                  cgso=cgop_18              cgdo=cgop_18
+ cgbo=0                    cgdl=cglp_18              cgsl=cglp_18
+ clc=1e-007                cle=0.6                   cf=cfp_18
+ ckappas=0.6               ckappad=0.6               acde=0.4
+ moin=5                    noff=1.9                  voffcv=-0.044
+ kt1=-0.19451106           lkt1=-4.85628e-009        kt1l=0
+ kt2=-0.03                 ute=-1.1307554            lute=1.7267239e-006
+ wute=3.3943737e-010       pute=-6.4791154e-013      ua1=1.7928299e-009
+ lua1=7.6492226e-015       wua1=-4.900192e-018       pua1=-3.2515239e-021
+ ub1=-3.0218978e-018       lub1=-4.2243706e-024      wub1=-3.0019548e-026
+ pub1=2.0103362e-030       uc1=-7.413638e-011        prt=0
+ at=42308.736              lat=0.014811654           wat=-0.005479403
+ pat=3.2532219e-008        jss=1.9e-07               jsd=1.9e-07
+ jsws=1e-12                jswd=1e-12                jswgs=1e-12
+ jswgd=1e-12               njs=1                     njd=1
+ ijthsfwd=0.01             ijthdfwd=0.01             ijthsrev=0.01
+ ijthdrev=0.01             bvs=10                    bvd=10
+ xjbvs=1                   xjbvd=1                   pbs=0.752
+ pbd=0.752                 cjs=cjp_18                cjd=cjp_18
+ mjs=0.335                 mjd=0.335                 pbsws=0.752
+ pbswd=0.752               cjsws=cjswp_18            cjswd=cjswp_18
+ mjsws=0.01                mjswd=0.01                pbswgs=0.952
+ pbswgd=0.952              cjswgs=cjswgp_18          cjswgd=cjswgp_18
+ mjswgs=0.68               mjswgd=0.68               tpb=0.00174
+ tcj=0.000859              tpbsw=0.00137             tcjsw=0.0001
+ tpbswg=0.00289            tcjswg=0.000931           xtis=3
+ xtid=3                    jtsswgs=1.000e-08         jtsswgd=1.000e-08
+ njtsswg=40.31             xtsswgs=0.4558            xtsswgd=0.4558
+ tnjtsswg=1                dmcg=1.255e-007           dmci=1.255e-007
+ dmdg=0                    dmcgt=0                   dwj=0
+ xgw=0                     xgl=0                     rshg=1
+ gbmin=1e-012              rbpb=50                   rbpd=50
+ rbps=50                   rbdb=50                   rbsb=50
+ ngcon=1                   lvsat=0+dlvsatp_18        saref=0.82e-6
+ sbref=0.82e-6             kvsat=-0.450              wlod=8e-7
+ tku0=0.3                  ku0=1.6e-7                llodku0=1
+ wlodku0=1                 lku0=7.43e-8              wku0=7.0e-7
+ pku0=0                    kvth0=0                   stk2=0
+ steta0=0                  lkvth0=0                  wkvth0=0
+ pkvth0=0                  llodvth=1                 wlodvth=1
+ lodk2=1                   lodeta0=1                 fnoimod=1
+ noia=2.0e+42              noib=2.2e+20              noic=5.0e+08
+ em=3.0e+07                ef=1.2e+00                tnoimod=0
+ lintnoi=-2.0e-8           ud=0                      wpemod=wpeflag_18
+ kvth0we=-4.0e-3           lkvth0we=0.0e-11          wkvth0we=0
+ pkvth0we=0                ku0we=-0.8e-3             lku0we=0
+ wku0we=0                  pku0we=0                  k2we=0
+ wk2we=0                   web=0                     wec=0
+ scref=1e-6                lnfactor=0+dlnfactorp_18  wnfactor=0+dwnfactorp_18
+ minr=1e-3

     18: type=p
+ lmin=7e-007-dxlp_18       lmax=1.2e-006-dxlp_18     wmin=4e-07
+ wmax=6e-007-dxwp_18       version=4.5               binunit=2
+ paramchk=1                mobmod=0                  capmod=2
+ igcmod=0                  igbmod=0                  geomod=0
+ diomod=1                  rdsmod=0                  rbodymod=0
+ rgatemod=0                permod=1                  acnqsmod=0
+ trnqsmod=0                tempmod=0                 tnom=25
+ toxe=toxp_18              toxm=toxp_18              dtox=3.312e-010
+ epsrox=3.9                wint=1e-008               lint=6.36e-009
+ ll=0                      wl=0                      lln=1
+ wln=1                     lw=0                      ww=0
+ lwn=1                     wwn=1                     lwl=0
+ wwl=0                     llc=0                     wlc=0
+ lwc=0                     wwc=0                     lwlc=0
+ wwlc=0                    xl=-5.5e-08+dxlp_18       xw=0+dxwp_18
+ dlc=dlcp_18               dwc=0                     xpart=1
+ toxref=3e-009             dlcig=6.95e-008           vth0=-0.38174275+dvthp_18
+ lvth0=-1.5463829e-008+dlvthp_18                     wvth0=-7.1950902e-009+dwvthp_18
+ pvth0=3.1557665e-015      k1=0.47                   k2=-0.07010102+dk2p_18
+ lk2=3.3290187e-008        wk2=1.3935451e-008        pk2=-1.5778833e-014
+ k3=-2.181735              k3b=1.642093              w0=0
+ dvt0=0.02355              dvt1=0.04408725           dvt2=0.3556108
+ dvt0w=0                   dvt1w=0                   dvt2w=0
+ dsub=0.0468373            minv=-0.3                 voffl=0
+ dvtp0=0                   dvtp1=0                   lpe0=9.321426e-008
+ lpeb=1.240401e-007        xj=1.8e-007               ngate=2.68e+020
+ ndep=8.4e+017             nsd=1e+020                phin=0
+ cdsc=0                    cdscb=0                   cdscd=0
+ cit=-0.00029776514        lcit=6.3086694e-010       wcit=3.4937632e-011
+ pcit=-2.2090366e-017      voff=-0.10390366          lvoff=-7.0159964e-009
+ wvoff=-2.4955451e-009     pvoff=1.5778833e-015      nfactor=0.691
+ eta0=0.001                weta0=3.306e-010          etab=-0.0042384731
+ letab=3.4392701e-009      u0=0.01287596             ua=1.4179784e-009
+ lua=3.2589074e-016        wua=4.7323602e-017        pua=-1.8042464e-022
+ ub=1.3069282e-018         lub=-4.8316124e-025       wub=-3.7944919e-025
+ pub=2.5735208e-031        uc=3.1201003e-011         luc=-7.4741839e-018
+ wuc=-2.0723471e-017       puc=5.9959564e-024        vsat=70000
+ a0=2.4134762              la0=-1.0902737e-006       wa0=-2.5288485e-007
+ pa0=2.850525e-013         ags=0.50707801            lags=2.7994948e-007
+ wags=-3.9745143e-008      pags=2.9436044e-014       a1=0
+ a2=0.99                   b0=0                      b1=0
+ keta=0.031930675          lketa=-1.0693275e-007     wketa=-3.0115343e-008
+ pketa=3.2842694e-014      dwg=0                     dwb=0
+ pclm=0.8911648            lpclm=-1.1454688e-007+dlpclmp_18
+ pdiblc1=0                 pdiblc2=0.019084122       lpdiblc2=-1.0841719e-008
+ wpdiblc2=-4.6000924e-009  ppdiblc2=5.2085927e-015   pdiblcb=0.98682746
+ lpdiblcb=-1.117365e-006   wpdiblcb=-1.9623624e-007  ppdiblcb=2.2219437e-013
+ drout=0                   pvag=0                    delta=0.007
+ pscbe1=8.564e+008         pscbe2=1e-020             fprout=0
+ pdits=0                   pditsd=0                  pditsl=0
+ rsh=9.68                  rdsw=456.4                prwg=0
+ prwb=0                    wr=1                      alpha0=0
+ alpha1=0.09               beta0=17                  agidl=1.56e-012
+ bgidl=8.66e+008           cgidl=0.25                egidl=0.2624
+ aigbacc=0.01213           bigbacc=0.006537          cigbacc=0.2809
+ nigbacc=4.05              aigbinv=0.35              bigbinv=0.03
+ cigbinv=0.006             eigbinv=1.1               nigbinv=1
+ aigc=0.01                 bigc=0.00144              cigc=1.515e-005
+ aigsd=0.008379            bigsd=0.0002699           cigsd=3.925e-020
+ nigc=1                    poxedge=1                 pigcd=2.171
+ ntox=1                    xrcrg1=12                 xrcrg2=1
+ cgso=cgop_18              cgdo=cgop_18              cgbo=0
+ cgdl=cglp_18              cgsl=cglp_18              clc=1e-007
+ cle=0.6                   cf=cfp_18                 ckappas=0.6
+ ckappad=0.6               acde=0.4                  moin=5
+ noff=1.9                  voffcv=-0.044             kt1=-0.2240912
+ lkt1=2.863672e-008        wkt1=1.1148361e-008       pkt1=-1.2623066e-014
+ kt1l=0                    kt2=-0.03                 ute=1.9576628
+ lute=-1.7702303e-006      wute=-1.2154109e-006      pute=7.2865829e-013
+ ua1=1.6373846e-008        lua1=-8.8605701e-015      wua1=-5.97023e-015
+ pua1=3.5028998e-021       ub1=-9.8702424e-018       lub1=3.5298731e-024
+ wub1=3.0071515e-024       pub1=-1.4285918e-030      uc1=-6.3510573e-011
+ luc1=-1.2031389e-017      prt=0                     at=-9494.5736
+ lat=0.073467505           wat=0.066591453           pat=-4.907217e-008
+ jss=1.9e-07               jsd=1.9e-07               jsws=1e-12
+ jswd=1e-12                jswgs=1e-12               jswgd=1e-12
+ njs=1                     njd=1                     ijthsfwd=0.01
+ ijthdfwd=0.01             ijthsrev=0.01             ijthdrev=0.01
+ bvs=10                    bvd=10                    xjbvs=1
+ xjbvd=1                   pbs=0.752                 pbd=0.752
+ cjs=cjp_18                cjd=cjp_18                mjs=0.335
+ mjd=0.335                 pbsws=0.752               pbswd=0.752
+ cjsws=cjswp_18            cjswd=cjswp_18            mjsws=0.01
+ mjswd=0.01                pbswgs=0.952              pbswgd=0.952
+ cjswgs=cjswgp_18          cjswgd=cjswgp_18          mjswgs=0.68
+ mjswgd=0.68               tpb=0.00174               tcj=0.000859
+ tpbsw=0.00137             tcjsw=0.0001              tpbswg=0.00289
+ tcjswg=0.000931           xtis=3                    xtid=3
+ jtsswgs=1.000e-08         jtsswgd=1.000e-08         njtsswg=40.31
+ xtsswgs=0.4558            xtsswgd=0.4558            tnjtsswg=1
+ dmcg=1.255e-007           dmci=1.255e-007           dmdg=0
+ dmcgt=0                   dwj=0                     xgw=0
+ xgl=0                     rshg=1                    gbmin=1e-012
+ rbpb=50                   rbpd=50                   rbps=50
+ rbdb=50                   rbsb=50                   ngcon=1
+ saref=0.82e-6             sbref=0.82e-6             kvsat=-0.450
+ wlod=8e-7                 tku0=0.3                  ku0=1.6e-7
+ llodku0=1                 wlodku0=1                 lku0=7.43e-8
+ wku0=7.0e-7               pku0=0                    kvth0=0
+ stk2=0                    steta0=0                  lkvth0=0
+ wkvth0=0                  pkvth0=0                  llodvth=1
+ wlodvth=1                 lodk2=1                   lodeta0=1
+ fnoimod=1                 noia=2.0e+42              noib=2.2e+20
+ noic=5.0e+08              em=3.0e+07                ef=1.2e+00
+ tnoimod=0                 lintnoi=-2.0e-8           ud=0
+ wpemod=wpeflag_18         kvth0we=-4.0e-3           lkvth0we=0.0e-11
+ wkvth0we=0                pkvth0we=0                ku0we=-0.8e-3
+ lku0we=0                  wku0we=0                  pku0we=0
+ k2we=0                    wk2we=0                   web=0
+ wec=0                     scref=1e-6                lvsat=0+dlvsatp_18
+ lnfactor=0+dlnfactorp_18  wnfactor=0+dwnfactorp_18  minr=1e-3

     19: type=p
+ lmin=4e-007-dxlp_18       lmax=7e-007-dxlp_18       wmin=4e-07
+ wmax=6e-007-dxwp_18       version=4.5               binunit=2
+ paramchk=1                mobmod=0                  capmod=2
+ igcmod=0                  igbmod=0                  geomod=0
+ diomod=1                  rdsmod=0                  rbodymod=0
+ rgatemod=0                permod=1                  acnqsmod=0
+ trnqsmod=0                tempmod=0                 tnom=25
+ toxe=toxp_18              toxm=toxp_18              dtox=3.312e-010
+ epsrox=3.9                wint=1e-008               lint=6.36e-009
+ ll=0                      wl=0                      lln=1
+ wln=1                     lw=0                      ww=0
+ lwn=1                     wwn=1                     lwl=0
+ wwl=0                     llc=0                     wlc=0
+ lwc=0                     wwc=0                     lwlc=0
+ wwlc=0                    xl=-5.5e-08+dxlp_18       xw=0+dxwp_18
+ dlc=dlcp_18               dwc=0                     xpart=1
+ toxref=3e-009             dlcig=6.95e-008           vth0=-0.40361929+dvthp_18
+ lvth0=-1.6317301e-009+dlvthp_18                     wvth0=6.0332296e-010+dwvthp_18
+ pvth0=-1.7750142e-015     k1=0.47                   k2=0.02524798+dk2p_18
+ lk2=-2.6997079e-008       wk2=-2.3225752e-008       pk2=7.7174529e-015
+ k3=-2.181735              k3b=1.642093              w0=0
+ dvt0=0.02355              dvt1=0.04408725           dvt2=0.3556108
+ dvt0w=0                   dvt1w=0                   dvt2w=0
+ dsub=0.0468373            minv=-0.3                 voffl=0
+ dvtp0=0                   dvtp1=0                   lpe0=9.321426e-008
+ lpeb=1.240401e-007        xj=1.8e-007               ngate=2.68e+020
+ ndep=8.4e+017             nsd=1e+020                phin=0
+ cdsc=0                    cdscb=0                   cdscd=0
+ cit=0.001652536           lcit=-6.0226946e-010      wcit=-4.8823008e-010
+ pcit=3.0869811e-016       voff=-0.052287688         lvoff=-3.9651741e-008
+ wvoff=-2.1726239e-008     pvoff=1.3737066e-014      nfactor=0.691
+ eta0=0.001                weta0=3.306e-010          etab=0.0038614552
+ letab=-1.6821526e-009     u0=0.011507253            lu0=8.6540589e-010
+ wu0=7.938499e-010         pu0=-5.0193542e-016       ua=2.2590928e-009
+ lua=-2.0592902e-016       wua=-2.8729808e-016       pua=3.1149955e-023
+ ub=-9.4626389e-020        lub=4.0301368e-025        wub=2.2457787e-025
+ pub=-1.2456215e-031       uc=4.8348884e-011         luc=-1.8316446e-017
+ wuc=-1.5981553e-017       puc=2.9977365e-024        vsat=70000
+ a0=0.063210311            la0=3.9575245e-007        wa0=5.158015e-007
+ pa0=-2.0097251e-013       ags=0.47780557            lags=2.9845786e-007
+ wags=-1.4568243e-007      pags=9.6418075e-014       a1=0
+ a2=0.99                   b0=0                      b1=0
+ keta=-0.1783854           lketa=2.6045902e-008      wketa=4.6004548e-008
+ pketa=-1.5286391e-014     dwg=0                     dwb=0
+ pclm=0.71                 pdiblc1=0                 pdiblc2=-0.0070033364
+ lpdiblc2=5.6528592e-009   wpdiblc2=7.6668207e-009   ppdiblc2=-2.5475312e-015
+ pdiblcb=-2.030894         lpdiblcb=7.9067994e-007   wpdiblcb=6.7246853e-007
+ ppdiblcb=-3.2707028e-013  drout=0                   pvag=0
+ delta=0.007               pscbe1=8.564e+008         pscbe2=1e-020
+ fprout=0                  pdits=0                   pditsd=0
+ pditsl=0                  rsh=9.68                  rdsw=456.4
+ prwg=0                    prwb=0                    wr=1
+ alpha0=0                  alpha1=0.09               beta0=17
+ agidl=1.56e-012           bgidl=8.66e+008           cgidl=0.25
+ egidl=0.2624              aigbacc=0.01213           bigbacc=0.006537
+ cigbacc=0.2809            nigbacc=4.05              aigbinv=0.35
+ bigbinv=0.03              cigbinv=0.006             eigbinv=1.1
+ nigbinv=1                 aigc=0.01                 bigc=0.00144
+ cigc=1.515e-005           aigsd=0.008379            bigsd=0.0002699
+ cigsd=3.925e-020          nigc=1                    poxedge=1
+ pigcd=2.171               ntox=1                    xrcrg1=12
+ xrcrg2=1                  cgso=cgop_18              cgdo=cgop_18
+ cgbo=0                    cgdl=cglp_18              cgsl=cglp_18
+ clc=1e-007                cle=0.6                   cf=cfp_18
+ ckappas=0.6               ckappad=0.6               acde=0.4
+ moin=5                    noff=1.9                  voffcv=-0.044
+ kt1=-0.10879968           lkt1=-4.4259802e-008      wkt1=-4.0550955e-008
+ pkt1=2.0065377e-014       kt1l=0                    kt2=-0.03
+ ute=-0.55294963           lute=-1.8282025e-007      wute=-1.6468157e-007
+ pute=6.4303129e-014       ua1=3.7425846e-009        lua1=-8.7407626e-016
+ wua1=-1.1466884e-015      pua1=4.5307082e-022       ub1=-5.751756e-018
+ lub1=9.2583649e-025       wub1=1.6393795e-024       pub1=-5.6377691e-031
+ uc1=-9.1846058e-011       luc1=5.8845718e-018       prt=0
+ at=162523.04              lat=-0.035295792          wat=-0.014681726
+ pat=2.3152359e-009        jss=1.9e-07               jsd=1.9e-07
+ jsws=1e-12                jswd=1e-12                jswgs=1e-12
+ jswgd=1e-12               njs=1                     njd=1
+ ijthsfwd=0.01             ijthdfwd=0.01             ijthsrev=0.01
+ ijthdrev=0.01             bvs=10                    bvd=10
+ xjbvs=1                   xjbvd=1                   pbs=0.752
+ pbd=0.752                 cjs=cjp_18                cjd=cjp_18
+ mjs=0.335                 mjd=0.335                 pbsws=0.752
+ pbswd=0.752               cjsws=cjswp_18            cjswd=cjswp_18
+ mjsws=0.01                mjswd=0.01                pbswgs=0.952
+ pbswgd=0.952              cjswgs=cjswgp_18          cjswgd=cjswgp_18
+ mjswgs=0.68               mjswgd=0.68               tpb=0.00174
+ tcj=0.000859              tpbsw=0.00137             tcjsw=0.0001
+ tpbswg=0.00289            tcjswg=0.000931           xtis=3
+ xtid=3                    jtsswgs=1.000e-08         jtsswgd=1.000e-08
+ njtsswg=40.31             xtsswgs=0.4558            xtsswgd=0.4558
+ tnjtsswg=1                dmcg=1.255e-007           dmci=1.255e-007
+ dmdg=0                    dmcgt=0                   dwj=0
+ xgw=0                     xgl=0                     rshg=1
+ gbmin=1e-012              rbpb=50                   rbpd=50
+ rbps=50                   rbdb=50                   rbsb=50
+ ngcon=1                   lvsat=0+dlvsatp_18        lpclm=0+dlpclmp_18
+ saref=0.82e-6             sbref=0.82e-6             kvsat=-0.450
+ wlod=8e-7                 tku0=0.3                  ku0=1.6e-7
+ llodku0=1                 wlodku0=1                 lku0=7.43e-8
+ wku0=7.0e-7               pku0=0                    kvth0=0
+ stk2=0                    steta0=0                  lkvth0=0
+ wkvth0=0                  pkvth0=0                  llodvth=1
+ wlodvth=1                 lodk2=1                   lodeta0=1
+ fnoimod=1                 noia=2.0e+42              noib=2.2e+20
+ noic=5.0e+08              em=3.0e+07                ef=1.2e+00
+ tnoimod=0                 lintnoi=-2.0e-8           ud=0
+ wpemod=wpeflag_18         kvth0we=-4.0e-3           lkvth0we=0.0e-11
+ wkvth0we=0                pkvth0we=0                ku0we=-0.8e-3
+ lku0we=0                  wku0we=0                  pku0we=0
+ k2we=0                    wk2we=0                   web=0
+ wec=0                     scref=1e-6                lnfactor=0+dlnfactorp_18
+ wnfactor=0+dwnfactorp_18  minr=1e-3

     20: type=p
+ lmin=2e-07                lmax=4e-007-dxlp_18       wmin=4e-07
+ wmax=6e-007-dxwp_18       version=4.5               binunit=2
+ paramchk=1                mobmod=0                  capmod=2
+ igcmod=0                  igbmod=0                  geomod=0
+ diomod=1                  rdsmod=0                  rbodymod=0
+ rgatemod=0                permod=1                  acnqsmod=0
+ trnqsmod=0                tempmod=0                 tnom=25
+ toxe=toxp_18              toxm=toxp_18              dtox=3.312e-010
+ epsrox=3.9                wint=1e-008               lint=6.36e-009
+ ll=0                      wl=0                      lln=1
+ wln=1                     lw=0                      ww=0
+ lwn=1                     wwn=1                     lwl=0
+ wwl=0                     llc=0                     wlc=0
+ lwc=0                     wwc=0                     lwlc=0
+ wwlc=0                    xl=-5.5e-08+dxlp_18       xw=0+dxwp_18
+ dlc=dlcp_18               dwc=0                     xpart=1
+ toxref=3e-009             dlcig=6.95e-008           vth0=-0.39962094+dvthp_18
+ lvth0=-2.9603018e-009+dlvthp_18                     wvth0=-7.87271e-009+dwvthp_18
+ pvth0=1.0414021e-015      k1=0.47                   k2=-0.03060224+dk2p_18
+ lk2=-8.4391677e-009       k3=-2.181735              k3b=1.642093
+ w0=0                      dvt0=0.02355              dvt1=0.04408725
+ dvt2=0.3556108            dvt0w=0                   dvt1w=0
+ dvt2w=0                   dsub=0.0468373            minv=-0.3
+ voffl=0                   dvtp0=0                   dvtp1=0
+ lpe0=9.321426e-008        lpeb=1.240401e-007        xj=1.8e-007
+ ngate=2.68e+020           ndep=8.4e+017             nsd=1e+020
+ phin=0                    cdsc=0                    cdscb=0
+ cdscd=0                   cit=-0.001596373          lcit=4.7727801e-010
+ wcit=1.0207124e-009       pcit=-1.9269329e-016      voff=-0.17421269
+ lvoff=8.6149837e-010      wvoff=2.1656416e-008      pvoff=-6.7812229e-016
+ nfactor=0.691             eta0=0.001                weta0=3.306e-010
+ etab=-0.001201            u0=0.015358904            lu0=-4.1442049e-010
+ wu0=-1.1907749e-009       pu0=1.575157e-016         ua=1.7689138e-009
+ lua=-4.3052348e-017       wua=-3.8242729e-016       pua=6.2759491e-023
+ ub=1.3265853e-018         lub=-6.9226524e-026       wub=-1.4125687e-025
+ pub=-3.0025831e-033       uc=-2.0559737e-012        luc=-1.5679198e-018
+ wuc=-8.5292445e-018       puc=5.214833e-025         vsat=70000
+ a0=1.3483097              la0=-3.1260369e-008       wa0=-2.8850755e-007
+ pa0=6.6283305e-014        ags=-0.58952374           lags=6.5311004e-007
+ wags=4.6185017e-007       pags=-1.0545286e-013      a1=0
+ a2=0.99                   b0=0                      b1=0
+ keta=-0.1                 dwg=0                     dwb=0
+ pclm=0.85828588           lpclm=-4.9272432e-008+dlpclmp_18
+ pdiblc1=0                 pdiblc2=0.014408104       lpdiblc2=-1.4617342e-009
+ pdiblcb=-0.55009556       lpdiblcb=2.9864022e-007   wpdiblcb=-8.8952392e-008
+ ppdiblcb=-7.406534e-014   drout=0                   pvag=0
+ delta=0.007               pscbe1=8.564e+008         pscbe2=1e-020
+ fprout=0                  pdits=0                   pditsd=0
+ pditsl=0                  rsh=9.68                  rdsw=456.4
+ prwg=0                    prwb=0                    wr=1
+ alpha0=0                  alpha1=0.09               beta0=17
+ agidl=1.56e-012           bgidl=8.66e+008           cgidl=0.25
+ egidl=0.2624              aigbacc=0.01213           bigbacc=0.006537
+ cigbacc=0.2809            nigbacc=4.05              aigbinv=0.35
+ bigbinv=0.03              cigbinv=0.006             eigbinv=1.1
+ nigbinv=1                 aigc=0.01                 bigc=0.00144
+ cigc=1.515e-005           aigsd=0.008379            bigsd=0.0002699
+ cigsd=3.925e-020          nigc=1                    poxedge=1
+ pigcd=2.171               ntox=1                    xrcrg1=12
+ xrcrg2=1                  cgso=cgop_18              cgdo=cgop_18
+ cgbo=0                    cgdl=cglp_18              cgsl=cglp_18
+ clc=1e-007                cle=0.6                   cf=cfp_18
+ ckappas=0.6               ckappad=0.6               acde=0.4
+ moin=5                    noff=1.9                  voffcv=-0.044
+ kt1=-0.27824538           lkt1=1.2043615e-008       wkt1=3.5863693e-008
+ pkt1=-5.3256818e-015      kt1l=0                    kt2=-0.03
+ ute=-1.3172832            lute=7.1152513e-008       wute=9.9735825e-008
+ pute=-2.3557484e-014      ua1=6.6959534e-010        lua1=1.4701661e-016
+ wua1=4.1491077e-016       pua1=-6.5817338e-023      ub1=-3.103874e-018
+ lub1=4.5998255e-026       wub1=-1.633529e-027       pub1=-1.8501113e-032
+ uc1=-5.3478464e-011       luc1=-6.8642124e-018      prt=0
+ at=90705.499              lat=-0.011432259          wat=-0.017311665
+ pat=3.1891122e-009        jss=1.9e-07               jsd=1.9e-07
+ jsws=1e-12                jswd=1e-12                jswgs=1e-12
+ jswgd=1e-12               njs=1                     njd=1
+ ijthsfwd=0.01             ijthdfwd=0.01             ijthsrev=0.01
+ ijthdrev=0.01             bvs=10                    bvd=10
+ xjbvs=1                   xjbvd=1                   pbs=0.752
+ pbd=0.752                 cjs=cjp_18                cjd=cjp_18
+ mjs=0.335                 mjd=0.335                 pbsws=0.752
+ pbswd=0.752               cjsws=cjswp_18            cjswd=cjswp_18
+ mjsws=0.01                mjswd=0.01                pbswgs=0.952
+ pbswgd=0.952              cjswgs=cjswgp_18          cjswgd=cjswgp_18
+ mjswgs=0.68               mjswgd=0.68               tpb=0.00174
+ tcj=0.000859              tpbsw=0.00137             tcjsw=0.0001
+ tpbswg=0.00289            tcjswg=0.000931           xtis=3
+ xtid=3                    jtsswgs=1.000e-08         jtsswgd=1.000e-08
+ njtsswg=40.31             xtsswgs=0.4558            xtsswgd=0.4558
+ tnjtsswg=1                dmcg=1.255e-007           dmci=1.255e-007
+ dmdg=0                    dmcgt=0                   dwj=0
+ xgw=0                     xgl=0                     rshg=1
+ gbmin=1e-012              rbpb=50                   rbpd=50
+ rbps=50                   rbdb=50                   rbsb=50
+ ngcon=1                   lvsat=0+dlvsatp_18        lnfactor=0+dlnfactorp_18
+ saref=0.82e-6             sbref=0.82e-6             kvsat=-0.450
+ wlod=8e-7                 tku0=0.3                  ku0=1.6e-7
+ llodku0=1                 wlodku0=1                 lku0=7.43e-8
+ wku0=7.0e-7               pku0=0                    kvth0=0
+ stk2=0                    steta0=0                  lkvth0=0
+ wkvth0=0                  pkvth0=0                  llodvth=1
+ wlodvth=1                 lodk2=1                   lodeta0=1
+ fnoimod=1                 noia=2.0e+42              noib=2.2e+20
+ noic=5.0e+08              em=3.0e+07                ef=1.2e+00
+ tnoimod=0                 lintnoi=-2.0e-8           ud=0
+ wpemod=wpeflag_18         kvth0we=-4.0e-3           lkvth0we=0.0e-11
+ wkvth0we=0                pkvth0we=0                ku0we=-0.8e-3
+ lku0we=0                  wku0we=0                  pku0we=0
+ k2we=0                    wk2we=0                   web=0
+ wec=0                     scref=1e-6                wnfactor=0+dwnfactorp_18
+ minr=1e-3

     }
endsection mos_18

section mos_33
//  ********************************************************************************************
//
//                *
//                                    3.3V NMOS DEVICE MODELS
//                  *
//
//                *
//  ********************************************************************************************

model nch_33 bsim4  {
     1: type=n
+ lmin=1e-005-dxln_33       lmax=0.0009001            wmin=1e-005-dxwn_33
+ wmax=0.0009001            version=4.5               binunit=2
+ paramchk=1                mobmod=0                  capmod=2
+ igcmod=0                  igbmod=0                  geomod=0
+ diomod=1                  rdsmod=0                  rbodymod=0
+ rgatemod=0                permod=1                  acnqsmod=0
+ trnqsmod=0                tempmod=0                 wpemod=wpeflag_33
+ tnom=25                   toxe=toxn_33              toxm=toxn_33
+ dtox=2.78e-010            epsrox=3.9                wint=5.05e-008
+ lint=6.25e-009            ll=0                      wl=0
+ lln=1                     wln=1                     lw=0
+ ww=0                      lwn=1                     wwn=1
+ lwl=0                     wwl=0                     llc=0
+ wlc=0                     lwc=0                     wwc=0
+ lwlc=0                    wwlc=0                    xl=-1.5e-08+dxln_33
+ xw=0+dxwn_33              dlc=5.318e-8              dwc=0
+ xpart=1                   toxref=3e-009             dlcig=6.25e-009
+ vth0=0.56307+dvthn_33     k1=0.56256                k2=0.04794+dk2n_33
+ k3=-3.628                 k3b=0.8                   w0=0
+ dvt0=11.761               dvt1=0.4                  dvt2=-0.115
+ dvt0w=0                   dvt1w=0                   dvt2w=0
+ dsub=0.17                 minv=-0.3                 voffl=0
+ dvtp0=1.4e-006            dvtp1=0.06                lpe0=1e-007
+ lpeb=0                    web=0                     wec=0
+ scref=1e-06               kvth0we=0.023             lkvth0we=0
+ wkvth0we=0                pkvth0we=0                k2we=0
+ lk2we=0                   wk2we=0                   pk2we=0
+ xj=1.5e-007               ngate=3.26e+020           ndep=4.2e+017
+ nsd=1e+020                phin=0                    cdsc=0
+ cdscb=0                   cdscd=0                   cit=0.00018276
+ voff=-0.07611             nfactor=1                 eta0=0.061
+ etab=-0.028               ud=0                      lud=0
+ wud=0                     pud=0                     ku0we=-0.006
+ lku0we=0                  wku0we=0                  pku0we=0
+ u0=400+du0n_33            ua=-4.1069999e-010        ub=2.2114e-018
+ uc=9.2e-011               vsat=80500                a0=1.334253
+ ags=0.2751499             a1=0                      a2=0.8
+ b0=0                      b1=0                      keta=-0.03
+ dwg=0                     dwb=0                     pclm=0.2
+ pdiblc1=0                 pdiblc2=0.00095           pdiblcb=0
+ drout=0.56                pvag=0                    delta=0.012
+ pscbe1=7.506e+008         pscbe2=1e-020             fprout=0
+ pdits=0                   pditsd=0                  pditsl=0
+ rsh=10.5                  rdsw=700+drdswn_33        prwg=0
+ prwb=0                    wr=1                      alpha0=0
+ alpha1=2.2950             beta0=17.8                agidl=0
+ bgidl=1.698e+009          cgidl=0.25                egidl=0.2624
+ aigbacc=0.01213           bigbacc=0.006537          cigbacc=0.2809
+ nigbacc=4.05              aigbinv=0.35              bigbinv=0.03
+ cigbinv=0.006             eigbinv=1.1               nigbinv=1
+ aigc=0.01                 bigc=0.00144              cigc=1.515e-005
+ aigsd=0.008379            bigsd=0.0002699           cigsd=3.925e-020
+ nigc=1                    poxedge=1                 pigcd=2.171
+ ntox=1                    xrcrg1=12                 xrcrg2=1
+ cgso=cgon_33              cgdo=cgon_33              cgbo=0
+ cgdl=cgln_33              cgsl=cgln_33              clc=1e-007
+ cle=0.6                   cf=cfn_33                 ckappas=0.6
+ ckappad=0.6               acde=0.4                  moin=5
+ noff=1.4479               voffcv=-0.0921            kt1=-0.3078
+ kt1l=0                    kt2=-0.02                 ute=-1.6854
+ ua1=7.3967e-010           ub1=-1.3408e-018          uc1=-6e-011
+ prt=0                     at=30000                  fnoimod=1
+ tnoimod=0                 noia=5.3e41               noib=1e20
+ noic=10000000             em=10000000               ef=0.8
+ jss=4.1e-07               jsd=4.1e-07               jsws=1.55e-12
+ jswd=1.55e-12             jswgs=1.6e-012            jswgd=1.6e-012
+ njs=1                     njd=1                     ijthsfwd=0.01
+ ijthdfwd=0.01             ijthsrev=0.01             ijthdrev=0.01
+ bvs=10                    bvd=10                    xjbvs=1
+ xjbvd=1                   pbs=0.7126                pbd=0.7126
+ cjs=cjn_33                cjd=cjn_33                mjs=0.3234
+ mjd=0.3234                pbsws=0.5345              pbswd=0.5345
+ cjsws=cjswn_33            cjswd=cjswn_33            mjsws=0.1391
+ mjswd=0.1391              pbswgs=0.73               pbswgd=0.73
+ cjswgs=cjswgn_33          cjswgd=cjswgn_33          mjswgs=0.5126
+ mjswgd=0.5126             tpb=0.0015                tcj=0.000891
+ tpbsw=0.00139             tcjsw=0.000445            tpbswg=0.0014
+ tcjswg=0.00129            xtis=3                    xtid=3
+ dmcg=1.125e-007           dmci=1.125e-007           dmdg=0
+ dmcgt=0                   dwj=0                     xgw=0
+ xgl=0                     rshg=1                    gbmin=1e-012
+ rbpb=50                   rbpd=50                   rbps=50
+ rbdb=50                   rbsb=50                   ngcon=1
+ saref=8.2e-07             sbref=8.2e-07             wlod=1.5e-07
+ kvth0=0                   lkvth0=0                  wkvth0=0
+ pkvth0=0                  llodvth=1                 wlodvth=1
+ stk2=0                    lodk2=1                   lodeta0=1
+ ku0=-8e-08                lku0=2.5e-07              wku0=3e-07
+ pku0=5e-14                llodku0=1                 wlodku0=1
+ kvsat=0.3                 steta0=0                  tku0=0.1
+ lvth0=0+dlvthn_33         wvth0=0+dwvthn_33         lu0=0+dlu0n_33
+ minr=1e-3

     2: type=n
+ lmin=1.2e-006-dxln_33     lmax=1e-005-dxln_33       wmin=1e-005-dxwn_33
+ wmax=0.0009001            version=4.5               binunit=2
+ paramchk=1                mobmod=0                  capmod=2
+ igcmod=0                  igbmod=0                  geomod=0
+ diomod=1                  rdsmod=0                  rbodymod=0
+ rgatemod=0                permod=1                  acnqsmod=0
+ trnqsmod=0                tempmod=0                 wpemod=wpeflag_33
+ tnom=25                   toxe=toxn_33              toxm=toxn_33
+ dtox=2.78e-010            epsrox=3.9                wint=5.05e-008
+ lint=6.25e-009            ll=0                      wl=0
+ lln=1                     wln=1                     lw=0
+ ww=0                      lwn=1                     wwn=1
+ lwl=0                     wwl=0                     llc=0
+ wlc=0                     lwc=0                     wwc=0
+ lwlc=0                    wwlc=0                    xl=-1.5e-08+dxln_33
+ xw=0+dxwn_33              dlc=5.318e-8              dwc=0
+ xpart=1                   toxref=3e-009             dlcig=6.25e-009
+ vth0=0.56214666+dvthn_33  lvth0=9.2080455e-009+dlvthn_33
+ k1=0.56256                k2=0.048073239+dk2n_33    lk2=-1.3287223e-009
+ k3=-3.628                 k3b=0.8                   w0=0
+ dvt0=11.761               dvt1=0.4                  dvt2=-0.115
+ dvt0w=0                   dvt1w=0                   dvt2w=0
+ dsub=0.17                 minv=-0.3                 voffl=0
+ dvtp0=1.4e-006            dvtp1=0.06                lpe0=1e-007
+ lpeb=0                    web=0                     wec=0
+ scref=1e-06               kvth0we=0.023             lkvth0we=0
+ wkvth0we=0                pkvth0we=0                k2we=0
+ lk2we=0                   wk2we=0                   pk2we=0
+ xj=1.5e-007               ngate=3.26e+020           ndep=4.2e+017
+ nsd=1e+020                phin=0                    cdsc=0
+ cdscb=0                   cdscd=0                   cit=0.00018046297
+ lcit=2.2907172e-011       voff=-0.075040094         lvoff=-1.066964e-008
+ wvoff=1.3335989e-015      pvoff=-1.3299316e-020     nfactor=1
+ eta0=0.061                etab=-0.028               ud=0
+ lud=0                     wud=0                     pud=0
+ ku0we=-0.006              lku0we=0                  wku0we=0
+ pku0we=0                  u0=400+du0n_33            ua=-4.0025766e-010
+ lua=-1.0413611e-016       wua=-2.6671981e-023       pua=2.6598632e-028
+ ub=2.2631442e-018         lub=-5.1601861e-025       uc=9.3865341e-011
+ luc=-1.8602112e-017       wuc=1.3335992e-024        puc=-1.3299316e-029
+ vsat=80500                a0=1.4250971              la0=-9.059428e-007
+ wa0=-1.3335986e-014       pa0=1.3299316e-019        ags=0.26897638
+ lags=6.1565418e-008       a1=0                      a2=0.8
+ b0=0                      b1=0                      keta=-0.028108011
+ lketa=-1.8867857e-008     dwg=0                     dwb=0
+ pclm=0.2                  pdiblc1=0                 pdiblc2=0.00073015625
+ lpdiblc2=2.1923918e-009   pdiblcb=0                 drout=0.56
+ pvag=0                    delta=0.012               pscbe1=7.506e+008
+ pscbe2=1e-020             fprout=0                  pdits=0
+ pditsd=0                  pditsl=0                  rsh=10.5
+ rdsw=700+drdswn_33        prwg=0                    prwb=0
+ wr=1                      alpha0=0                  alpha1=2.2950
+ beta0=17.8                agidl=0                   bgidl=1.698e+009
+ cgidl=0.25                egidl=0.2624              aigbacc=0.01213
+ bigbacc=0.006537          cigbacc=0.2809            nigbacc=4.05
+ aigbinv=0.35              bigbinv=0.03              cigbinv=0.006
+ eigbinv=1.1               nigbinv=1                 aigc=0.01
+ bigc=0.00144              cigc=1.515e-005           aigsd=0.008379
+ bigsd=0.0002699           cigsd=3.925e-020          nigc=1
+ poxedge=1                 pigcd=2.171               ntox=1
+ xrcrg1=12                 xrcrg2=1                  cgso=cgon_33
+ cgdo=cgon_33              cgbo=0                    cgdl=cgln_33
+ cgsl=cgln_33              clc=1e-007                cle=0.6
+ cf=cfn_33                 ckappas=0.6               ckappad=0.6
+ acde=0.4                  moin=5                    noff=1.4479
+ voffcv=-0.0921            kt1=-0.30685935           lkt1=-9.3805892e-009
+ wkt1=1.6803348e-008       pkt1=-1.6757138e-013      kt1l=0
+ kt2=-0.02                 ute=-1.6537381            lute=-3.1574875e-007
+ wute=-4.4008767e-011      pute=4.3887743e-016       ua1=8.4105049e-010
+ lua1=-1.011017e-015       wua1=-1.5069669e-022      pua1=1.5028227e-027
+ ub1=-1.3921958e-018       lub1=5.1254454e-025       wub1=3.1739656e-030
+ pub1=-3.1652373e-035      uc1=-6.1332386e-011       luc1=1.3287223e-017
+ prt=0                     at=31598.864              lat=-0.015944668
+ fnoimod=1                 tnoimod=0                 noia=5.3e41
+ noib=1e20                 noic=10000000             em=10000000
+ ef=0.8                    jss=4.1e-07               jsd=4.1e-07
+ jsws=1.55e-12             jswd=1.55e-12             jswgs=1.6e-012
+ jswgd=1.6e-012            njs=1                     njd=1
+ ijthsfwd=0.01             ijthdfwd=0.01             ijthsrev=0.01
+ ijthdrev=0.01             bvs=10                    bvd=10
+ xjbvs=1                   xjbvd=1                   pbs=0.7126
+ pbd=0.7126                cjs=cjn_33                cjd=cjn_33
+ mjs=0.3234                mjd=0.3234                pbsws=0.5345
+ pbswd=0.5345              cjsws=cjswn_33            cjswd=cjswn_33
+ mjsws=0.1391              mjswd=0.1391              pbswgs=0.73
+ pbswgd=0.73               cjswgs=cjswgn_33          cjswgd=cjswgn_33
+ mjswgs=0.5126             mjswgd=0.5126             tpb=0.0015
+ tcj=0.000891              tpbsw=0.00139             tcjsw=0.000445
+ tpbswg=0.0014             tcjswg=0.00129            xtis=3
+ xtid=3                    dmcg=1.125e-007           dmci=1.125e-007
+ dmdg=0                    dmcgt=0                   dwj=0
+ xgw=0                     xgl=0                     rshg=1
+ gbmin=1e-012              rbpb=50                   rbpd=50
+ rbps=50                   rbdb=50                   rbsb=50
+ ngcon=1                   saref=8.2e-07             sbref=8.2e-07
+ wlod=1.5e-07              kvth0=0                   lkvth0=0
+ wkvth0=0                  pkvth0=0                  llodvth=1
+ wlodvth=1                 stk2=0                    lodk2=1
+ lodeta0=1                 ku0=-8e-08                lku0=2.5e-07
+ wku0=3e-07                pku0=5e-14                llodku0=1
+ wlodku0=1                 kvsat=0.3                 steta0=0
+ tku0=0.1                  wvth0=0+dwvthn_33         lu0=0+dlu0n_33
+ minr=1e-3

     3: type=n
+ lmin=7e-007-dxln_33       lmax=1.2e-006-dxln_33     wmin=1e-005-dxwn_33
+ wmax=0.0009001            version=4.5               binunit=2
+ paramchk=1                mobmod=0                  capmod=2
+ igcmod=0                  igbmod=0                  geomod=0
+ diomod=1                  rdsmod=0                  rbodymod=0
+ rgatemod=0                permod=1                  acnqsmod=0
+ trnqsmod=0                tempmod=0                 wpemod=wpeflag_33
+ tnom=25                   toxe=toxn_33              toxm=toxn_33
+ dtox=2.78e-010            epsrox=3.9                wint=5.05e-008
+ lint=6.25e-009            ll=0                      wl=0
+ lln=1                     wln=1                     lw=0
+ ww=0                      lwn=1                     wwn=1
+ lwl=0                     wwl=0                     llc=0
+ wlc=0                     lwc=0                     wwc=0
+ lwlc=0                    wwlc=0                    xl=-1.5e-08+dxln_33
+ xw=0+dxwn_33              dlc=5.318e-8              dwc=0
+ xpart=1                   toxref=3e-009             dlcig=6.25e-009
+ vth0=0.5800875+dvthn_33   lvth0=-1.1827594e-008+dlvthn_33
+ k1=0.56256                k2=0.0535843+dk2n_33      lk2=-7.7904418e-009
+ k3=-3.628                 k3b=0.8                   w0=0
+ dvt0=11.761               dvt1=0.4                  dvt2=-0.115
+ dvt0w=0                   dvt1w=0                   dvt2w=0
+ dsub=0.17                 minv=-0.3                 voffl=0
+ dvtp0=1.4e-006            dvtp1=0.06                lpe0=1e-007
+ lpeb=0                    web=0                     wec=0
+ scref=1e-06               kvth0we=0.023             lkvth0we=0
+ wkvth0we=0                pkvth0we=0                k2we=0
+ lk2we=0                   wk2we=0                   pk2we=0
+ xj=1.5e-007               ngate=3.26e+020           ndep=4.2e+017
+ nsd=1e+020                phin=0                    cdsc=0
+ cdscb=0                   cdscd=0                   cit=-0.000301685
+ lcit=5.8822566e-010       wcit=-1.3462242e-016      pcit=1.5784477e-022
+ voff=-0.08991005          lvoff=6.7653836e-009      wvoff=-2.3471342e-014
+ pvoff=1.5784477e-020      nfactor=0.8386            lnfactor=1.892415e-007
+ eta0=0.061                etab=-0.028               ud=0
+ lud=0                     wud=0                     pud=0
+ ku0we=-0.006              lku0we=0                  wku0we=0
+ pku0we=0                  u0=400+du0n_33            ua=-3.6919743e-010
+ lua=-1.4055424e-016       wua=2.0018203e-022        pua=-4.8302774e-036
+ ub=2.2132853e-018         lub=-4.5755914e-025       uc=1.1297e-010
+ luc=-4.1002325e-017       wuc=1.691538e-023         puc=-3.1568955e-029
+ vsat=80500                a0=0.97995976             la0=-3.8401926e-007
+ wa0=1.0009101e-013        pa0=-1.1210341e-027       ags=0.12862142
+ lags=2.2613161e-007       a1=0                      a2=0.8
+ b0=0                      b1=0                      keta=-0.051194
+ lketa=8.200465e-009       dwg=0                     dwb=0
+ pclm=0.13275              lpclm=7.8850625e-008      pdiblc1=0
+ pdiblc2=0.0054244999      lpdiblc2=-3.3117261e-009  wpdiblc2=-1.3462242e-016
+ ppdiblc2=1.5784482e-022   pdiblcb=0                 drout=0.56
+ pvag=0                    delta=0.012               pscbe1=7.506e+008
+ pscbe2=1e-020             fprout=0                  pdits=0
+ pditsd=0                  pditsl=0                  rsh=10.5
+ rdsw=700+drdswn_33        prwg=0                    prwb=0
+ wr=1                      alpha0=0                  alpha1=2.2950
+ beta0=17.8                agidl=0                   bgidl=1.698e+009
+ cgidl=0.25                egidl=0.2624              aigbacc=0.01213
+ bigbacc=0.006537          cigbacc=0.2809            nigbacc=4.05
+ aigbinv=0.35              bigbinv=0.03              cigbinv=0.006
+ eigbinv=1.1               nigbinv=1                 aigc=0.01
+ bigc=0.00144              cigc=1.515e-005           aigsd=0.008379
+ bigsd=0.0002699           cigsd=3.925e-020          nigc=1
+ poxedge=1                 pigcd=2.171               ntox=1
+ xrcrg1=12                 xrcrg2=1                  cgso=cgon_33
+ cgdo=cgon_33              cgbo=0                    cgdl=cgln_33
+ cgsl=cgln_33              clc=1e-007                cle=0.6
+ cf=cfn_33                 ckappas=0.6               ckappad=0.6
+ acde=0.4                  moin=5                    noff=1.4479
+ voffcv=-0.0921            kt1=-0.3083772            lkt1=-7.60091e-009
+ wkt1=9.1973632e-008       pkt1=-2.5570854e-013      kt1l=0
+ kt2=-0.02                 ute=-3.0826502            lute=1.3596507e-006
+ wute=1.2443865e-009       pute=-1.0717661e-015      ua1=-3.7303358e-009
+ lua1=4.3489335e-015       wua1=-2.6659256e-019      pua1=3.1390591e-025
+ ub1=1.3703699e-018        lub1=-2.7265638e-024      wub1=-5.5861796e-029
+ pub1=3.7567058e-035       uc1=-6.345e-011           luc1=1.5770125e-017
+ prt=0                     at=15310                  lat=0.003154025
+ fnoimod=1                 tnoimod=0                 noia=5.3e41
+ noib=1e20                 noic=10000000             em=10000000
+ ef=0.8                    jss=4.1e-07               jsd=4.1e-07
+ jsws=1.55e-12             jswd=1.55e-12             jswgs=1.6e-012
+ jswgd=1.6e-012            njs=1                     njd=1
+ ijthsfwd=0.01             ijthdfwd=0.01             ijthsrev=0.01
+ ijthdrev=0.01             bvs=10                    bvd=10
+ xjbvs=1                   xjbvd=1                   pbs=0.7126
+ pbd=0.7126                cjs=cjn_33                cjd=cjn_33
+ mjs=0.3234                mjd=0.3234                pbsws=0.5345
+ pbswd=0.5345              cjsws=cjswn_33            cjswd=cjswn_33
+ mjsws=0.1391              mjswd=0.1391              pbswgs=0.73
+ pbswgd=0.73               cjswgs=cjswgn_33          cjswgd=cjswgn_33
+ mjswgs=0.5126             mjswgd=0.5126             tpb=0.0015
+ tcj=0.000891              tpbsw=0.00139             tcjsw=0.000445
+ tpbswg=0.0014             tcjswg=0.00129            xtis=3
+ xtid=3                    dmcg=1.125e-007           dmci=1.125e-007
+ dmdg=0                    dmcgt=0                   dwj=0
+ xgw=0                     xgl=0                     rshg=1
+ gbmin=1e-012              rbpb=50                   rbpd=50
+ rbps=50                   rbdb=50                   rbsb=50
+ ngcon=1                   saref=8.2e-07             sbref=8.2e-07
+ wlod=1.5e-07              kvth0=0                   lkvth0=0
+ wkvth0=0                  pkvth0=0                  llodvth=1
+ wlodvth=1                 stk2=0                    lodk2=1
+ lodeta0=1                 ku0=-8e-08                lku0=2.5e-07
+ wku0=3e-07                pku0=5e-14                llodku0=1
+ wlodku0=1                 kvsat=0.3                 steta0=0
+ tku0=0.1                  wvth0=0+dwvthn_33         lu0=0+dlu0n_33
+ minr=1e-3

     4: type=n
+ lmin=3.8e-07              lmax=7e-007-dxln_33       wmin=1e-005-dxwn_33
+ wmax=0.0009001            version=4.5               binunit=2
+ paramchk=1                mobmod=0                  capmod=2
+ igcmod=0                  igbmod=0                  geomod=0
+ diomod=1                  rdsmod=0                  rbodymod=0
+ rgatemod=0                permod=1                  acnqsmod=0
+ trnqsmod=0                tempmod=0                 wpemod=wpeflag_33
+ tnom=25                   toxe=toxn_33              toxm=toxn_33
+ dtox=2.78e-010            epsrox=3.9                wint=5.05e-008
+ lint=6.25e-009            ll=0                      wl=0
+ lln=1                     wln=1                     lw=0
+ ww=0                      lwn=1                     wwn=1
+ lwl=0                     wwl=0                     llc=0
+ wlc=0                     lwc=0                     wwc=0
+ lwlc=0                    wwlc=0                    xl=-1.5e-08+dxln_33
+ xw=0+dxwn_33              dlc=5.318e-8              dwc=0
+ xpart=1                   toxref=3e-009             dlcig=6.25e-009
+ vth0=0.53771484+dvthn_33  lvth0=1.6668018e-008+dlvthn_33
+ k1=0.56256                k2=0.044203125+dk2n_33    lk2=-1.4816016e-009
+ k3=-3.628                 k3b=0.8                   w0=0
+ dvt0=11.761               dvt1=0.4                  dvt2=-0.115
+ dvt0w=0                   dvt1w=0                   dvt2w=0
+ dsub=0.17                 minv=-0.3                 voffl=0
+ dvtp0=1.4e-006            dvtp1=0.06                lpe0=1e-007
+ lpeb=0                    web=0                     wec=0
+ scref=1e-06               kvth0we=0.023             lkvth0we=0
+ wkvth0we=0                pkvth0we=0                k2we=0
+ lk2we=0                   wk2we=0                   pk2we=0
+ xj=1.5e-007               ngate=3.26e+020           ndep=4.2e+017
+ nsd=1e+020                phin=0                    cdsc=0
+ cdscb=0                   cdscd=0                   cit=0.0010940391
+ lcit=-3.5039877e-010      wcit=2.1034752e-016       pcit=-7.4147506e-023
+ voff=-0.024177031         lvoff=-3.7440071e-008     nfactor=1.1971094
+ lnfactor=-5.1856055e-008  eta0=0.062101563          leta0=-7.4080078e-010
+ etab=-0.020289062         letab=-5.1856055e-009     ud=0
+ lud=0                     wud=0                     pud=0
+ ku0we=-0.006              lku0we=0                  wku0we=0
+ pku0we=0                  u0=467.41563+du0n_33      lu0=-4.5337008e-005+dlu0n_33
+ ua=5.8956638e-010         lua=-7.853229e-016        wua=4.2069504e-022
+ pua=-1.4829501e-028       ub=1.0742094e-018         lub=3.0846945e-025
+ uc=1.1445143e-010         luc=-4.1998589e-017       wuc=-6.3104256e-023
+ puc=2.224425e-029         vsat=72238.281            lvsat=0.0055560059
+ a0=0.83735524             la0=-2.8811772e-007       wa0=2.1034752e-013
+ pa0=-7.4147502e-020       ags=-0.12459527           lags=3.9641983e-007
+ a1=0                      a2=0.8                    b0=0
+ b1=0                      keta=-0.088570313         lketa=3.3336035e-008
+ dwg=0                     dwb=0                     pclm=0.084765625
+ lpclm=1.1112012e-007      pdiblc1=0                 pdiblc2=-0.0035757811
+ lpdiblc2=2.7409628e-009   wpdiblc2=2.1034751e-016   ppdiblc2=-7.4147495e-023
+ pdiblcb=0                 drout=0.56                pvag=0
+ delta=0.012               pscbe1=7.506e+008         pscbe2=1e-020
+ fprout=0                  pdits=0                   pditsd=0
+ pditsl=0                  rsh=10.5                  rdsw=700+drdswn_33
+ prwg=0                    prwb=0                    wr=1
+ alpha0=0                  alpha1=2.2950             beta0=17.8
+ agidl=0                   bgidl=1.698e+009          cgidl=0.25
+ egidl=0.2624              aigbacc=0.01213           bigbacc=0.006537
+ cigbacc=0.2809            nigbacc=4.05              aigbinv=0.35
+ bigbinv=0.03              cigbinv=0.006             eigbinv=1.1
+ nigbinv=1                 aigc=0.01                 bigc=0.00144
+ cigc=1.515e-005           aigsd=0.008379            bigsd=0.0002699
+ cigsd=3.925e-020          nigc=1                    poxedge=1
+ pigcd=2.171               ntox=1                    xrcrg1=12
+ xrcrg2=1                  cgso=cgon_33              cgdo=cgon_33
+ cgbo=0                    cgdl=cgln_33              cgsl=cgln_33
+ clc=1e-007                cle=0.6                   cf=cfn_33
+ ckappas=0.6               ckappad=0.6               acde=0.4
+ moin=5                    noff=1.4479               voffcv=-0.0921
+ kt1=-0.32482361           lkt1=3.4592973e-009       wkt1=-6.0580086e-007
+ pkt1=2.135448e-013        kt1l=0                    kt2=-0.018898437
+ lkt2=-7.4080078e-010      ute=-1.127911             lute=4.5088626e-008
+ wute=-7.3411285e-010      pute=2.5877478e-016       ua1=3.9880528e-009
+ lua1=-8.4168287e-016      wua1=4.2069504e-019       pua1=-1.48295e-025
+ ub1=-5.0791604e-018       lub1=1.6107454e-024       uc1=-1.3914063e-010
+ luc1=6.667207e-017        prt=0                     at=17796.875
+ lat=0.0014816016          fnoimod=1                 tnoimod=0
+ noia=5.3e41               noib=1e20                 noic=10000000
+ em=10000000               ef=0.8                    jss=4.1e-07
+ jsd=4.1e-07               jsws=1.55e-12             jswd=1.55e-12
+ jswgs=1.6e-012            jswgd=1.6e-012            njs=1
+ njd=1                     ijthsfwd=0.01             ijthdfwd=0.01
+ ijthsrev=0.01             ijthdrev=0.01             bvs=10
+ bvd=10                    xjbvs=1                   xjbvd=1
+ pbs=0.7126                pbd=0.7126                cjs=cjn_33
+ cjd=cjn_33                mjs=0.3234                mjd=0.3234
+ pbsws=0.5345              pbswd=0.5345              cjsws=cjswn_33
+ cjswd=cjswn_33            mjsws=0.1391              mjswd=0.1391
+ pbswgs=0.73               pbswgd=0.73               cjswgs=cjswgn_33
+ cjswgd=cjswgn_33          mjswgs=0.5126             mjswgd=0.5126
+ tpb=0.0015                tcj=0.000891              tpbsw=0.00139
+ tcjsw=0.000445            tpbswg=0.0014             tcjswg=0.00129
+ xtis=3                    xtid=3                    dmcg=1.125e-007
+ dmci=1.125e-007           dmdg=0                    dmcgt=0
+ dwj=0                     xgw=0                     xgl=0
+ rshg=1                    gbmin=1e-012              rbpb=50
+ rbpd=50                   rbps=50                   rbdb=50
+ rbsb=50                   ngcon=1                   saref=8.2e-07
+ sbref=8.2e-07             wlod=1.5e-07              kvth0=0
+ lkvth0=0                  wkvth0=0                  pkvth0=0
+ llodvth=1                 wlodvth=1                 stk2=0
+ lodk2=1                   lodeta0=1                 ku0=-8e-08
+ lku0=2.5e-07              wku0=3e-07                pku0=5e-14
+ llodku0=1                 wlodku0=1                 kvsat=0.3
+ steta0=0                  tku0=0.1                  wvth0=0+dwvthn_33
+ minr=1e-3

     5: type=n
+ lmin=1e-005-dxln_33       lmax=0.0009001            wmin=1e-006-dxwn_33
+ wmax=1e-005-dxwn_33       version=4.5               binunit=2
+ paramchk=1                mobmod=0                  capmod=2
+ igcmod=0                  igbmod=0                  geomod=0
+ diomod=1                  rdsmod=0                  rbodymod=0
+ rgatemod=0                permod=1                  acnqsmod=0
+ trnqsmod=0                tempmod=0                 wpemod=wpeflag_33
+ tnom=25                   toxe=toxn_33              toxm=toxn_33
+ dtox=2.78e-010            epsrox=3.9                wint=5.05e-008
+ lint=6.25e-009            ll=0                      wl=0
+ lln=1                     wln=1                     lw=0
+ ww=0                      lwn=1                     wwn=1
+ lwl=0                     wwl=0                     llc=0
+ wlc=0                     lwc=0                     wwc=0
+ lwlc=0                    wwlc=0                    xl=-1.5e-08+dxln_33
+ xw=0+dxwn_33              dlc=5.318e-8              dwc=0
+ xpart=1                   toxref=3e-009             dlcig=6.25e-009
+ vth0=0.56286723+dvthn_33  wvth0=2.0072642e-009+dwvthn_33
+ k1=0.56256                k2=0.047440556+dk2n_33    wk2=4.9440006e-009
+ k3=-3.628                 k3b=0.8                   w0=0
+ dvt0=11.761               dvt1=0.4                  dvt2=-0.115
+ dvt0w=0                   dvt1w=0                   dvt2w=0
+ dsub=0.17                 minv=-0.3                 voffl=0
+ dvtp0=1.4e-006            dvtp1=0.06                lpe0=1e-007
+ lpeb=0                    web=0                     wec=0
+ scref=1e-06               kvth0we=0.023             lkvth0we=0
+ wkvth0we=0                pkvth0we=0                k2we=0
+ lk2we=0                   wk2we=0                   pk2we=0
+ xj=1.5e-007               ngate=3.26e+020           ndep=4.2e+017
+ nsd=1e+020                phin=0                    cdsc=0
+ cdscb=0                   cdscd=0                   cit=0.00018276
+ voff=-0.076010111         wvoff=-9.8880011e-010     nfactor=1
+ eta0=0.062897889          weta0=-1.8787202e-008     etab=-0.028
+ ud=0                      lud=0                     wud=0
+ pud=0                     ku0we=-0.006              lku0we=0
+ wku0we=0                  pku0we=0                  u0=400.26253+du0n_33
+ wu0=-2.5987645e-006       ua=-4.2454703e-010        lua=-2.0146072e-023
+ wua=1.370718e-016         pua=1.9942596e-028        ub=2.2374788e-018
+ wub=-2.5815396e-025       uc=9.2169811e-011         wuc=-1.6809602e-018
+ vsat=80050.5              wvsat=0.0044496005        a0=1.3157043
+ wa0=1.8361326e-007        ags=0.27619869            wags=-1.0382006e-008
+ a1=0                      a2=0.8                    b0=0
+ b1=0                      keta=-0.03                dwg=0
+ dwb=0                     pclm=0.19001111           wpclm=9.8880011e-008
+ pdiblc1=0                 pdiblc2=0.00094500556     wpdiblc2=4.9440006e-011
+ pdiblcb=0                 drout=0.56                pvag=0
+ delta=0.012               pscbe1=7.506e+008         pscbe2=1e-020
+ fprout=0                  pdits=0                   pditsd=0
+ pditsl=0                  rsh=10.5                  rdsw=700+drdswn_33
+ prwg=0                    prwb=0                    wr=1
+ alpha0=0                  alpha1=2.2950             beta0=17.8
+ agidl=0                   bgidl=1.698e+009          cgidl=0.25
+ egidl=0.2624              aigbacc=0.01213           bigbacc=0.006537
+ cigbacc=0.2809            nigbacc=4.05              aigbinv=0.35
+ bigbinv=0.03              cigbinv=0.006             eigbinv=1.1
+ nigbinv=1                 aigc=0.01                 bigc=0.00144
+ cigc=1.515e-005           aigsd=0.008379            bigsd=0.0002699
+ cigsd=3.925e-020          nigc=1                    poxedge=1
+ pigcd=2.171               ntox=1                    xrcrg1=12
+ xrcrg2=1                  cgso=cgon_33              cgdo=cgon_33
+ cgbo=0                    cgdl=cgln_33              cgsl=cgln_33
+ clc=1e-007                cle=0.6                   cf=cfn_33
+ ckappas=0.6               ckappad=0.6               acde=0.4
+ moin=5                    noff=1.4479               voffcv=-0.0921
+ kt1=-0.31856802           wkt1=1.0659265e-007       kt1l=0
+ kt2=-0.02                 ute=-1.687823             wute=2.3985324e-008
+ ua1=7.7472775e-010        lua1=-1.0073035e-023      wua1=-3.470367e-016
+ pua1=9.9712981e-029       ub1=-1.3533679e-018       wub1=1.2440984e-025
+ uc1=-6e-011               prt=0                     at=30000
+ fnoimod=1                 tnoimod=0                 noia=5.3e41
+ noib=1e20                 noic=10000000             em=10000000
+ ef=0.8                    jss=4.1e-07               jsd=4.1e-07
+ jsws=1.55e-12             jswd=1.55e-12             jswgs=1.6e-012
+ jswgd=1.6e-012            njs=1                     njd=1
+ ijthsfwd=0.01             ijthdfwd=0.01             ijthsrev=0.01
+ ijthdrev=0.01             bvs=10                    bvd=10
+ xjbvs=1                   xjbvd=1                   pbs=0.7126
+ pbd=0.7126                cjs=cjn_33                cjd=cjn_33
+ mjs=0.3234                mjd=0.3234                pbsws=0.5345
+ pbswd=0.5345              cjsws=cjswn_33            cjswd=cjswn_33
+ mjsws=0.1391              mjswd=0.1391              pbswgs=0.73
+ pbswgd=0.73               cjswgs=cjswgn_33          cjswgd=cjswgn_33
+ mjswgs=0.5126             mjswgd=0.5126             tpb=0.0015
+ tcj=0.000891              tpbsw=0.00139             tcjsw=0.000445
+ tpbswg=0.0014             tcjswg=0.00129            xtis=3
+ xtid=3                    dmcg=1.125e-007           dmci=1.125e-007
+ dmdg=0                    dmcgt=0                   dwj=0
+ xgw=0                     xgl=0                     rshg=1
+ gbmin=1e-012              rbpb=50                   rbpd=50
+ rbps=50                   rbdb=50                   rbsb=50
+ ngcon=1                   saref=8.2e-07             sbref=8.2e-07
+ wlod=1.5e-07              kvth0=0                   lkvth0=0
+ wkvth0=0                  pkvth0=0                  llodvth=1
+ wlodvth=1                 stk2=0                    lodk2=1
+ lodeta0=1                 ku0=-8e-08                lku0=2.5e-07
+ wku0=3e-07                pku0=5e-14                llodku0=1
+ wlodku0=1                 kvsat=0.3                 steta0=0
+ tku0=0.1                  lvth0=0+dlvthn_33         lu0=0+dlu0n_33
+ minr=1e-3

     6: type=n
+ lmin=1.2e-006-dxln_33     lmax=1e-005-dxln_33       wmin=1e-006-dxwn_33
+ wmax=1e-005-dxwn_33       version=4.5               binunit=2
+ paramchk=1                mobmod=0                  capmod=2
+ igcmod=0                  igbmod=0                  geomod=0
+ diomod=1                  rdsmod=0                  rbodymod=0
+ rgatemod=0                permod=1                  acnqsmod=0
+ trnqsmod=0                tempmod=0                 wpemod=wpeflag_33
+ tnom=25                   toxe=toxn_33              toxm=toxn_33
+ dtox=2.78e-010            epsrox=3.9                wint=5.05e-008
+ lint=6.25e-009            ll=0                      wl=0
+ lln=1                     wln=1                     lw=0
+ ww=0                      lwn=1                     wwn=1
+ lwl=0                     wwl=0                     llc=0
+ wlc=0                     lwc=0                     wwc=0
+ lwlc=0                    wwlc=0                    xl=-1.5e-08+dxln_33
+ xw=0+dxwn_33              dlc=5.318e-8              dwc=0
+ xpart=1                   toxref=3e-009             dlcig=6.25e-009
+ vth0=0.56172388+dvthn_33  lvth0=1.1401983e-008+dlvthn_33
+ wvth0=4.1850319e-009+dwvthn_33                      pvth0=-2.1717788e-014
+ k1=0.56256                k2=0.047433709+dk2n_33    lk2=6.8281034e-011
+ wk2=6.3307076e-009        pk2=-1.3828936e-014       k3=-3.628
+ k3b=0.8                   w0=0                      dvt0=11.761
+ dvt1=0.4                  dvt2=-0.115               dvt0w=0
+ dvt1w=0                   dvt2w=0                   dsub=0.17
+ minv=-0.3                 voffl=0                   dvtp0=1.4e-006
+ dvtp1=0.06                lpe0=1e-007               lpeb=0
+ web=0                     wec=0                     scref=1e-06
+ kvth0we=0.023             lkvth0we=0                wkvth0we=0
+ pkvth0we=0                k2we=0                    lk2we=0
+ wk2we=0                   pk2we=0                   xj=1.5e-007
+ ngate=3.26e+020           ndep=4.2e+017             nsd=1e+020
+ phin=0                    cdsc=0                    cdscb=0
+ cdscd=0                   cit=0.00017780115         lcit=4.9452092e-011
+ wcit=2.6349276e-011       pcit=-2.6276815e-016      voff=-0.074882443
+ lvoff=-1.1245666e-008     wvoff=-1.5605794e-009     pvoff=5.7020689e-015
+ nfactor=1                 eta0=0.062897889          weta0=-1.8787202e-008
+ etab=-0.028               ud=0                      lud=0
+ wud=0                     pud=0                     ku0we=-0.006
+ lku0we=0                  wku0we=0                  pku0we=0
+ u0=400.26253+du0n_33      wu0=-2.5987645e-006       ua=-4.1339459e-010
+ lua=-1.1121763e-016       wua=1.3004247e-016        pua=7.0100236e-023
+ ub=2.2874155e-018         lub=-4.9799394e-025       wub=-2.4026214e-025
+ pub=-1.7842614e-031       uc=9.361991e-011          luc=-1.4461106e-017
+ wuc=2.4295268e-018        puc=-4.0991832e-023       vsat=80050.5
+ wvsat=0.0044496005        a0=1.4073749              la0=-9.1418462e-007
+ wa0=1.7543216e-007        pa0=8.1585964e-014        ags=0.2709998
+ lags=5.1845916e-008       wags=-2.0029872e-008      pags=9.6213347e-014
+ a1=0                      a2=0.8                    b0=0
+ b1=0                      keta=-0.028190528         lketa=-1.8044964e-008
+ wketa=8.1682755e-010      pketa=-8.1458127e-015     dwg=0
+ dwb=0                     pclm=0.19174129           lpclm=-1.7254197e-008
+ wpclm=8.1752982e-008      ppclm=1.707993e-013       pdiblc1=0
+ pdiblc2=0.00071651092     lpdiblc2=2.2786628e-009   wpdiblc2=1.3507515e-010
+ ppdiblc2=-8.5399649e-016  pdiblcb=0                 drout=0.56
+ pvag=0                    delta=0.012               pscbe1=7.506e+008
+ pscbe2=1e-020             fprout=0                  pdits=0
+ pditsd=0                  pditsl=0                  rsh=10.5
+ rdsw=700+drdswn_33        prwg=0                    prwb=0
+ wr=1                      alpha0=0                  alpha1=2.2950
+ beta0=17.8                agidl=0                   bgidl=1.698e+009
+ cgidl=0.25                egidl=0.2624              aigbacc=0.01213
+ bigbacc=0.006537          cigbacc=0.2809            nigbacc=4.05
+ aigbinv=0.35              bigbinv=0.03              cigbinv=0.006
+ eigbinv=1.1               nigbinv=1                 aigc=0.01
+ bigc=0.00144              cigc=1.515e-005           aigsd=0.008379
+ bigsd=0.0002699           cigsd=3.925e-020          nigc=1
+ poxedge=1                 pigcd=2.171               ntox=1
+ xrcrg1=12                 xrcrg2=1                  cgso=cgon_33
+ cgdo=cgon_33              cgbo=0                    cgdl=cgln_33
+ cgsl=cgln_33              clc=1e-007                cle=0.6
+ cf=cfn_33                 ckappas=0.6               ckappad=0.6
+ acde=0.4                  moin=5                    noff=1.4479
+ voffcv=-0.0921            kt1=-0.31729075           lkt1=-1.2737612e-008
+ wkt1=1.2006372e-007       pkt1=-1.3434022e-013      kt1l=0
+ kt2=-0.02                 ute=-1.6531957            lute=-3.4532098e-007
+ wute=-5.4129578e-009      pute=2.9317437e-013       ua1=8.8637592e-010
+ lua1=-1.1134114e-015      wua1=-4.4867659e-016      pua1=1.0136038e-021
+ ub1=-1.4066748e-018       lub1=5.3160311e-025       wub1=1.4333112e-025
+ pub1=-1.886925e-031       uc1=-6.2205594e-011       luc1=2.1995284e-017
+ wuc1=8.6438799e-018       puc1=-8.6201092e-023      prt=0
+ at=31452.464              lat=-0.014484697          wat=0.0014492102
+ pat=-1.4452248e-008       fnoimod=1                 tnoimod=0
+ noia=5.3e41               noib=1e20                 noic=10000000
+ em=10000000               ef=0.8                    jss=4.1e-07
+ jsd=4.1e-07               jsws=1.55e-12             jswd=1.55e-12
+ jswgs=1.6e-012            jswgd=1.6e-012            njs=1
+ njd=1                     ijthsfwd=0.01             ijthdfwd=0.01
+ ijthsrev=0.01             ijthdrev=0.01             bvs=10
+ bvd=10                    xjbvs=1                   xjbvd=1
+ pbs=0.7126                pbd=0.7126                cjs=cjn_33
+ cjd=cjn_33                mjs=0.3234                mjd=0.3234
+ pbsws=0.5345              pbswd=0.5345              cjsws=cjswn_33
+ cjswd=cjswn_33            mjsws=0.1391              mjswd=0.1391
+ pbswgs=0.73               pbswgd=0.73               cjswgs=cjswgn_33
+ cjswgd=cjswgn_33          mjswgs=0.5126             mjswgd=0.5126
+ tpb=0.0015                tcj=0.000891              tpbsw=0.00139
+ tcjsw=0.000445            tpbswg=0.0014             tcjswg=0.00129
+ xtis=3                    xtid=3                    dmcg=1.125e-007
+ dmci=1.125e-007           dmdg=0                    dmcgt=0
+ dwj=0                     xgw=0                     xgl=0
+ rshg=1                    gbmin=1e-012              rbpb=50
+ rbpd=50                   rbps=50                   rbdb=50
+ rbsb=50                   ngcon=1                   saref=8.2e-07
+ sbref=8.2e-07             wlod=1.5e-07              kvth0=0
+ lkvth0=0                  wkvth0=0                  pkvth0=0
+ llodvth=1                 wlodvth=1                 stk2=0
+ lodk2=1                   lodeta0=1                 ku0=-8e-08
+ lku0=2.5e-07              wku0=3e-07                pku0=5e-14
+ llodku0=1                 wlodku0=1                 kvsat=0.3
+ steta0=0                  tku0=0.1                  lu0=0+dlu0n_33
+ minr=1e-3

     7: type=n
+ lmin=7e-007-dxln_33       lmax=1.2e-006-dxln_33     wmin=1e-006-dxwn_33
+ wmax=1e-005-dxwn_33       version=4.5               binunit=2
+ paramchk=1                mobmod=0                  capmod=2
+ igcmod=0                  igbmod=0                  geomod=0
+ diomod=1                  rdsmod=0                  rbodymod=0
+ rgatemod=0                permod=1                  acnqsmod=0
+ trnqsmod=0                tempmod=0                 wpemod=wpeflag_33
+ tnom=25                   toxe=toxn_33              toxm=toxn_33
+ dtox=2.78e-010            epsrox=3.9                wint=5.05e-008
+ lint=6.25e-009            ll=0                      wl=0
+ lln=1                     wln=1                     lw=0
+ ww=0                      lwn=1                     wwn=1
+ lwl=0                     wwl=0                     llc=0
+ wlc=0                     lwc=0                     wwc=0
+ lwlc=0                    wwlc=0                    xl=-1.5e-08+dxln_33
+ xw=0+dxwn_33              dlc=5.318e-8              dwc=0
+ xpart=1                   toxref=3e-009             dlcig=6.25e-009
+ vth0=0.58480061+dvthn_33  lvth0=-1.5655476e-008+dlvthn_33
+ wvth0=-4.665505e-008+dwvthn_33                      pvth0=3.7892208e-014
+ k1=0.56256                k2=0.054878609+dk2n_33    lk2=-8.6608644e-009
+ wk2=-1.2812363e-008       pk2=8.6163139e-015        k3=-3.628
+ k3b=0.8                   w0=0                      dvt0=11.761
+ dvt1=0.4                  dvt2=-0.115               dvt0w=0
+ dvt1w=0                   dvt2w=0                   dsub=0.17
+ minv=-0.3                 voffl=0                   dvtp0=1.4e-006
+ dvtp1=0.06                lpe0=1e-007               lpeb=0
+ web=0                     wec=0                     scref=1e-06
+ kvth0we=0.023             lkvth0we=0                wkvth0we=0
+ pkvth0we=0                k2we=0                    lk2we=0
+ wk2we=0                   pk2we=0                   xj=1.5e-007
+ ngate=3.26e+020           ndep=4.2e+017             nsd=1e+020
+ phin=0                    cdsc=0                    cdscb=0
+ cdscd=0                   cit=-0.00022433955        lcit=5.2096206e-010
+ wcit=-7.6564276e-010      pcit=6.6584251e-016       voff=-0.096113457
+ lvoff=1.3647697e-008      wvoff=6.1407503e-008      pvoff=-6.8128007e-014
+ nfactor=0.82516494        lnfactor=2.049941e-007    wnfactor=1.3299361e-007
+ pnfactor=-1.5593501e-013  eta0=0.062897889          weta0=-1.8787202e-008
+ etab=-0.028               ud=0                      lud=0
+ wud=0                     pud=0                     ku0we=-0.006
+ lku0we=0                  wku0we=0                  pku0we=0
+ u0=400.93807+du0n_33      lu0=-7.9207237e-007+dlu0n_33
+ wu0=-9.2859494e-006       pu0=7.8407243e-012        ua=-4.1475574e-010
+ lua=-1.0962168e-016       wua=4.5098196e-016        pua=-3.0620132e-022
+ ub=2.2868041e-018         lub=-4.9727712e-025       wub=-7.2776274e-025
+ pub=3.9316831e-031        uc=1.1704901e-010         luc=-4.1931732e-017
+ wuc=-4.0378147e-017       puc=9.2001658e-024        vsat=81394.006
+ lvsat=-0.0015752603       wvsat=-0.008849761        pvsat=1.5593501e-008
+ a0=0.93158818             la0=-3.563247e-007        wa0=4.7883035e-007
+ pa0=-2.7414841e-013       ags=0.079155543           lags=2.7678331e-007
+ wags=4.8966274e-007       pags=-5.0140124e-013      a1=0
+ a2=0.8                    b0=0                      b1=0
+ keta=-0.049123703         lketa=6.4991841e-009      wketa=-2.049387e-008
+ pketa=1.684098e-014       dwg=0                     dwb=0
+ pclm=0.082905444          lpclm=1.1035583e-007      wpclm=4.9341126e-007
+ ppclm=-3.1187003e-013     pdiblc1=0                 pdiblc2=0.00592779
+ lpdiblc2=-3.831562e-009   wpdiblc2=-4.9820693e-009  ppdiblc2=5.1458553e-015
+ pdiblcb=0                 drout=0.56                pvag=0
+ delta=0.012               pscbe1=7.506e+008         pscbe2=1e-020
+ fprout=0                  pdits=0                   pditsd=0
+ pditsl=0                  rsh=10.5                  rdsw=700+drdswn_33
+ prwg=0                    prwb=0                    wr=1
+ alpha0=0                  alpha1=2.2950             beta0=17.8
+ agidl=0                   bgidl=1.698e+009          cgidl=0.25
+ egidl=0.2624              aigbacc=0.01213           bigbacc=0.006537
+ cigbacc=0.2809            nigbacc=4.05              aigbinv=0.35
+ bigbinv=0.03              cigbinv=0.006             eigbinv=1.1
+ nigbinv=1                 aigc=0.01                 bigc=0.00144
+ cigc=1.515e-005           aigsd=0.008379            bigsd=0.0002699
+ cigsd=3.925e-020          nigc=1                    poxedge=1
+ pigcd=2.171               ntox=1                    xrcrg1=12
+ xrcrg2=1                  cgso=cgon_33              cgdo=cgon_33
+ cgbo=0                    cgdl=cgln_33              cgsl=cgln_33
+ clc=1e-007                cle=0.6                   cf=cfn_33
+ ckappas=0.6               ckappad=0.6               acde=0.4
+ moin=5                    noff=1.4479               voffcv=-0.0921
+ kt1=-0.30240129           lkt1=-3.0195505e-008      wkt1=3.2818028e-008
+ pkt1=-3.2044645e-014      kt1l=0                    kt2=-0.02
+ ute=-3.1355044            lute=1.392686e-006        wute=5.2444771e-007
+ pute=-3.2808727e-013      ua1=-3.8324643e-009       lua1=4.4194288e-015
+ wua1=1.0107033e-015       pua1=-6.9751915e-022      ub1=1.3817081e-018
+ lub1=-2.7377758e-024      wub1=-1.122921e-025       pub1=1.1102573e-031
+ uc1=-4.808155e-011        luc1=5.4348424e-018       wuc1=-1.5213229e-016
+ puc1=1.0230896e-022       prt=0                     at=15871.376
+ lat=0.0037841291          wat=-0.0055570566         pat=-6.2374005e-009
+ fnoimod=1                 tnoimod=0                 noia=5.3e41
+ noib=1e20                 noic=10000000             em=10000000
+ ef=0.8                    jss=4.1e-07               jsd=4.1e-07
+ jsws=1.55e-12             jswd=1.55e-12             jswgs=1.6e-012
+ jswgd=1.6e-012            njs=1                     njd=1
+ ijthsfwd=0.01             ijthdfwd=0.01             ijthsrev=0.01
+ ijthdrev=0.01             bvs=10                    bvd=10
+ xjbvs=1                   xjbvd=1                   pbs=0.7126
+ pbd=0.7126                cjs=cjn_33                cjd=cjn_33
+ mjs=0.3234                mjd=0.3234                pbsws=0.5345
+ pbswd=0.5345              cjsws=cjswn_33            cjswd=cjswn_33
+ mjsws=0.1391              mjswd=0.1391              pbswgs=0.73
+ pbswgd=0.73               cjswgs=cjswgn_33          cjswgd=cjswgn_33
+ mjswgs=0.5126             mjswgd=0.5126             tpb=0.0015
+ tcj=0.000891              tpbsw=0.00139             tcjsw=0.000445
+ tpbswg=0.0014             tcjswg=0.00129            xtis=3
+ xtid=3                    dmcg=1.125e-007           dmci=1.125e-007
+ dmdg=0                    dmcgt=0                   dwj=0
+ xgw=0                     xgl=0                     rshg=1
+ gbmin=1e-012              rbpb=50                   rbpd=50
+ rbps=50                   rbdb=50                   rbsb=50
+ ngcon=1                   saref=8.2e-07             sbref=8.2e-07
+ wlod=1.5e-07              kvth0=0                   lkvth0=0
+ wkvth0=0                  pkvth0=0                  llodvth=1
+ wlodvth=1                 stk2=0                    lodk2=1
+ lodeta0=1                 ku0=-8e-08                lku0=2.5e-07
+ wku0=3e-07                pku0=5e-14                llodku0=1
+ wlodku0=1                 kvsat=0.3                 steta0=0
+ tku0=0.1                  minr=1e-3

     8: type=n
+ lmin=3.8e-07              lmax=7e-007-dxln_33       wmin=1e-006-dxwn_33
+ wmax=1e-005-dxwn_33       version=4.5               binunit=2
+ paramchk=1                mobmod=0                  capmod=2
+ igcmod=0                  igbmod=0                  geomod=0
+ diomod=1                  rdsmod=0                  rbodymod=0
+ rgatemod=0                permod=1                  acnqsmod=0
+ trnqsmod=0                tempmod=0                 wpemod=wpeflag_33
+ tnom=25                   toxe=toxn_33              toxm=toxn_33
+ dtox=2.78e-010            epsrox=3.9                wint=5.05e-008
+ lint=6.25e-009            ll=0                      wl=0
+ lln=1                     wln=1                     lw=0
+ ww=0                      lwn=1                     wwn=1
+ lwl=0                     wwl=0                     llc=0
+ wlc=0                     lwc=0                     wwc=0
+ lwlc=0                    wwlc=0                    xl=-1.5e-08+dxln_33
+ xw=0+dxwn_33              dlc=5.318e-8              dwc=0
+ xpart=1                   toxref=3e-009             dlcig=6.25e-009
+ vth0=0.5356576+dvthn_33   lvth0=1.7393196e-008+dlvthn_33
+ wvth0=2.0364647e-008+dwvthn_33                      pvth0=-7.1785382e-015
+ k1=0.56256                k2=0.044753294+dk2n_33    lk2=-1.8515904e-009
+ wk2=-5.4461256e-009       pk2=3.6625195e-015        k3=-3.628
+ k3b=0.8                   w0=0                      dvt0=11.761
+ dvt1=0.4                  dvt2=-0.115               dvt0w=0
+ dvt1w=0                   dvt2w=0                   dsub=0.17
+ minv=-0.3                 voffl=0                   dvtp0=1.4e-006
+ dvtp1=0.06                lpe0=1e-007               lpeb=0
+ web=0                     wec=0                     scref=1e-06
+ kvth0we=0.023             lkvth0we=0                wkvth0we=0
+ pkvth0we=0                k2we=0                    lk2we=0
+ wk2we=0                   pk2we=0                   xj=1.5e-007
+ ngate=3.26e+020           ndep=4.2e+017             nsd=1e+020
+ phin=0                    cdsc=0                    cdscb=0
+ cdscd=0                   cit=0.0011124069          lcit=-3.7799994e-010
+ wcit=-1.8182335e-010      pcit=2.7322395e-016       voff=-0.01905938
+ lvoff=-3.8171169e-008     wvoff=-5.0659629e-008     pvoff=7.2371385e-015
+ nfactor=1.2181016         lnfactor=-5.9255831e-008  wnfactor=-2.0780252e-007
+ pnfactor=7.3250389e-014   eta0=0.064109485          leta0=-8.1479855e-010
+ weta0=-1.9876427e-008     peta0=7.3250389e-016      etab=-0.019188724
+ letab=-5.9255831e-009     wetab=-1.0892251e-008     petab=7.3250389e-015
+ ud=0                      lud=0                     wud=0
+ pud=0                     ku0we=-0.006              lku0we=0
+ wku0we=0                  pku0we=0                  u0=465.67503+du0n_33
+ lu0=-4.4327678e-005+dlu0n_33                        wu0=1.7230151e-005
+ pu0=-9.9913531e-012       ua=5.9701197e-010         lua=-7.9003547e-016
+ wua=-7.3703398e-017       pua=4.6649584e-023        ub=1.0768005e-018
+ lub=3.1645033e-025        wub=-2.5649653e-026       pub=-7.9002743e-032
+ uc=1.1845711e-010         luc=-4.2878679e-017       wuc=-3.9652302e-017
+ puc=8.7120351e-024        vsat=69799.588            lvsat=0.0062219858
+ wvsat=0.024140628         pvsat=-6.5925351e-009     a0=0.83489873
+ la0=-2.9130105e-007       wa0=2.4317237e-008        pa0=3.1511658e-014
+ ags=0.094786456           lags=2.6627152e-007       wags=-2.1716597e-006
+ pags=1.2883381e-012       a1=0                      a2=0.8
+ b0=0                      b1=0                      keta=-0.091296499
+ lketa=3.4860389e-008      wketa=2.6986516e-008      pketa=-1.508958e-014
+ dwg=0                     dwb=0                     pclm=0.089471328
+ lpclm=1.0594027e-007      wpclm=-4.6581755e-008     ppclm=5.1275273e-014
+ pdiblc1=0                 pdiblc2=-0.0041315691     lpdiblc2=2.933357e-009
+ wpdiblc2=5.5017455e-009   ppdiblc2=-1.9045101e-015  pdiblcb=0
+ drout=0.56                pvag=0                    delta=0.012
+ pscbe1=7.506e+008         pscbe2=1e-020             fprout=0
+ pdits=0                   pditsd=0                  pditsl=0
+ rsh=10.5                  rdsw=700+drdswn_33        prwg=0
+ prwb=0                    wr=1                      alpha0=0
+ alpha1=2.2950             beta0=17.8                agidl=0
+ bgidl=1.698e+009          cgidl=0.25                egidl=0.2624
+ aigbacc=0.01213           bigbacc=0.006537          cigbacc=0.2809
+ nigbacc=4.05              aigbinv=0.35              bigbinv=0.03
+ cigbinv=0.006             eigbinv=1.1               nigbinv=1
+ aigc=0.01                 bigc=0.00144              cigc=1.515e-005
+ aigsd=0.008379            bigsd=0.0002699           cigsd=3.925e-020
+ nigc=1                    poxedge=1                 pigcd=2.171
+ ntox=1                    xrcrg1=12                 xrcrg2=1
+ cgso=cgon_33              cgdo=cgon_33              cgbo=0
+ cgdl=cgln_33              cgsl=cgln_33              clc=1e-007
+ cle=0.6                   cf=cfn_33                 ckappas=0.6
+ ckappad=0.6               acde=0.4                  moin=5
+ noff=1.4479               voffcv=-0.0921            kt1=-0.3755271
+ lkt1=1.8981601e-008       wkt1=-1.0388705e-007      pkt1=5.9889518e-014
+ kt1l=0                    kt2=-0.018788404          lkt2=-8.1479855e-010
+ wkt2=-1.0892251e-009      pkt2=7.3250389e-016       ute=-1.1302506
+ lute=4.4152797e-008       wute=2.2425678e-008       pute=9.5225506e-015
+ ua1=3.9688646e-009        lua1=-8.2696489e-016      wua1=1.9036488e-016
+ pua1=-1.4584153e-022      ub1=-5.0603497e-018       lub1=1.594508e-024
+ wub1=-1.8620674e-025      pub1=1.6073333e-031       uc1=-1.3804029e-010
+ luc1=6.5932093e-017       wuc1=-1.0892251e-017      puc1=7.3250389e-024
+ prt=0                     at=20774.063              lat=0.00048707158
+ wat=-0.029471187          pat=9.8448523e-009        fnoimod=1
+ tnoimod=0                 noia=5.3e41               noib=1e20
+ noic=10000000             em=10000000               ef=0.8
+ jss=4.1e-07               jsd=4.1e-07               jsws=1.55e-12
+ jswd=1.55e-12             jswgs=1.6e-012            jswgd=1.6e-012
+ njs=1                     njd=1                     ijthsfwd=0.01
+ ijthdfwd=0.01             ijthsrev=0.01             ijthdrev=0.01
+ bvs=10                    bvd=10                    xjbvs=1
+ xjbvd=1                   pbs=0.7126                pbd=0.7126
+ cjs=cjn_33                cjd=cjn_33                mjs=0.3234
+ mjd=0.3234                pbsws=0.5345              pbswd=0.5345
+ cjsws=cjswn_33            cjswd=cjswn_33            mjsws=0.1391
+ mjswd=0.1391              pbswgs=0.73               pbswgd=0.73
+ cjswgs=cjswgn_33          cjswgd=cjswgn_33          mjswgs=0.5126
+ mjswgd=0.5126             tpb=0.0015                tcj=0.000891
+ tpbsw=0.00139             tcjsw=0.000445            tpbswg=0.0014
+ tcjswg=0.00129            xtis=3                    xtid=3
+ dmcg=1.125e-007           dmci=1.125e-007           dmdg=0
+ dmcgt=0                   dwj=0                     xgw=0
+ xgl=0                     rshg=1                    gbmin=1e-012
+ rbpb=50                   rbpd=50                   rbps=50
+ rbdb=50                   rbsb=50                   ngcon=1
+ saref=8.2e-07             sbref=8.2e-07             wlod=1.5e-07
+ kvth0=0                   lkvth0=0                  wkvth0=0
+ pkvth0=0                  llodvth=1                 wlodvth=1
+ stk2=0                    lodk2=1                   lodeta0=1
+ ku0=-8e-08                lku0=2.5e-07              wku0=3e-07
+ pku0=5e-14                llodku0=1                 wlodku0=1
+ kvsat=0.3                 steta0=0                  tku0=0.1
+ minr=1e-3

     9: type=n
+ lmin=1e-005-dxln_33       lmax=0.0009001            wmin=6e-007-dxwn_33
+ wmax=1e-006-dxwn_33       version=4.5               binunit=2
+ paramchk=1                mobmod=0                  capmod=2
+ igcmod=0                  igbmod=0                  geomod=0
+ diomod=1                  rdsmod=0                  rbodymod=0
+ rgatemod=0                permod=1                  acnqsmod=0
+ trnqsmod=0                tempmod=0                 wpemod=wpeflag_33
+ tnom=25                   toxe=toxn_33              toxm=toxn_33
+ dtox=2.78e-010            epsrox=3.9                wint=5.05e-008
+ lint=6.25e-009            ll=0                      wl=0
+ lln=1                     wln=1                     lw=0
+ ww=0                      lwn=1                     wwn=1
+ lwl=0                     wwl=0                     llc=0
+ wlc=0                     lwc=0                     wwc=0
+ lwlc=0                    wwlc=0                    xl=-1.5e-08+dxln_33
+ xw=0+dxwn_33              dlc=5.318e-8              dwc=0
+ xpart=1                   toxref=3e-009             dlcig=6.25e-009
+ vth0=0.58019475+dvthn_33  wvth0=-1.357018e-008+dwvthn_33
+ k1=0.56256                k2=0.05294+dk2n_33        k3=-3.628
+ k3b=0.8                   w0=0                      dvt0=11.761
+ dvt1=0.4                  dvt2=-0.115               dvt0w=0
+ dvt1w=0                   dvt2w=0                   dsub=0.17
+ minv=-0.3                 voffl=0                   dvtp0=1.4e-006
+ dvtp1=0.06                lpe0=1e-007               lpeb=0
+ web=0                     wec=0                     scref=1e-06
+ kvth0we=0.023             lkvth0we=0                wkvth0we=0
+ pkvth0we=0                k2we=0                    lk2we=0
+ wk2we=0                   pk2we=0                   xj=1.5e-007
+ ngate=3.26e+020           ndep=4.2e+017             nsd=1e+020
+ phin=0                    cdsc=0                    cdscb=0
+ cdscd=0                   cit=0.0004107531          wcit=-2.049658e-010
+ voff=-0.093414825         wvoff=1.4658038e-008      nfactor=0.87525
+ wnfactor=1.1215025e-007   eta0=0.065078749          weta0=-2.0747795e-008
+ etab=-0.045465            wetab=1.5701035e-008      ud=0
+ lud=0                     wud=0                     pud=0
+ ku0we=-0.006              lku0we=0                  wku0we=0
+ pku0we=0                  u0=431.51812+du0n_33      wu0=-3.0697542e-005
+ ua=4.884737e-011          lua=4.5328662e-022        wua=-2.8850976e-016
+ pua=-2.2619002e-028       ub=1.9912762e-018         wub=-3.6817806e-026
+ uc=1.135035e-010          wuc=-2.0859949e-017       vsat=72525
+ wvsat=0.011215025         a0=1.561731               wa0=-3.7564726e-008
+ ags=0.2761772             wags=-1.0362683e-008      a1=0
+ a2=0.8                    b0=0                      b1=0
+ keta=-0.032495            wketa=2.243005e-009       dwg=0
+ dwb=0                     pclm=-0.011875            wpclm=2.8037563e-007
+ pdiblc1=0                 pdiblc2=0.0011247501      wpdiblc2=-1.1215032e-010
+ pdiblcb=0                 drout=0.56                pvag=0
+ delta=0.012               pscbe1=7.506e+008         pscbe2=1e-020
+ fprout=0                  pdits=0                   pditsd=0
+ pditsl=0                  rsh=10.5                  rdsw=700+drdswn_33
+ prwg=0                    prwb=0                    wr=1
+ alpha0=0                  alpha1=2.2950             beta0=17.8
+ agidl=0                   bgidl=1.698e+009          cgidl=0.25
+ egidl=0.2624              aigbacc=0.01213           bigbacc=0.006537
+ cigbacc=0.2809            nigbacc=4.05              aigbinv=0.35
+ bigbinv=0.03              cigbinv=0.006             eigbinv=1.1
+ nigbinv=1                 aigc=0.01                 bigc=0.00144
+ cigc=1.515e-005           aigsd=0.008379            bigsd=0.0002699
+ cigsd=3.925e-020          nigc=1                    poxedge=1
+ pigcd=2.171               ntox=1                    xrcrg1=12
+ xrcrg2=1                  cgso=cgon_33              cgdo=cgon_33
+ cgbo=0                    cgdl=cgln_33              cgsl=cgln_33
+ clc=1e-007                cle=0.6                   cf=cfn_33
+ ckappas=0.6               ckappad=0.6               acde=0.4
+ moin=5                    noff=1.4479               voffcv=-0.0921
+ kt1=-0.1002               wkt1=-8.97202e-008        kt1l=0
+ kt2=-0.02                 ute=-1.7729726            wute=1.0053485e-007
+ ua1=4.9920917e-010        lua1=2.2664331e-022       wua1=-9.9345495e-017
+ pua1=-1.1309501e-028      ub1=-1.7844909e-018       wub1=5.1198944e-025
+ uc1=-6e-011               prt=0                     at=54950
+ wat=-0.02243005           fnoimod=1                 tnoimod=0
+ noia=5.3e41               noib=1e20                 noic=10000000
+ em=10000000               ef=0.8                    jss=4.1e-07
+ jsd=4.1e-07               jsws=1.55e-12             jswd=1.55e-12
+ jswgs=1.6e-012            jswgd=1.6e-012            njs=1
+ njd=1                     ijthsfwd=0.01             ijthdfwd=0.01
+ ijthsrev=0.01             ijthdrev=0.01             bvs=10
+ bvd=10                    xjbvs=1                   xjbvd=1
+ pbs=0.7126                pbd=0.7126                cjs=cjn_33
+ cjd=cjn_33                mjs=0.3234                mjd=0.3234
+ pbsws=0.5345              pbswd=0.5345              cjsws=cjswn_33
+ cjswd=cjswn_33            mjsws=0.1391              mjswd=0.1391
+ pbswgs=0.73               pbswgd=0.73               cjswgs=cjswgn_33
+ cjswgd=cjswgn_33          mjswgs=0.5126             mjswgd=0.5126
+ tpb=0.0015                tcj=0.000891              tpbsw=0.00139
+ tcjsw=0.000445            tpbswg=0.0014             tcjswg=0.00129
+ xtis=3                    xtid=3                    dmcg=1.125e-007
+ dmci=1.125e-007           dmdg=0                    dmcgt=0
+ dwj=0                     xgw=0                     xgl=0
+ rshg=1                    gbmin=1e-012              rbpb=50
+ rbpd=50                   rbps=50                   rbdb=50
+ rbsb=50                   ngcon=1                   saref=8.2e-07
+ sbref=8.2e-07             wlod=1.5e-07              kvth0=0
+ lkvth0=0                  wkvth0=0                  pkvth0=0
+ llodvth=1                 wlodvth=1                 stk2=0
+ lodk2=1                   lodeta0=1                 ku0=-8e-08
+ lku0=2.5e-07              wku0=3e-07                pku0=5e-14
+ llodku0=1                 wlodku0=1                 kvsat=0.3
+ steta0=0                  tku0=0.1                  lvth0=0+dlvthn_33
+ lu0=0+dlu0n_33            minr=1e-3

     10: type=n
+ lmin=1.2e-006-dxln_33     lmax=1e-005-dxln_33       wmin=6e-007-dxwn_33
+ wmax=1e-006-dxwn_33       version=4.5               binunit=2
+ paramchk=1                mobmod=0                  capmod=2
+ igcmod=0                  igbmod=0                  geomod=0
+ diomod=1                  rdsmod=0                  rbodymod=0
+ rgatemod=0                permod=1                  acnqsmod=0
+ trnqsmod=0                tempmod=0                 wpemod=wpeflag_33
+ tnom=25                   toxe=toxn_33              toxm=toxn_33
+ dtox=2.78e-010            epsrox=3.9                wint=5.05e-008
+ lint=6.25e-009            ll=0                      wl=0
+ lln=1                     wln=1                     lw=0
+ ww=0                      lwn=1                     wwn=1
+ lwl=0                     wwl=0                     llc=0
+ wlc=0                     lwc=0                     wwc=0
+ lwlc=0                    wwlc=0                    xl=-1.5e-08+dxln_33
+ xw=0+dxwn_33              dlc=5.318e-8              dwc=0
+ xpart=1                   toxref=3e-009             dlcig=6.25e-009
+ vth0=0.58572895+dvthn_33  lvth0=-5.5189809e-008+dlvthn_33
+ wvth0=-1.7395523e-008+dwvthn_33                     pvth0=3.8148234e-014
+ k1=0.56256                k2=0.053810057+dk2n_33    lk2=-8.6766444e-009
+ wk2=5.9837032e-010        pk2=-5.9672481e-015       k3=-3.628
+ k3b=0.8                   w0=0                      dvt0=11.761
+ dvt1=0.4                  dvt2=-0.115               dvt0w=0
+ dvt1w=0                   dvt2w=0                   dsub=0.17
+ minv=-0.3                 voffl=0                   dvtp0=1.4e-006
+ dvtp1=0.06                lpe0=1e-007               lpeb=0
+ web=0                     wec=0                     scref=1e-06
+ kvth0we=0.023             lkvth0we=0                wkvth0we=0
+ pkvth0we=0                k2we=0                    lk2we=0
+ wk2we=0                   pk2we=0                   xj=1.5e-007
+ ngate=3.26e+020           ndep=4.2e+017             nsd=1e+020
+ phin=0                    cdsc=0                    cdscb=0
+ cdscd=0                   cit=0.00046548129         lcit=-5.4577683e-010
+ wcit=-2.3227516e-010      pcit=2.7234264e-016       voff=-0.098785584
+ lvoff=5.3559896e-008      wvoff=1.9928344e-008      pvoff=-5.2558132e-014
+ nfactor=0.84200696        lnfactor=3.3151625e-007   wnfactor=1.4203575e-007
+ pnfactor=-2.9803311e-013  eta0=0.065078749          weta0=-2.0747795e-008
+ etab=-0.045465            wetab=1.5701035e-008      ud=0
+ lud=0                     wud=0                     pud=0
+ ku0we=-0.006              lku0we=0                  wku0we=0
+ pku0we=0                  u0=431.51812+du0n_33      wu0=-3.0697542e-005
+ ua=6.1562766e-011         lua=-1.2680384e-016       wua=-2.969442e-016
+ pua=8.4112236e-023        ub=2.0518445e-018         lub=-6.0401747e-025
+ wub=-2.8483788e-026       pub=-8.3110994e-032       uc=1.1894414e-010
+ luc=-5.4256717e-017       wuc=-2.0336953e-017       puc=-5.2155773e-024
+ vsat=72525                wvsat=0.011215025         a0=1.6199992
+ la0=-5.8107943e-007       wa0=-1.5717085e-008       pa0=-2.1787561e-013
+ ags=0.263088              lags=1.3053205e-007       wags=-1.2917159e-008
+ pags=2.5474511e-014       a1=0                      a2=0.8
+ b0=0                      b1=0                      keta=-0.029311529
+ lketa=-3.1747162e-008     wketa=1.8246081e-009      pketa=4.1724631e-015
+ dwg=0                     dwb=0                     pclm=-0.10233071
+ lpclm=9.0206957e-007      wpclm=3.4612371e-007      ppclm=-6.5567277e-013
+ pdiblc1=0                 pdiblc2=0.0011411051      lpdiblc2=-1.631006e-010
+ wpdiblc2=-2.4663503e-010  ppdiblc2=1.3411488e-015   pdiblcb=0
+ drout=0.56                pvag=0                    delta=0.012
+ pscbe1=7.506e+008         pscbe2=1e-020             fprout=0
+ pdits=0                   pditsd=0                  pditsl=0
+ rsh=10.5                  rdsw=700+drdswn_33        prwg=0
+ prwb=0                    wr=1                      alpha0=0
+ alpha1=2.2950             beta0=17.8                agidl=0
+ bgidl=1.698e+009          cgidl=0.25                egidl=0.2624
+ aigbacc=0.01213           bigbacc=0.006537          cigbacc=0.2809
+ nigbacc=4.05              aigbinv=0.35              bigbinv=0.03
+ cigbinv=0.006             eigbinv=1.1               nigbinv=1
+ aigc=0.01                 bigc=0.00144              cigc=1.515e-005
+ aigsd=0.008379            bigsd=0.0002699           cigsd=3.925e-020
+ nigc=1                    poxedge=1                 pigcd=2.171
+ ntox=1                    xrcrg1=12                 xrcrg2=1
+ cgso=cgon_33              cgdo=cgon_33              cgbo=0
+ cgdl=cgln_33              cgsl=cgln_33              clc=1e-007
+ cle=0.6                   cf=cfn_33                 ckappas=0.6
+ ckappad=0.6               acde=0.4                  moin=5
+ noff=1.4479               voffcv=-0.0921            kt1=-0.076533337
+ lkt1=-2.3601579e-007      wkt1=-9.6377194e-008      pkt1=6.6386868e-014
+ kt1l=0                    kt2=-0.02                 ute=-1.6932648
+ lute=-7.94886e-007        wute=3.0609221e-008       pute=6.9733332e-013
+ ua1=8.7362647e-010        lua1=-3.7338763e-015      wua1=-4.3721483e-016
+ pua1=3.3694018e-021       ub1=-2.2638466e-018       lub1=4.7803742e-024
+ wub1=9.1392855e-025       pub1=-4.0083377e-030      uc1=-5.830674e-011
+ luc1=-1.6886034e-017      wuc1=5.1388105e-018       puc1=-5.1246788e-023
+ prt=0                     at=68569.154              lat=-0.13581701
+ wat=-0.031918694          pat=9.4625502e-008        fnoimod=1
+ tnoimod=0                 noia=5.3e41               noib=1e20
+ noic=10000000             em=10000000               ef=0.8
+ jss=4.1e-07               jsd=4.1e-07               jsws=1.55e-12
+ jswd=1.55e-12             jswgs=1.6e-012            jswgd=1.6e-012
+ njs=1                     njd=1                     ijthsfwd=0.01
+ ijthdfwd=0.01             ijthsrev=0.01             ijthdrev=0.01
+ bvs=10                    bvd=10                    xjbvs=1
+ xjbvd=1                   pbs=0.7126                pbd=0.7126
+ cjs=cjn_33                cjd=cjn_33                mjs=0.3234
+ mjd=0.3234                pbsws=0.5345              pbswd=0.5345
+ cjsws=cjswn_33            cjswd=cjswn_33            mjsws=0.1391
+ mjswd=0.1391              pbswgs=0.73               pbswgd=0.73
+ cjswgs=cjswgn_33          cjswgd=cjswgn_33          mjswgs=0.5126
+ mjswgd=0.5126             tpb=0.0015                tcj=0.000891
+ tpbsw=0.00139             tcjsw=0.000445            tpbswg=0.0014
+ tcjswg=0.00129            xtis=3                    xtid=3
+ dmcg=1.125e-007           dmci=1.125e-007           dmdg=0
+ dmcgt=0                   dwj=0                     xgw=0
+ xgl=0                     rshg=1                    gbmin=1e-012
+ rbpb=50                   rbpd=50                   rbps=50
+ rbdb=50                   rbsb=50                   ngcon=1
+ saref=8.2e-07             sbref=8.2e-07             wlod=1.5e-07
+ kvth0=0                   lkvth0=0                  wkvth0=0
+ pkvth0=0                  llodvth=1                 wlodvth=1
+ stk2=0                    lodk2=1                   lodeta0=1
+ ku0=-8e-08                lku0=2.5e-07              wku0=3e-07
+ pku0=5e-14                llodku0=1                 wlodku0=1
+ kvsat=0.3                 steta0=0                  tku0=0.1
+ lu0=0+dlu0n_33            minr=1e-3

     11: type=n
+ lmin=7e-007-dxln_33       lmax=1.2e-006-dxln_33     wmin=6e-007-dxwn_33
+ wmax=1e-006-dxwn_33       version=4.5               binunit=2
+ paramchk=1                mobmod=0                  capmod=2
+ igcmod=0                  igbmod=0                  geomod=0
+ diomod=1                  rdsmod=0                  rbodymod=0
+ rgatemod=0                permod=1                  acnqsmod=0
+ trnqsmod=0                tempmod=0                 wpemod=wpeflag_33
+ tnom=25                   toxe=toxn_33              toxm=toxn_33
+ dtox=2.78e-010            epsrox=3.9                wint=5.05e-008
+ lint=6.25e-009            ll=0                      wl=0
+ lln=1                     wln=1                     lw=0
+ ww=0                      lwn=1                     wwn=1
+ lwl=0                     wwl=0                     llc=0
+ wlc=0                     lwc=0                     wwc=0
+ lwlc=0                    wwlc=0                    xl=-1.5e-08+dxln_33
+ xw=0+dxwn_33              dlc=5.318e-8              dwc=0
+ xpart=1                   toxref=3e-009             dlcig=6.25e-009
+ vth0=0.46186698+dvthn_33  lvth0=9.0038346e-008+dlvthn_33
+ wvth0=6.3862278e-008+dwvthn_33                      pvth0=-5.7126538e-014
+ k1=0.56256                k2=0.04227397+dk2n_33     lk2=4.8494176e-009
+ wk2=-1.4807925e-009       pk2=-3.5294296e-015       k3=-3.628
+ k3b=0.8                   w0=0                      dvt0=11.761
+ dvt1=0.4                  dvt2=-0.115               dvt0w=0
+ dvt1w=0                   dvt2w=0                   dsub=0.17
+ minv=-0.3                 voffl=0                   dvtp0=1.4e-006
+ dvtp1=0.06                lpe0=1e-007               lpeb=0
+ web=0                     wec=0                     scref=1e-06
+ kvth0we=0.023             lkvth0we=0                wkvth0we=0
+ pkvth0we=0                k2we=0                    lk2we=0
+ wk2we=0                   pk2we=0                   xj=1.5e-007
+ ngate=3.26e+020           ndep=4.2e+017             nsd=1e+020
+ phin=0                    cdsc=0                    cdscb=0
+ cdscd=0                   cit=-0.0013746641         lcit=1.6117937e-009
+ wcit=2.6849905e-010       pcit=-3.1481512e-016      voff=0.05425105
+ lvoff=-1.2587556e-007     wvoff=-7.3770189e-008     pvoff=5.7303398e-014
+ nfactor=1.2320811         lnfactor=-1.2584564e-007  wnfactor=-2.3282397e-007
+ pnfactor=1.4148991e-013   eta0=0.065078749          weta0=-2.0747795e-008
+ etab=-0.045465            wetab=1.5701035e-008      ud=0
+ lud=0                     wud=0                     pud=0
+ ku0we=-0.006              lku0we=0                  wku0we=0
+ pku0we=0                  u0=416.31844+du0n_33      lu0=1.7821628e-005+dlu0n_33
+ wu0=-2.31129e-005         pu0=-8.8929925e-012       ua=2.714579e-010
+ lua=-3.7290588e-016       wua=-1.659241e-016        pua=-6.950883e-023
+ ub=1.8965786e-018         lub=-4.2196824e-025       wub=-3.7694999e-025
+ pub=3.2546563e-031        uc=1.3175191e-010         luc=-6.9273829e-017
+ wuc=-5.3596048e-017       puc=3.3780712e-023        vsat=42296.125
+ lvsat=0.035443356         wvsat=0.026299234         pvsat=-1.7686235e-008
+ a0=2.2456476              la0=-1.3146522e-006       wa0=-7.0250906e-007
+ pa0=5.8738799e-013        ags=1.1420213             lags=-9.0001727e-007
+ wags=-4.658536e-007       pags=5.5654249e-013       a1=0
+ a2=0.8                    b0=0                      b1=0
+ keta=-0.11482153          lketa=6.8513314e-008      wketa=3.8568477e-008
+ pketa=-3.8909723e-014     dwg=0                     dwb=0
+ pclm=1.3889201            lpclm=-8.4642199e-007     wpclm=-6.8069591e-007
+ ppclm=5.4827324e-013      pdiblc1=0                 pdiblc2=0.00022694404
+ lpdiblc2=9.0875326e-010   wpdiblc2=1.4299131e-010   ppdiblc2=8.8431191e-016
+ pdiblcb=0                 drout=0.56                pvag=0
+ delta=0.012               pscbe1=7.506e+008         pscbe2=1e-020
+ fprout=0                  pdits=0                   pditsd=0
+ pditsl=0                  rsh=10.5                  rdsw=700+drdswn_33
+ prwg=0                    prwb=0                    wr=1
+ alpha0=0                  alpha1=2.2950             beta0=17.8
+ agidl=0                   bgidl=1.698e+009          cgidl=0.25
+ egidl=0.2624              aigbacc=0.01213           bigbacc=0.006537
+ cigbacc=0.2809            nigbacc=4.05              aigbinv=0.35
+ bigbinv=0.03              cigbinv=0.006             eigbinv=1.1
+ nigbinv=1                 aigc=0.01                 bigc=0.00144
+ cigc=1.515e-005           aigsd=0.008379            bigsd=0.0002699
+ cigsd=3.925e-020          nigc=1                    poxedge=1
+ pigcd=2.171               ntox=1                    xrcrg1=12
+ xrcrg2=1                  cgso=cgon_33              cgdo=cgon_33
+ cgbo=0                    cgdl=cgln_33              cgsl=cgln_33
+ clc=1e-007                cle=0.6                   cf=cfn_33
+ ckappas=0.6               ckappad=0.6               acde=0.4
+ moin=5                    noff=1.4479               voffcv=-0.0921
+ kt1=-0.11554599           lkt1=-1.9027346e-007      wkt1=-1.3516488e-007
+ pkt1=1.1186543e-013       kt1l=0                    kt2=-0.02
+ ute=-4.793748             lute=2.8404305e-006       wute=2.0152088e-006
+ pute=-1.6296097e-012      ua1=-1.2663385e-008       lua1=1.213827e-014
+ wua1=8.9497009e-015       pua1=-7.6367569e-021      ub1=1.1792115e-017
+ lub1=-1.170024e-023       wub1=-9.4712476e-024      pub1=8.1682813e-030
+ uc1=-5.7975311e-011       luc1=-1.7274634e-017      wuc1=-1.4323779e-016
+ puc1=1.2272478e-022       prt=0                     at=-102463.37
+ lat=0.064718622           wat=0.10082588            pat=-6.1017509e-008
+ fnoimod=1                 tnoimod=0                 noia=5.3e41
+ noib=1e20                 noic=10000000             em=10000000
+ ef=0.8                    jss=4.1e-07               jsd=4.1e-07
+ jsws=1.55e-12             jswd=1.55e-12             jswgs=1.6e-012
+ jswgd=1.6e-012            njs=1                     njd=1
+ ijthsfwd=0.01             ijthdfwd=0.01             ijthsrev=0.01
+ ijthdrev=0.01             bvs=10                    bvd=10
+ xjbvs=1                   xjbvd=1                   pbs=0.7126
+ pbd=0.7126                cjs=cjn_33                cjd=cjn_33
+ mjs=0.3234                mjd=0.3234                pbsws=0.5345
+ pbswd=0.5345              cjsws=cjswn_33            cjswd=cjswn_33
+ mjsws=0.1391              mjswd=0.1391              pbswgs=0.73
+ pbswgd=0.73               cjswgs=cjswgn_33          cjswgd=cjswgn_33
+ mjswgs=0.5126             mjswgd=0.5126             tpb=0.0015
+ tcj=0.000891              tpbsw=0.00139             tcjsw=0.000445
+ tpbswg=0.0014             tcjswg=0.00129            xtis=3
+ xtid=3                    dmcg=1.125e-007           dmci=1.125e-007
+ dmdg=0                    dmcgt=0                   dwj=0
+ xgw=0                     xgl=0                     rshg=1
+ gbmin=1e-012              rbpb=50                   rbpd=50
+ rbps=50                   rbdb=50                   rbsb=50
+ ngcon=1                   saref=8.2e-07             sbref=8.2e-07
+ wlod=1.5e-07              kvth0=0                   lkvth0=0
+ wkvth0=0                  pkvth0=0                  llodvth=1
+ wlodvth=1                 stk2=0                    lodk2=1
+ lodeta0=1                 ku0=-8e-08                lku0=2.5e-07
+ wku0=3e-07                pku0=5e-14                llodku0=1
+ wlodku0=1                 kvsat=0.3                 steta0=0
+ tku0=0.1                  minr=1e-3

     12: type=n
+ lmin=3.8e-07              lmax=7e-007-dxln_33       wmin=6e-007-dxwn_33
+ wmax=1e-006-dxwn_33       version=4.5               binunit=2
+ paramchk=1                mobmod=0                  capmod=2
+ igcmod=0                  igbmod=0                  geomod=0
+ diomod=1                  rdsmod=0                  rbodymod=0
+ rgatemod=0                permod=1                  acnqsmod=0
+ trnqsmod=0                tempmod=0                 wpemod=wpeflag_33
+ tnom=25                   toxe=toxn_33              toxm=toxn_33
+ dtox=2.78e-010            epsrox=3.9                wint=5.05e-008
+ lint=6.25e-009            ll=0                      wl=0
+ lln=1                     wln=1                     lw=0
+ ww=0                      lwn=1                     wwn=1
+ lwl=0                     wwl=0                     llc=0
+ wlc=0                     lwc=0                     wwc=0
+ lwlc=0                    wwlc=0                    xl=-1.5e-08+dxln_33
+ xw=0+dxwn_33              dlc=5.318e-8              dwc=0
+ xpart=1                   toxref=3e-009             dlcig=6.25e-009
+ vth0=0.56637213+dvthn_33  lvth0=1.9758638e-008+dlvthn_33
+ wvth0=-7.2477099e-009+dwvthn_33                     pvth0=-9.3050712e-015
+ k1=0.56256                k2=0.077786895+dk2n_33    lk2=-1.9033024e-008
+ wk2=-3.5143332e-008       pk2=1.9108628e-014        k3=-3.628
+ k3b=0.8                   w0=0                      dvt0=11.761
+ dvt1=0.4                  dvt2=-0.115               dvt0w=0
+ dvt1w=0                   dvt2w=0                   dsub=0.17
+ minv=-0.3                 voffl=0                   dvtp0=1.4e-006
+ dvtp1=0.06                lpe0=1e-007               lpeb=0
+ web=0                     wec=0                     scref=1e-06
+ kvth0we=0.023             lkvth0we=0                wkvth0we=0
+ pkvth0we=0                k2we=0                    lk2we=0
+ wk2we=0                   pk2we=0                   xj=1.5e-007
+ ngate=3.26e+020           ndep=4.2e+017             nsd=1e+020
+ phin=0                    cdsc=0                    cdscb=0
+ cdscd=0                   cit=0.001239399           lcit=-1.4616377e-010
+ wcit=-2.9598921e-010      pcit=6.4803233e-017       voff=-0.086430962
+ lvoff=-3.1266904e-008     wvoff=9.9074232e-009      pvoff=1.0302043e-015
+ nfactor=0.97067715        lnfactor=4.9948493e-008   wnfactor=1.4632103e-008
+ pnfactor=-2.4924298e-014  eta0=0.063017449          leta0=1.3862244e-009
+ weta0=-1.8894686e-008     peta0=-1.2462157e-015     etab=-0.052892285
+ letab=4.9948493e-009      wetab=1.940725e-008       petab=-2.4924298e-015
+ ud=0                      lud=0                     wud=0
+ pud=0                     ku0we=-0.006              lku0we=0
+ wku0we=0                  pku0we=0                  u0=540.78839+du0n_33
+ lu0=-6.5884414e-005+dlu0n_33                        wu0=-5.0296759e-005
+ pu0=9.3881522e-012        ua=9.0939656e-010         lua=-8.0191963e-016
+ wua=-3.5453715e-016       pua=5.7333445e-023        ub=9.9241843e-019
+ lub=1.8607949e-025        wub=5.0209842e-026        pub=3.820064e-032
+ uc=1.0414731e-010         luc=-5.0709736e-017       wuc=-2.6787786e-017
+ puc=1.5752155e-023        vsat=104897.54            lvsat=-0.006656095
+ wvsat=-0.0074124306       pvsat=4.9848596e-009      a0=0.53724989
+ la0=-1.6575472e-007       wa0=2.9190354e-007        pa0=-8.1354487e-014
+ ags=-4.7962313            lags=3.0934576e-006       wags=2.2253653e-006
+ pags=-1.2533022e-012      a1=0                      a2=0.8
+ b0=0                      b1=0                      keta=-0.067030261
+ lketa=3.6373686e-008      wketa=5.1711685e-009      pketa=-1.6450033e-014
+ dwg=0                     dwb=0                     pclm=-0.070817721
+ lpclm=1.3525168e-007      wpclm=9.75181e-008        ppclm=2.4924314e-014
+ pdiblc1=0                 pdiblc2=-0.00070534414    lpdiblc2=1.5357171e-009
+ wpdiblc2=2.4215692e-009   ppdiblc2=-6.4803174e-016  pdiblcb=0
+ drout=0.56                pvag=0                    delta=0.012
+ pscbe1=7.506e+008         pscbe2=1e-020             fprout=0
+ pdits=0                   pditsd=0                  pditsl=0
+ rsh=10.5                  rdsw=700+drdswn_33        prwg=0
+ prwb=0                    wr=1                      alpha0=0
+ alpha1=2.2950             beta0=17.8                agidl=0
+ bgidl=1.698e+009          cgidl=0.25                egidl=0.2624
+ aigbacc=0.01213           bigbacc=0.006537          cigbacc=0.2809
+ nigbacc=4.05              aigbinv=0.35              bigbinv=0.03
+ cigbinv=0.006             eigbinv=1.1               nigbinv=1
+ aigc=0.01                 bigc=0.00144              cigc=1.515e-005
+ aigsd=0.008379            bigsd=0.0002699           cigsd=3.925e-020
+ nigc=1                    poxedge=1                 pigcd=2.171
+ ntox=1                    xrcrg1=12                 xrcrg2=1
+ cgso=cgon_33              cgdo=cgon_33              cgbo=0
+ cgdl=cgln_33              cgsl=cgln_33              clc=1e-007
+ cle=0.6                   cf=cfn_33                 ckappas=0.6
+ ckappad=0.6               acde=0.4                  moin=5
+ noff=1.4479               voffcv=-0.0921            kt1=-0.70585485
+ lkt1=2.0670925e-007       wkt1=1.9307761e-007       pkt1=-1.0887764e-013
+ kt1l=0                    kt2=-0.0062580078         lkt2=-9.2414897e-009
+ wkt2=-1.2354051e-008      pkt2=8.3080993e-015       ute=-0.2398923
+ lute=-2.2203744e-007      wute=-7.7800644e-007      pute=2.4882757e-013
+ ua1=9.4521781e-009        lua1=-2.7344466e-015      wua1=-4.739134e-015
+ pua1=1.5689845e-021       ub1=-1.1456027e-017       lub1=3.9341352e-024
+ wub1=5.5635075e-024       pub1=-1.9425915e-030      uc1=-3.1887088e-010
+ luc1=1.5817763e-016       wuc1=1.5167445e-016       puc1=-7.5603703e-023
+ prt=0                     at=-41704.863             lat=0.023858526
+ wat=0.026697367           pat=-1.1166085e-008       fnoimod=1
+ tnoimod=0                 noia=5.3e41               noib=1e20
+ noic=10000000             em=10000000               ef=0.8
+ jss=4.1e-07               jsd=4.1e-07               jsws=1.55e-12
+ jswd=1.55e-12             jswgs=1.6e-012            jswgd=1.6e-012
+ njs=1                     njd=1                     ijthsfwd=0.01
+ ijthdfwd=0.01             ijthsrev=0.01             ijthdrev=0.01
+ bvs=10                    bvd=10                    xjbvs=1
+ xjbvd=1                   pbs=0.7126                pbd=0.7126
+ cjs=cjn_33                cjd=cjn_33                mjs=0.3234
+ mjd=0.3234                pbsws=0.5345              pbswd=0.5345
+ cjsws=cjswn_33            cjswd=cjswn_33            mjsws=0.1391
+ mjswd=0.1391              pbswgs=0.73               pbswgd=0.73
+ cjswgs=cjswgn_33          cjswgd=cjswgn_33          mjswgs=0.5126
+ mjswgd=0.5126             tpb=0.0015                tcj=0.000891
+ tpbsw=0.00139             tcjsw=0.000445            tpbswg=0.0014
+ tcjswg=0.00129            xtis=3                    xtid=3
+ dmcg=1.125e-007           dmci=1.125e-007           dmdg=0
+ dmcgt=0                   dwj=0                     xgw=0
+ xgl=0                     rshg=1                    gbmin=1e-012
+ rbpb=50                   rbpd=50                   rbps=50
+ rbdb=50                   rbsb=50                   ngcon=1
+ saref=8.2e-07             sbref=8.2e-07             wlod=1.5e-07
+ kvth0=0                   lkvth0=0                  wkvth0=0
+ pkvth0=0                  llodvth=1                 wlodvth=1
+ stk2=0                    lodk2=1                   lodeta0=1
+ ku0=-8e-08                lku0=2.5e-07              wku0=3e-07
+ pku0=5e-14                llodku0=1                 wlodku0=1
+ kvsat=0.3                 steta0=0                  tku0=0.1
+ minr=1e-3

     13: type=n
+ lmin=1e-005-dxln_33       lmax=0.0009001            wmin=4e-07
+ wmax=6e-007-dxwn_33       version=4.5               binunit=2
+ paramchk=1                mobmod=0                  capmod=2
+ igcmod=0                  igbmod=0                  geomod=0
+ diomod=1                  rdsmod=0                  rbodymod=0
+ rgatemod=0                permod=1                  acnqsmod=0
+ trnqsmod=0                tempmod=0                 wpemod=wpeflag_33
+ tnom=25                   toxe=toxn_33              toxm=toxn_33
+ dtox=2.78e-010            epsrox=3.9                wint=5.05e-008
+ lint=6.25e-009            ll=0                      wl=0
+ lln=1                     wln=1                     lw=0
+ ww=0                      lwn=1                     wwn=1
+ lwl=0                     wwl=0                     llc=0
+ wlc=0                     lwc=0                     wwc=0
+ lwlc=0                    wwlc=0                    xl=-1.5e-08+dxln_33
+ xw=0+dxwn_33              dlc=5.318e-8              dwc=0
+ xpart=1                   toxref=3e-009             dlcig=6.25e-009
+ vth0=0.5340135+dvthn_33   wvth0=9.4742635e-009+dwvthn_33
+ k1=0.56256                k2=0.05294+dk2n_33        k3=-3.628
+ k3b=0.8                   w0=0                      dvt0=11.761
+ dvt1=0.4                  dvt2=-0.115               dvt0w=0
+ dvt1w=0                   dvt2w=0                   dsub=0.17
+ minv=-0.3                 voffl=0                   dvtp0=1.4e-006
+ dvtp1=0.06                lpe0=1e-007               lpeb=0
+ web=0                     wec=0                     scref=1e-06
+ kvth0we=0.023             lkvth0we=0                wkvth0we=0
+ pkvth0we=0                k2we=0                    lk2we=0
+ wk2we=0                   pk2we=0                   xj=1.5e-007
+ ngate=3.26e+020           ndep=4.2e+017             nsd=1e+020
+ phin=0                    cdsc=0                    cdscb=0
+ cdscd=0                   cit=-2.9906233e-012       wcit=8.9419636e-019
+ voff=-0.07209805          wvoff=4.0209669e-009      nfactor=0.9505
+ wnfactor=7.46005e-008     eta0=0.018267502          weta0=2.6110168e-009
+ etab=-0.014               ud=0                      lud=0
+ wud=0                     pud=0                     ku0we=-0.006
+ lku0we=0                  wku0we=0                  pku0we=0
+ u0=265.35+du0n_33         wu0=5.222035e-005         ua=-1.2253533e-009
+ wua=3.473164e-016         ub=2.5244525e-018         wub=-3.0287281e-025
+ uc=8.9191495e-011         wuc=-8.728257e-018        vsat=84535
+ wvsat=0.005222035         a0=1.7853776              wa0=-1.4916437e-007
+ ags=0.2647246             wags=-4.647835e-009       a1=0
+ a2=0.8                    b0=0                      b1=0
+ keta=-0.028               dwg=0                     dwb=0
+ pclm=1.22275              wpclm=-3.3570223e-007     pdiblc1=0
+ pdiblc2=0.0020212499      wpdiblc2=-5.5950371e-010  pdiblcb=0
+ drout=0.56                pvag=0                    delta=0.012
+ pscbe1=7.506e+008         pscbe2=1e-020             fprout=0
+ pdits=0                   pditsd=0                  pditsl=0
+ rsh=10.5                  rdsw=700+drdswn_33        prwg=0
+ prwb=0                    wr=1                      alpha0=0
+ alpha1=2.2950             beta0=17.8                agidl=0
+ bgidl=1.698e+009          cgidl=0.25                egidl=0.2624
+ aigbacc=0.01213           bigbacc=0.006537          cigbacc=0.2809
+ nigbacc=4.05              aigbinv=0.35              bigbinv=0.03
+ cigbinv=0.006             eigbinv=1.1               nigbinv=1
+ aigc=0.01                 bigc=0.00144              cigc=1.515e-005
+ aigsd=0.008379            bigsd=0.0002699           cigsd=3.925e-020
+ nigc=1                    poxedge=1                 pigcd=2.171
+ ntox=1                    xrcrg1=12                 xrcrg2=1
+ cgso=cgon_33              cgdo=cgon_33              cgbo=0
+ cgdl=cgln_33              cgsl=cgln_33              clc=1e-007
+ cle=0.6                   cf=cfn_33                 ckappas=0.6
+ ckappad=0.6               acde=0.4                  moin=5
+ noff=1.4479               voffcv=-0.0921            kt1=-0.246512
+ wkt1=-1.6710512e-008      kt1l=0                    kt2=-0.02
+ ute=-1.7941055            wute=1.1108014e-007       ua1=-4.598483e-010
+ wua1=3.7922418e-016       ub1=-2.841862e-019        wub1=-2.3666263e-025
+ uc1=-6e-011               prt=0                     at=-12425
+ wat=0.011190075           fnoimod=1                 tnoimod=0
+ noia=5.3e41               noib=1e20                 noic=10000000
+ em=10000000               ef=0.8                    jss=4.1e-07
+ jsd=4.1e-07               jsws=1.55e-12             jswd=1.55e-12
+ jswgs=1.6e-012            jswgd=1.6e-012            njs=1
+ njd=1                     ijthsfwd=0.01             ijthdfwd=0.01
+ ijthsrev=0.01             ijthdrev=0.01             bvs=10
+ bvd=10                    xjbvs=1                   xjbvd=1
+ pbs=0.7126                pbd=0.7126                cjs=cjn_33
+ cjd=cjn_33                mjs=0.3234                mjd=0.3234
+ pbsws=0.5345              pbswd=0.5345              cjsws=cjswn_33
+ cjswd=cjswn_33            mjsws=0.1391              mjswd=0.1391
+ pbswgs=0.73               pbswgd=0.73               cjswgs=cjswgn_33
+ cjswgd=cjswgn_33          mjswgs=0.5126             mjswgd=0.5126
+ tpb=0.0015                tcj=0.000891              tpbsw=0.00139
+ tcjsw=0.000445            tpbswg=0.0014             tcjswg=0.00129
+ xtis=3                    xtid=3                    dmcg=1.125e-007
+ dmci=1.125e-007           dmdg=0                    dmcgt=0
+ dwj=0                     xgw=0                     xgl=0
+ rshg=1                    gbmin=1e-012              rbpb=50
+ rbpd=50                   rbps=50                   rbdb=50
+ rbsb=50                   ngcon=1                   saref=8.2e-07
+ sbref=8.2e-07             wlod=1.5e-07              kvth0=0
+ lkvth0=0                  wkvth0=0                  pkvth0=0
+ llodvth=1                 wlodvth=1                 stk2=0
+ lodk2=1                   lodeta0=1                 ku0=-8e-08
+ lku0=2.5e-07              wku0=3e-07                pku0=5e-14
+ llodku0=1                 wlodku0=1                 kvsat=0.3
+ steta0=0                  tku0=0.1                  lvth0=0+dlvthn_33
+ lu0=0+dlu0n_33            minr=1e-3

     14: type=n
+ lmin=1.2e-006-dxln_33     lmax=1e-005-dxln_33       wmin=4e-07
+ wmax=6e-007-dxwn_33       version=4.5               binunit=2
+ paramchk=1                mobmod=0                  capmod=2
+ igcmod=0                  igbmod=0                  geomod=0
+ diomod=1                  rdsmod=0                  rbodymod=0
+ rgatemod=0                permod=1                  acnqsmod=0
+ trnqsmod=0                tempmod=0                 wpemod=wpeflag_33
+ tnom=25                   toxe=toxn_33              toxm=toxn_33
+ dtox=2.78e-010            epsrox=3.9                wint=5.05e-008
+ lint=6.25e-009            ll=0                      wl=0
+ lln=1                     wln=1                     lw=0
+ ww=0                      lwn=1                     wwn=1
+ lwl=0                     wwl=0                     llc=0
+ wlc=0                     lwc=0                     wwc=0
+ lwlc=0                    wwlc=0                    xl=-1.5e-08+dxln_33
+ xw=0+dxwn_33              dlc=5.318e-8              dwc=0
+ xpart=1                   toxref=3e-009             dlcig=6.25e-009
+ vth0=0.52600552+dvthn_33  lvth0=7.9859552e-008+dlvthn_33
+ wvth0=1.2406467e-008+dwvthn_33                      pvth0=-2.9241398e-014
+ k1=0.56256                k2=0.055009196+dk2n_33    lk2=-2.0635057e-008
+ k3=-3.628                 k3b=0.8                   w0=0
+ dvt0=11.761               dvt1=0.4                  dvt2=-0.115
+ dvt0w=0                   dvt1w=0                   dvt2w=0
+ dsub=0.17                 minv=-0.3                 voffl=0
+ dvtp0=1.4e-006            dvtp1=0.06                lpe0=1e-007
+ lpeb=0                    web=0                     wec=0
+ scref=1e-06               kvth0we=0.023             lkvth0we=0
+ wkvth0we=0                pkvth0we=0                k2we=0
+ lk2we=0                   wk2we=0                   pk2we=0
+ xj=1.5e-007               ngate=3.26e+020           ndep=4.2e+017
+ nsd=1e+020                phin=0                    cdsc=0
+ cdscb=0                   cdscd=0                   cit=-6.399999e-012
+ lcit=3.3999999e-017       wcit=1.9135997e-018       pcit=-1.0166e-023
+ voff=-0.060925345         lvoff=-1.1141981e-007     wvoff=1.0360846e-009
+ pvoff=2.9766739e-014      nfactor=0.97714773        lnfactor=-2.6574453e-007
+ wnfactor=7.4600498e-008   pnfactor=1.982467e-020    eta0=0.018267502
+ weta0=2.6110168e-009      etab=-0.014               ud=0
+ lud=0                     wud=0                     pud=0
+ ku0we=-0.006              lku0we=0                  wku0we=0
+ pku0we=0                  u0=265.35+du0n_33         wu0=5.222035e-005
+ ua=-1.2763978e-009        lua=5.0904074e-016        wua=3.7069812e-016
+ pua=-2.3317421e-022       ub=2.6763321e-018         lub=-1.5146194e-024
+ wub=-3.4010313e-025       pub=3.7127939e-031        uc=9.801076e-011
+ luc=-8.7950124e-017       wuc=-9.8911984e-018       puc=1.1597433e-023
+ vsat=84535                wvsat=0.005222035         a0=1.9251011
+ la0=-1.3933926e-006       wa0=-1.6796293e-007       pa0=1.8746868e-013
+ ags=0.24961191            lags=1.507113e-007        wags=-6.1925897e-009
+ pags=1.5405067e-014       a1=0                      a2=0.8
+ b0=0                      b1=0                      keta=-0.025655
+ lketa=-2.3385513e-008     dwg=0                     dwb=0
+ pclm=1.3656417            lpclm=-1.4249883e-006     wpclm=-3.8639454e-007
+ ppclm=5.0552908e-013      pdiblc1=0                 pdiblc2=0.0017581369
+ lpdiblc2=2.6238942e-009   wpdiblc2=-5.5453388e-010  ppdiblc2=-4.9561624e-017
+ pdiblcb=0                 drout=0.56                pvag=0
+ delta=0.012               pscbe1=7.506e+008         pscbe2=1e-020
+ fprout=0                  pdits=0                   pditsd=0
+ pditsl=0                  rsh=10.5                  rdsw=700+drdswn_33
+ prwg=0                    prwb=0                    wr=1
+ alpha0=0                  alpha1=2.2950             beta0=17.8
+ agidl=0                   bgidl=1.698e+009          cgidl=0.25
+ egidl=0.2624              aigbacc=0.01213           bigbacc=0.006537
+ cigbacc=0.2809            nigbacc=4.05              aigbinv=0.35
+ bigbinv=0.03              cigbinv=0.006             eigbinv=1.1
+ nigbinv=1                 aigc=0.01                 bigc=0.00144
+ cigc=1.515e-005           aigsd=0.008379            bigsd=0.0002699
+ cigsd=3.925e-020          nigc=1                    poxedge=1
+ pigcd=2.171               ntox=1                    xrcrg1=12
+ xrcrg2=1                  cgso=cgon_33              cgdo=cgon_33
+ cgbo=0                    cgdl=cgln_33              cgsl=cgln_33
+ clc=1e-007                cle=0.6                   cf=cfn_33
+ ckappas=0.6               ckappad=0.6               acde=0.4
+ moin=5                    noff=1.4479               voffcv=-0.0921
+ kt1=-0.2246528            lkt1=-2.1799085e-007      wkt1=-2.246558e-008
+ pkt1=5.7392419e-014       kt1l=0                    kt2=-0.02
+ ute=-1.9821508            lute=1.8752814e-006       wute=1.7476329e-007
+ pute=-6.3508022e-013      ua1=-1.4066945e-009       lua1=9.4424236e-015
+ wua1=7.0066533e-016       pua1=-3.2055719e-021      ub1=6.9277418e-019
+ lub1=-9.7427374e-024      wub1=-5.6142522e-025      pub1=3.238695e-030
+ uc1=-4.8008523e-011       luc1=-1.1958501e-016      prt=0
+ at=-20709.445             lat=0.082616627           wat=0.012631327
+ pat=-1.4372883e-008       fnoimod=1                 tnoimod=0
+ noia=5.3e41               noib=1e20                 noic=10000000
+ em=10000000               ef=0.8                    jss=4.1e-07
+ jsd=4.1e-07               jsws=1.55e-12             jswd=1.55e-12
+ jswgs=1.6e-012            jswgd=1.6e-012            njs=1
+ njd=1                     ijthsfwd=0.01             ijthdfwd=0.01
+ ijthsrev=0.01             ijthdrev=0.01             bvs=10
+ bvd=10                    xjbvs=1                   xjbvd=1
+ pbs=0.7126                pbd=0.7126                cjs=cjn_33
+ cjd=cjn_33                mjs=0.3234                mjd=0.3234
+ pbsws=0.5345              pbswd=0.5345              cjsws=cjswn_33
+ cjswd=cjswn_33            mjsws=0.1391              mjswd=0.1391
+ pbswgs=0.73               pbswgd=0.73               cjswgs=cjswgn_33
+ cjswgd=cjswgn_33          mjswgs=0.5126             mjswgd=0.5126
+ tpb=0.0015                tcj=0.000891              tpbsw=0.00139
+ tcjsw=0.000445            tpbswg=0.0014             tcjswg=0.00129
+ xtis=3                    xtid=3                    dmcg=1.125e-007
+ dmci=1.125e-007           dmdg=0                    dmcgt=0
+ dwj=0                     xgw=0                     xgl=0
+ rshg=1                    gbmin=1e-012              rbpb=50
+ rbpd=50                   rbps=50                   rbdb=50
+ rbsb=50                   ngcon=1                   saref=8.2e-07
+ sbref=8.2e-07             wlod=1.5e-07              kvth0=0
+ lkvth0=0                  wkvth0=0                  pkvth0=0
+ llodvth=1                 wlodvth=1                 stk2=0
+ lodk2=1                   lodeta0=1                 ku0=-8e-08
+ lku0=2.5e-07              wku0=3e-07                pku0=5e-14
+ llodku0=1                 wlodku0=1                 kvsat=0.3
+ steta0=0                  tku0=0.1                  lu0=0+dlu0n_33
+ minr=1e-3

     15: type=n
+ lmin=7e-007-dxln_33       lmax=1.2e-006-dxln_33     wmin=4e-07
+ wmax=6e-007-dxwn_33       version=4.5               binunit=2
+ paramchk=1                mobmod=0                  capmod=2
+ igcmod=0                  igbmod=0                  geomod=0
+ diomod=1                  rdsmod=0                  rbodymod=0
+ rgatemod=0                permod=1                  acnqsmod=0
+ trnqsmod=0                tempmod=0                 wpemod=wpeflag_33
+ tnom=25                   toxe=toxn_33              toxm=toxn_33
+ dtox=2.78e-010            epsrox=3.9                wint=5.05e-008
+ lint=6.25e-009            ll=0                      wl=0
+ lln=1                     wln=1                     lw=0
+ ww=0                      lwn=1                     wwn=1
+ lwl=0                     wwl=0                     llc=0
+ wlc=0                     lwc=0                     wwc=0
+ lwlc=0                    wwlc=0                    xl=-1.5e-08+dxln_33
+ xw=0+dxwn_33              dlc=5.318e-8              dwc=0
+ xpart=1                   toxref=3e-009             dlcig=6.25e-009
+ vth0=0.64874456+dvthn_33  lvth0=-6.4051963e-008+dlvthn_33
+ wvth0=-2.938963e-008+dwvthn_33                      pvth0=1.9764526e-014
+ k1=0.56256                k2=0.03930645+dk2n_33     lk2=-2.2235876e-009
+ k3=-3.628                 k3b=0.8                   w0=0
+ dvt0=11.761               dvt1=0.4                  dvt2=-0.115
+ dvt0w=0                   dvt1w=0                   dvt2w=0
+ dsub=0.17                 minv=-0.3                 voffl=0
+ dvtp0=1.4e-006            dvtp1=0.06                lpe0=1e-007
+ lpeb=0                    web=0                     wec=0
+ scref=1e-06               kvth0we=0.023             lkvth0we=0
+ wkvth0we=0                pkvth0we=0                k2we=0
+ lk2we=0                   wk2we=0                   pk2we=0
+ xj=1.5e-007               ngate=3.26e+020           ndep=4.2e+017
+ nsd=1e+020                phin=0                    cdsc=0
+ cdscb=0                   cdscd=0                   cit=-0.0013934409
+ lcit=1.6338095e-009       wcit=2.7786864e-010       pcit=-3.2580099e-016
+ voff=-0.2521438           lvoff=1.1278383e-007      wvoff=7.9120839e-008
+ pvoff=-6.1787635e-014     nfactor=0.41492238        lnfactor=3.934647e-007
+ wnfactor=1.7493821e-007   pnfactor=-1.1764594e-013  eta0=0.018267502
+ weta0=2.6110168e-009      etab=-0.014               ud=0
+ lud=-2.3576337e+008       wud=-1.0033767e+008       pud=117.64592
+ ku0we=-0.006              lku0we=0                  wku0we=0
+ pku0we=0                  u0=265.35+du0n_33         wu0=5.222035e-005
+ ua=-8.1862595e-010        lua=-2.7696739e-017       wua=3.7802774e-016
+ pua=-2.4176819e-022       ub=1.591308e-018          lub=-2.4242864e-025
+ wub=-2.2461996e-025       pub=2.3587537e-031        uc=4.0431192e-011
+ luc=-2.043808e-017        wuc=-8.0270106e-018       puc=9.4116725e-024
+ vsat=84535                wvsat=0.005222035         a0=0.65141354
+ la0=1.0000605e-007        wa0=9.3013733e-008        pa0=-1.1852647e-013
+ ags=0.33901284            lags=4.5888704e-008       wags=-6.5152367e-008
+ pags=8.4535406e-014       a1=0                      a2=0.8
+ b0=0                      b1=0                      keta=-0.071311005
+ lketa=3.0146154e-008      wketa=1.6856725e-008      pketa=-1.976451e-014
+ dwg=0                     dwb=0                     pclm=-0.18554661
+ lpclm=3.9378008e-007      wpclm=1.0496297e-007      ppclm=-7.05876e-014
+ pdiblc1=0                 pdiblc2=0.0063342819      lpdiblc2=-2.7416358e-009
+ wpdiblc2=-2.9045703e-009  ppdiblc2=2.7058561e-015   pdiblcb=0
+ drout=0.56                pvag=0                    delta=0.012
+ pscbe1=7.506e+008         pscbe2=1e-020             fprout=0
+ pdits=0                   pditsd=0                  pditsl=0
+ rsh=10.5                  rdsw=700+drdswn_33        prwg=0
+ prwb=0                    wr=1                      alpha0=0
+ alpha1=2.2950             beta0=17.8                agidl=0
+ bgidl=1.698e+009          cgidl=0.25                egidl=0.2624
+ aigbacc=0.01213           bigbacc=0.006537          cigbacc=0.2809
+ nigbacc=4.05              aigbinv=0.35              bigbinv=0.03
+ cigbinv=0.006             eigbinv=1.1               nigbinv=1
+ aigc=0.01                 bigc=0.00144              cigc=1.515e-005
+ aigsd=0.008379            bigsd=0.0002699           cigsd=3.925e-020
+ nigc=1                    poxedge=1                 pigcd=2.171
+ ntox=1                    xrcrg1=12                 xrcrg2=1
+ cgso=cgon_33              cgdo=cgon_33              cgbo=0
+ cgdl=cgln_33              cgsl=cgln_33              clc=1e-007
+ cle=0.6                   cf=cfn_33                 ckappas=0.6
+ ckappad=0.6               acde=0.4                  moin=5
+ noff=1.4479               voffcv=-0.0921            kt1=-0.53661043
+ lkt1=1.4777948e-007       wkt1=7.4946273e-008       pkt1=-5.682298e-014
+ kt1l=0                    kt2=-0.02                 ute=1.2198205
+ lute=-1.8790299e-006      wute=-9.8556192e-007      pute=7.254011e-013
+ ua1=1.5751921e-008        lua1=-1.0676053e-014      wua1=-5.2295365e-015
+ pua1=3.7475898e-021       ub1=-1.8669766e-017       lub1=1.295984e-023
+ wub1=5.7292306e-024       pub1=-4.137099e-030       uc1=-4.1540213e-010
+ luc1=3.1118399e-016       wuc1=3.5118185e-017       puc1=-4.1176072e-023
+ prt=0                     at=109904.26              lat=-0.070527937
+ wat=-0.005145566          pat=6.4705233e-009        fnoimod=1
+ tnoimod=0                 noia=5.3e41               noib=1e20
+ noic=10000000             em=10000000               ef=0.8
+ jss=4.1e-07               jsd=4.1e-07               jsws=1.55e-12
+ jswd=1.55e-12             jswgs=1.6e-012            jswgd=1.6e-012
+ njs=1                     njd=1                     ijthsfwd=0.01
+ ijthdfwd=0.01             ijthsrev=0.01             ijthdrev=0.01
+ bvs=10                    bvd=10                    xjbvs=1
+ xjbvd=1                   pbs=0.7126                pbd=0.7126
+ cjs=cjn_33                cjd=cjn_33                mjs=0.3234
+ mjd=0.3234                pbsws=0.5345              pbswd=0.5345
+ cjsws=cjswn_33            cjswd=cjswn_33            mjsws=0.1391
+ mjswd=0.1391              pbswgs=0.73               pbswgd=0.73
+ cjswgs=cjswgn_33          cjswgd=cjswgn_33          mjswgs=0.5126
+ mjswgd=0.5126             tpb=0.0015                tcj=0.000891
+ tpbsw=0.00139             tcjsw=0.000445            tpbswg=0.0014
+ tcjswg=0.00129            xtis=3                    xtid=3
+ dmcg=1.125e-007           dmci=1.125e-007           dmdg=0
+ dmcgt=0                   dwj=0                     xgw=0
+ xgl=0                     rshg=1                    gbmin=1e-012
+ rbpb=50                   rbpd=50                   rbps=50
+ rbdb=50                   rbsb=50                   ngcon=1
+ saref=8.2e-07             sbref=8.2e-07             wlod=1.5e-07
+ kvth0=0                   lkvth0=0                  wkvth0=0
+ pkvth0=0                  llodvth=1                 wlodvth=1
+ stk2=0                    lodk2=1                   lodeta0=1
+ ku0=-8e-08                lku0=2.5e-07              wku0=3e-07
+ pku0=5e-14                llodku0=1                 wlodku0=1
+ kvsat=0.3                 steta0=0                  tku0=0.1
+ lu0=0+dlu0n_33            minr=1e-3

     16: type=n
+ lmin=3.8e-07              lmax=7e-007-dxln_33       wmin=4e-07
+ wmax=6e-007-dxwn_33       version=4.5               binunit=2
+ paramchk=1                mobmod=0                  capmod=2
+ igcmod=0                  igbmod=0                  geomod=0
+ diomod=1                  rdsmod=0                  rbodymod=0
+ rgatemod=0                permod=1                  acnqsmod=0
+ trnqsmod=0                tempmod=0                 wpemod=wpeflag_33
+ tnom=25                   toxe=toxn_33              toxm=toxn_33
+ dtox=2.78e-010            epsrox=3.9                wint=5.05e-008
+ lint=6.25e-009            ll=0                      wl=0
+ lln=1                     wln=1                     lw=0
+ ww=0                      lwn=1                     wwn=1
+ lwl=0                     wwl=0                     llc=0
+ wlc=0                     lwc=0                     wwc=0
+ lwlc=0                    wwlc=0                    xl=-1.5e-08+dxln_33
+ xw=0+dxwn_33              dlc=5.318e-8              dwc=0
+ xpart=1                   toxref=3e-009             dlcig=6.25e-009
+ vth0=0.57325652+dvthn_33  lvth0=-1.3286262e-008+dlvthn_33
+ wvth0=-1.0683025e-008+dwvthn_33                     pvth0=7.1843341e-015
+ k1=0.56256                k2=0.037002422+dk2n_33    lk2=-6.7412871e-010
+ wk2=-1.479188e-008        pk2=9.9475396e-015        k3=-3.628
+ k3b=0.8                   w0=0                      dvt0=11.761
+ dvt1=0.4                  dvt2=-0.115               dvt0w=0
+ dvt1w=0                   dvt2w=0                   dsub=0.17
+ minv=-0.3                 voffl=0                   dvtp0=1.4e-006
+ dvtp1=0.06                lpe0=1e-007               lpeb=0
+ web=0                     wec=0                     scref=1e-06
+ kvth0we=0.023             lkvth0we=0                wkvth0we=0
+ pkvth0we=0                k2we=0                    lk2we=0
+ wk2we=0                   pk2we=0                   xj=1.5e-007
+ ngate=3.26e+020           ndep=4.2e+017             nsd=1e+020
+ phin=0                    cdsc=0                    cdscb=0
+ cdscd=0                   cit=0.001104605           lcit=-4.6126381e-011
+ wcit=-2.28727e-010        pcit=1.4884575e-017       voff=-0.0032499582
+ lvoff=-5.4597277e-008     wvoff=-3.1599898e-008     pvoff=1.267206e-014
+ nfactor=1.0823418         lnfactor=-5.5374858e-008  wnfactor=-4.1088557e-008
+ pnfactor=2.7632054e-014   eta0=0.027330611          leta0=-6.0949403e-009
+ weta0=-1.0869542e-009     peta0=2.4868854e-015      etab=0.0090557027
+ letab=-1.550496e-008      wetab=-1.1504796e-008     petab=7.7369752e-015
+ ud=0                      lud=1.1074972e+008        wud=1.5677761e+008
+ pud=-55.264109            ku0we=-0.006              lku0we=0
+ wku0we=0                  pku0we=0                  u0=439.98324+du0n_33
+ lu0=-0.00011744085+dlu0n_33                         wu0=5.0122211e-009
+ pu0=3.5114815e-011        ua=1.3859651e-009         lua=-1.5102842e-015
+ wua=-5.9234483e-016       pua=4.1080736e-022        ub=-8.2790313e-019
+ lub=1.3844909e-024        wub=9.585503e-025         pub=-5.5980663e-031
+ uc=-2.1045223e-011        luc=2.0904809e-017        wuc=3.5683287e-017
+ puc=-1.9983503e-023       vsat=84518.477            lvsat=1.1112012e-005
+ wvsat=0.0027567216        pvsat=1.6579233e-009      a0=1.4977032
+ la0=-4.6912373e-007       wa0=-1.8736265e-007       pa0=7.002665e-014
+ ags=-1.1087007            lags=1.0194761e-006       wags=3.8528751e-007
+ pags=-2.1838541e-013      a1=0                      a2=0.8
+ b0=0                      b1=0                      keta=-0.066464132
+ lketa=2.6886632e-008      wketa=4.8886703e-009      pketa=-1.1715993e-014
+ dwg=0                     dwb=0                     pclm=0.20695113
+ lpclm=1.2982535e-007      wpclm=-4.1088557e-008     ppclm=2.7632054e-014
+ pdiblc1=0                 pdiblc2=-0.00056525391    lpdiblc2=1.898302e-009
+ wpdiblc2=2.3516642e-009   ppdiblc2=-8.2896163e-016  pdiblcb=0
+ drout=0.56                pvag=0                    delta=0.012
+ pscbe1=7.506e+008         pscbe2=1e-020             fprout=0
+ pdits=0                   pditsd=0                  pditsl=0
+ rsh=10.5                  rdsw=700+drdswn_33        prwg=0
+ prwb=0                    wr=1                      alpha0=0
+ alpha1=2.2950             beta0=17.8                agidl=0
+ bgidl=1.698e+009          cgidl=0.25                egidl=0.2624
+ aigbacc=0.01213           bigbacc=0.006537          cigbacc=0.2809
+ nigbacc=4.05              aigbinv=0.35              bigbinv=0.03
+ cigbinv=0.006             eigbinv=1.1               nigbinv=1
+ aigc=0.01                 bigc=0.00144              cigc=1.515e-005
+ aigsd=0.008379            bigsd=0.0002699           cigsd=3.925e-020
+ nigc=1                    poxedge=1                 pigcd=2.171
+ ntox=1                    xrcrg1=12                 xrcrg2=1
+ cgso=cgon_33              cgdo=cgon_33              cgbo=0
+ cgdl=cgln_33              cgsl=cgln_33              clc=1e-007
+ cle=0.6                   cf=cfn_33                 ckappas=0.6
+ ckappad=0.6               acde=0.4                  moin=5
+ noff=1.4479               voffcv=-0.0921            kt1=-0.32564511
+ lkt1=5.9052934e-009       wkt1=3.3529428e-009       pkt1=-8.6764651e-015
+ kt1l=0                    kt2=-0.047483984          lkt2=1.8482979e-008
+ wkt2=8.2177113e-009       pkt2=-5.5264109e-015      ute=-2.7866204
+ lute=8.1530163e-007       wute=4.928109e-007        pute=-2.6880462e-013
+ ua1=-2.3936665e-009       lua1=1.5268548e-015       wua1=1.1719425e-015
+ pua1=-5.5740485e-022      ub1=2.3905931e-018        lub1=-1.2032507e-024
+ wub1=-1.3459562e-024      pub1=6.209641e-031        uc1=2.3667809e-010
+ luc1=-1.2733995e-016      wuc1=-1.2554448e-016      puc1=6.6869572e-023
+ prt=0                     at=22588.906              lat=-0.011808364
+ wat=-0.0053852236         pat=6.631693e-009         fnoimod=1
+ tnoimod=0                 noia=5.3e41               noib=1e20
+ noic=10000000             em=10000000               ef=0.8
+ jss=4.1e-07               jsd=4.1e-07               jsws=1.55e-12
+ jswd=1.55e-12             jswgs=1.6e-012            jswgd=1.6e-012
+ njs=1                     njd=1                     ijthsfwd=0.01
+ ijthdfwd=0.01             ijthsrev=0.01             ijthdrev=0.01
+ bvs=10                    bvd=10                    xjbvs=1
+ xjbvd=1                   pbs=0.7126                pbd=0.7126
+ cjs=cjn_33                cjd=cjn_33                mjs=0.3234
+ mjd=0.3234                pbsws=0.5345              pbswd=0.5345
+ cjsws=cjswn_33            cjswd=cjswn_33            mjsws=0.1391
+ mjswd=0.1391              pbswgs=0.73               pbswgd=0.73
+ cjswgs=cjswgn_33          cjswgd=cjswgn_33          mjswgs=0.5126
+ mjswgd=0.5126             tpb=0.0015                tcj=0.000891
+ tpbsw=0.00139             tcjsw=0.000445            tpbswg=0.0014
+ tcjswg=0.00129            xtis=3                    xtid=3
+ dmcg=1.125e-007           dmci=1.125e-007           dmdg=0
+ dmcgt=0                   dwj=0                     xgw=0
+ xgl=0                     rshg=1                    gbmin=1e-012
+ rbpb=50                   rbpd=50                   rbps=50
+ rbdb=50                   rbsb=50                   ngcon=1
+ saref=8.2e-07             sbref=8.2e-07             wlod=1.5e-07
+ kvth0=0                   lkvth0=0                  wkvth0=0
+ pkvth0=0                  llodvth=1                 wlodvth=1
+ stk2=0                    lodk2=1                   lodeta0=1
+ ku0=-8e-08                lku0=2.5e-07              wku0=3e-07
+ pku0=5e-14                llodku0=1                 wlodku0=1
+ kvsat=0.3                 steta0=0                  tku0=0.1
+ minr=1e-3

//  ********************************************************************************************
//
//                *
//                                    3.3V PMOS DEVICE MODELS
//                  *
//
//                *
//  ********************************************************************************************

//  ********************************************************************************************
//
//                *
//                                    3.3V PMOS DEVICE MODELS
//                  *
//
//                *
//  ********************************************************************************************

     }
model pch_33 bsim4  {
     1: type=p
+ lmin=1e-005-dxlp_33       lmax=0.0009001            wmin=1e-005-dxwp_33
+ wmax=0.0009001            version=4.5               binunit=2
+ paramchk=1                mobmod=0                  capmod=2
+ igcmod=0                  igbmod=0                  geomod=0
+ diomod=1                  rdsmod=0                  rbodymod=0
+ rgatemod=0                permod=1                  acnqsmod=0
+ trnqsmod=0                tempmod=0                 wpemod=wpeflag_33
+ tnom=25                   toxe=toxp_33              toxm=toxp_33
+ dtox=4.31e-010            epsrox=3.9                wint=3.99e-008
+ lint=6.95e-008            ll=0                      wl=0
+ lln=1                     wln=1                     lw=0
+ ww=0                      lwn=1                     wwn=1
+ lwl=0                     wwl=0                     llc=0
+ wlc=0                     lwc=0                     wwc=0
+ lwlc=0                    wwlc=0                    xl=-1.5e-08+dxlp_33
+ xw=0+dxwp_33              dlc=4.963e-8              dwc=0
+ xpart=1                   toxref=3e-009             dlcig=6.95e-008
+ vth0=-0.68884+dvthp_33    k1=0.7905                 k2=-0.0333+dk2p_33
+ lk2=-1.0065884e-014       wk2=-1.1096783e-016       pk2=9.9855584e-020
+ k3=-1.5                   k3b=1.2                   w0=0
+ dvt0=0.9                  dvt1=0.14                 dvt2=-0.012
+ dvt0w=0                   dvt1w=0                   dvt2w=0
+ dsub=0.2                  minv=-0.3                 voffl=0
+ dvtp0=0                   dvtp1=0                   lpe0=1.5e-008
+ lpeb=0                    web=0                     wec=0
+ scref=1e-006              kvth0we=-0.016            lkvth0we=0
+ wkvth0we=0                pkvth0we=0                k2we=0
+ lk2we=0                   wk2we=0                   pk2we=0
+ xj=1.8e-007               ngate=8.8e+019            ndep=8.4e+017
+ nsd=1e+020                phin=0                    cdsc=0
+ cdscb=0                   cdscd=0                   cit=0.00029
+ voff=-0.0782              nfactor=0.826             lnfactor=1.1096051e-015
+ wnfactor=1.109679e-015    pnfactor=-9.9855584e-019  eta0=0.025
+ etab=-0.023               ud=0                      lud=0
+ wud=0                     pud=0                     ku0we=-0.006
+ lku0we=0                  wku0we=0                  pku0we=0
+ u0=121.7384+du0p_33       ua=1.057916e-009          ub=1.018144e-018
+ uc=-1.9e-011              vsat=70000                a0=1.278228
+ ags=0.2142058             a1=0                      a2=0.99
+ b0=0                      b1=0                      keta=-0.031
+ dwg=0                     dwb=0                     pclm=0.3
+ pdiblc1=0                 pdiblc2=0.000233          pdiblcb=0
+ drout=0                   pvag=0                    delta=0.007
+ pscbe1=8.564e+008         pscbe2=1e-020             fprout=0
+ pdits=0                   pditsd=0                  pditsl=0
+ rsh=9.68                  rdsw=1005+drdswp_33       prwg=0
+ prwb=0                    wr=1                      alpha0=0
+ alpha1=0.09               beta0=17                  agidl=2.76e-012
+ bgidl=8.66e+008           cgidl=0.25                egidl=0.2624
+ aigbacc=0.01213           bigbacc=0.006537          cigbacc=0.2809
+ nigbacc=4.05              aigbinv=0.35              bigbinv=0.03
+ cigbinv=0.006             eigbinv=1.1               nigbinv=1
+ aigc=0.01                 bigc=0.00144              cigc=1.515e-005
+ aigsd=0.008379            bigsd=0.0002699           cigsd=3.925e-020
+ nigc=1                    poxedge=1                 pigcd=2.171
+ ntox=1                    xrcrg1=12                 xrcrg2=1
+ cgso=cgop_33              cgdo=cgop_33              cgbo=0
+ cgdl=cglp_33              cgsl=cglp_33              clc=1e-007
+ cle=0.6                   cf=cfp_33                 ckappas=0.6
+ ckappad=0.6               acde=0.4                  moin=5.02
+ noff=1                    voffcv=-0.044             kt1=-0.184
+ kt1l=0                    kt2=-0.03                 ute=-1.01
+ ua1=1.17e-009             ub1=-2.47e-018            uc1=-1e-012
+ prt=0                     at=80000                  fnoimod=1
+ tnoimod=0                 noia=6.5e+041             noib=2.2e+020
+ noic=5e+009               em=30000000               ef=1.2
+ jss=3.6e-07               jsd=3.6e-07               jsws=1.6e-12
+ jswd=1.6e-12              jswgs=1.7e-12             jswgd=1.7e-12
+ njs=1                     njd=1                     ijthsfwd=0.01
+ ijthdfwd=0.01             ijthsrev=0.01             ijthdrev=0.01
+ bvs=10                    bvd=10                    xjbvs=1
+ xjbvd=1                   pbs=0.7556                pbd=0.7556
+ cjs=cjp_33                cjd=cjp_33                mjs=0.3261
+ mjd=0.3261                pbsws=0.3954              pbswd=0.3954
+ cjsws=cjswp_33            cjswd=cjswp_33            mjsws=0.0496
+ mjswd=0.0496              pbswgs=0.85               pbswgd=0.85
+ cjswgs=cjswgp_33          cjswgd=cjswgp_33          mjswgs=0.518
+ mjswgd=0.518              tpb=0.0015                tcj=0.000866
+ tpbsw=0.0019              tcjsw=0.00032             tpbswg=0.0014
+ tcjswg=0.000945           xtis=3                    xtid=3
+ dmcg=1.125e-007           dmci=1.125e-007           dmdg=0
+ dmcgt=0                   dwj=0                     xgw=0
+ xgl=0                     rshg=1                    gbmin=1e-012
+ rbpb=50                   rbpd=50                   rbps=50
+ rbdb=50                   rbsb=50                   ngcon=1
+ saref=8.2e-007            sbref=8.2e-007            wlod=3e-007
+ kvth0=2e-009              lkvth0=-1e-007            wkvth0=1e-007
+ pkvth0=0                  llodvth=1                 wlodvth=1
+ stk2=0                    lodk2=1                   lodeta0=1
+ ku0=1.4e-007              lku0=-9e-008              wku0=5.5e-007
+ pku0=-1e-013              llodku0=1                 wlodku0=1
+ kvsat=-0.2                steta0=0                  tku0=0.3
+ lvth0=0+dlvthp_33         wvth0=0+dwvthp_33         lu0=0+dlu0p_33
+ minr=1e-3

     2: type=p
+ lmin=1.2e-006-dxlp_33     lmax=1e-005-dxlp_33       wmin=1e-005-dxwp_33
+ wmax=0.0009001            version=4.5               binunit=2
+ paramchk=1                mobmod=0                  capmod=2
+ igcmod=0                  igbmod=0                  geomod=0
+ diomod=1                  rdsmod=0                  rbodymod=0
+ rgatemod=0                permod=1                  acnqsmod=0
+ trnqsmod=0                tempmod=0                 wpemod=wpeflag_33
+ tnom=25                   toxe=toxp_33              toxm=toxp_33
+ dtox=4.31e-010            epsrox=3.9                wint=3.99e-008
+ lint=6.95e-008            ll=0                      wl=0
+ lln=1                     wln=1                     lw=0
+ ww=0                      lwn=1                     wwn=1
+ lwl=0                     wwl=0                     llc=0
+ wlc=0                     lwc=0                     wwc=0
+ lwlc=0                    wwlc=0                    xl=-1.5e-08+dxlp_33
+ xw=0+dxwp_33              dlc=4.963e-8              dwc=0
+ xpart=1                   toxref=3e-009             dlcig=6.95e-008
+ vth0=-0.68884+dvthp_33    k1=0.7905                 k2=-0.032206456+dk2p_33
+ lk2=-1.0767049e-008       wk2=1.0030773e-014        pk2=-5.6848079e-029
+ k3=-1.5                   k3b=1.2                   w0=0
+ dvt0=0.9                  dvt1=0.14                 dvt2=-0.012
+ dvt0w=0                   dvt1w=0                   dvt2w=0
+ dsub=0.2                  minv=-0.3                 voffl=0
+ dvtp0=0                   dvtp1=0                   lpe0=1.5e-008
+ lpeb=0                    web=0                     wec=0
+ scref=1e-006              kvth0we=-0.016            lkvth0we=0
+ wkvth0we=0                pkvth0we=0                k2we=0
+ lk2we=0                   wk2we=0                   pk2we=0
+ xj=1.8e-007               ngate=8.8e+019            ndep=8.4e+017
+ nsd=1e+020                phin=0                    cdsc=0
+ cdscb=0                   cdscd=0                   cit=0.00029743528
+ lcit=-7.3207738e-011      voff=-0.077384877         lvoff=-8.0256995e-009
+ nfactor=0.84097682        lnfactor=-1.4746175e-007  wnfactor=-1.0030773e-013
+ pnfactor=1.1561055e-027   eta0=0.025                etab=-0.023
+ ud=0                      lud=0                     wud=0
+ pud=0                     ku0we=-0.006              lku0we=0
+ wku0we=0                  pku0we=0                  u0=121.70731+du0p_33
+ lu0=3.0615868e-007+dlu0p_33                         ua=1.0830547e-009
+ lua=-2.4751573e-016       wua=-3.5768826e-023       pua=3.5217986e-028
+ ub=9.9745804e-019         lub=2.0367394e-025        uc=-2.0069773e-011
+ luc=1.0532981e-017        wuc=-1.6692119e-024       puc=1.643506e-029
+ vsat=70000                a0=1.2990982              la0=-2.0548795e-007
+ ags=0.19959974            lags=1.4381124e-007       wags=-1.1922942e-014
+ pags=1.1739329e-019       a1=0                      a2=0.99
+ b0=0                      b1=0                      keta=-0.0270775
+ lketa=-3.8620935e-008     wketa=-1.1922942e-015     pketa=1.1739329e-020
+ dwg=0                     dwb=0                     pclm=0.29072864
+ lpclm=9.1285846e-008      pdiblc1=0                 pdiblc2=0.00020720659
+ lpdiblc2=2.5396191e-010   pdiblcb=0                 drout=0
+ pvag=0                    delta=0.007               pscbe1=8.564e+008
+ pscbe2=1e-020             fprout=0                  pdits=0
+ pditsd=0                  pditsl=0                  rsh=9.68
+ rdsw=1005+drdswp_33       prwg=0                    prwb=0
+ wr=1                      alpha0=0                  alpha1=0.09
+ beta0=17                  agidl=2.76e-012           bgidl=8.66e+008
+ cgidl=0.25                egidl=0.2624              aigbacc=0.01213
+ bigbacc=0.006537          cigbacc=0.2809            nigbacc=4.05
+ aigbinv=0.35              bigbinv=0.03              cigbinv=0.006
+ eigbinv=1.1               nigbinv=1                 aigc=0.01
+ bigc=0.00144              cigc=1.515e-005           aigsd=0.008379
+ bigsd=0.0002699           cigsd=3.925e-020          nigc=1
+ poxedge=1                 pigcd=2.171               ntox=1
+ xrcrg1=12                 xrcrg2=1                  cgso=cgop_33
+ cgdo=cgop_33              cgbo=0                    cgdl=cglp_33
+ cgsl=cglp_33              clc=1e-007                cle=0.6
+ cf=cfp_33                 ckappas=0.6               ckappad=0.6
+ acde=0.4                  moin=5.02                 noff=1
+ voffcv=-0.044             kt1=-0.18503411           lkt1=1.0181883e-008
+ kt1l=0                    kt2=-0.03                 ute=-1.0088114
+ lute=-1.1703314e-008      ua1=1.1842636e-009        lua1=-1.4043976e-016
+ ub1=-2.47e-018            uc1=-1e-012               prt=0
+ at=85943.182              lat=-0.058516568          fnoimod=1
+ tnoimod=0                 noia=6.5e+041             noib=2.2e+020
+ noic=5e+009               em=30000000               ef=1.2
+ jss=3.6e-07               jsd=3.6e-07               jsws=1.6e-12
+ jswd=1.6e-12              jswgs=1.7e-12             jswgd=1.7e-12
+ njs=1                     njd=1                     ijthsfwd=0.01
+ ijthdfwd=0.01             ijthsrev=0.01             ijthdrev=0.01
+ bvs=10                    bvd=10                    xjbvs=1
+ xjbvd=1                   pbs=0.7556                pbd=0.7556
+ cjs=cjp_33                cjd=cjp_33                mjs=0.3261
+ mjd=0.3261                pbsws=0.3954              pbswd=0.3954
+ cjsws=cjswp_33            cjswd=cjswp_33            mjsws=0.0496
+ mjswd=0.0496              pbswgs=0.85               pbswgd=0.85
+ cjswgs=cjswgp_33          cjswgd=cjswgp_33          mjswgs=0.518
+ mjswgd=0.518              tpb=0.0015                tcj=0.000866
+ tpbsw=0.0019              tcjsw=0.00032             tpbswg=0.0014
+ tcjswg=0.000945           xtis=3                    xtid=3
+ dmcg=1.125e-007           dmci=1.125e-007           dmdg=0
+ dmcgt=0                   dwj=0                     xgw=0
+ xgl=0                     rshg=1                    gbmin=1e-012
+ rbpb=50                   rbpd=50                   rbps=50
+ rbdb=50                   rbsb=50                   ngcon=1
+ saref=8.2e-007            sbref=8.2e-007            wlod=3e-007
+ kvth0=2e-009              lkvth0=-1e-007            wkvth0=1e-007
+ pkvth0=0                  llodvth=1                 wlodvth=1
+ stk2=0                    lodk2=1                   lodeta0=1
+ ku0=1.4e-007              lku0=-9e-008              wku0=5.5e-007
+ pku0=-1e-013              llodku0=1                 wlodku0=1
+ kvsat=-0.2                steta0=0                  tku0=0.3
+ lvth0=0+dlvthp_33         wvth0=0+dwvthp_33         minr=1e-3

     3: type=p
+ lmin=7e-007-dxlp_33       lmax=1.2e-006-dxlp_33     wmin=1e-005-dxwp_33
+ wmax=0.0009001            version=4.5               binunit=2
+ paramchk=1                mobmod=0                  capmod=2
+ igcmod=0                  igbmod=0                  geomod=0
+ diomod=1                  rdsmod=0                  rbodymod=0
+ rgatemod=0                permod=1                  acnqsmod=0
+ trnqsmod=0                tempmod=0                 wpemod=wpeflag_33
+ tnom=25                   toxe=toxp_33              toxm=toxp_33
+ dtox=4.31e-010            epsrox=3.9                wint=3.99e-008
+ lint=6.95e-008            ll=0                      wl=0
+ lln=1                     wln=1                     lw=0
+ ww=0                      lwn=1                     wwn=1
+ lwl=0                     wwl=0                     llc=0
+ wlc=0                     lwc=0                     wwc=0
+ lwlc=0                    wwlc=0                    xl=-1.5e-08+dxlp_33
+ xw=0+dxwp_33              dlc=4.963e-8              dwc=0
+ xpart=1                   toxref=3e-009             dlcig=6.95e-008
+ vth0=-0.68975728+dvthp_33 lvth0=9.5947488e-010+dlvthp_33
+ k1=0.7905                 k2=-0.049052002+dk2p_33   lk2=6.8533932e-009
+ wk2=2.0984378e-014        pk2=-1.145747e-020        k3=-1.5
+ k3b=1.2                   w0=0                      dvt0=0.9
+ dvt1=0.14                 dvt2=-0.012               dvt0w=0
+ dvt1w=0                   dvt2w=0                   dsub=0.2
+ minv=-0.3                 voffl=0                   dvtp0=0
+ dvtp1=0                   lpe0=1.5e-008             lpeb=0
+ web=0                     wec=0                     scref=1e-006
+ kvth0we=-0.016            lkvth0we=0                wkvth0we=0
+ pkvth0we=0                k2we=0                    lk2we=0
+ wk2we=0                   pk2we=0                   xj=1.8e-007
+ ngate=8.8e+019            ndep=8.4e+017             nsd=1e+020
+ phin=0                    cdsc=0                    cdscb=0
+ cdscd=0                   cit=0.00014821912         lcit=8.2872358e-011
+ voff=-0.085666562         lvoff=6.3694283e-010      nfactor=0.7
+ lnfactor=-1.2731657e-016  wnfactor=-2.0984378e-013  pnfactor=1.145747e-019
+ eta0=0.025                etab=-0.023               ud=0
+ lud=0                     wud=0                     pud=0
+ ku0we=-0.006              lku0we=0                  wku0we=0
+ pku0we=0                  u0=120.908+du0p_33        lu0=1.142232e-006+dlu0p_33
+ ua=6.6566959e-010         lua=1.8906911e-016        wua=6.2953133e-022
+ pua=-3.437241e-028        ub=1.429579e-018          lub=-2.4832458e-025
+ wub=-3.2860814e-031       pub=3.437241e-037         uc=-3.7300002e-011
+ luc=2.8555801e-017        wuc=2.9378129e-023        puc=-1.6040459e-029
+ vsat=70000                a0=1.2147376              la0=-1.1724672e-007
+ ags=0.21378514            lags=1.2897332e-007       wags=3.1937983e-013
+ pags=-2.2914941e-019      a1=0                      a2=0.99
+ b0=0                      b1=0                      keta=-0.057448
+ lketa=-6.853392e-009      wketa=2.0984377e-014      pketa=-1.145747e-020
+ dwg=0                     dwb=0                     pclm=0.375816
+ lpclm=2.284464e-009       pdiblc1=0                 pdiblc2=0.00041724
+ lpdiblc2=3.426696e-011    pdiblcb=0                 drout=0
+ pvag=0                    delta=0.007               pscbe1=8.564e+008
+ pscbe2=1e-020             fprout=0                  pdits=0
+ pditsd=0                  pditsl=0                  rsh=9.68
+ rdsw=1005+drdswp_33       prwg=0                    prwb=0
+ wr=1                      alpha0=0                  alpha1=0.09
+ beta0=17                  agidl=2.76e-012           bgidl=8.66e+008
+ cgidl=0.25                egidl=0.2624              aigbacc=0.01213
+ bigbacc=0.006537          cigbacc=0.2809            nigbacc=4.05
+ aigbinv=0.35              bigbinv=0.03              cigbinv=0.006
+ eigbinv=1.1               nigbinv=1                 aigc=0.01
+ bigc=0.00144              cigc=1.515e-005           aigsd=0.008379
+ bigsd=0.0002699           cigsd=3.925e-020          nigc=1
+ poxedge=1                 pigcd=2.171               ntox=1
+ xrcrg1=12                 xrcrg2=1                  cgso=cgop_33
+ cgdo=cgop_33              cgbo=0                    cgdl=cglp_33
+ cgsl=cglp_33              clc=1e-007                cle=0.6
+ cf=cfp_33                 ckappas=0.6               ckappad=0.6
+ acde=0.4                  moin=5.02                 noff=1
+ voffcv=-0.044             kt1=-0.1745356            lkt1=-7.995624e-010
+ kt1l=0                    kt2=-0.03                 ute=-0.98724
+ lute=-3.426696e-008       ua1=1.0371199e-009        lua1=1.3472626e-017
+ ub1=-2.1700385e-018       lub1=-3.1375971e-025      uc1=-1e-012
+ prt=0                     at=40920                  lat=-0.01142232
+ fnoimod=1                 tnoimod=0                 noia=6.5e+041
+ noib=2.2e+020             noic=5e+009               em=30000000
+ ef=1.2                    jss=3.6e-07               jsd=3.6e-07
+ jsws=1.6e-12              jswd=1.6e-12              jswgs=1.7e-12
+ jswgd=1.7e-12             njs=1                     njd=1
+ ijthsfwd=0.01             ijthdfwd=0.01             ijthsrev=0.01
+ ijthdrev=0.01             bvs=10                    bvd=10
+ xjbvs=1                   xjbvd=1                   pbs=0.7556
+ pbd=0.7556                cjs=cjp_33                cjd=cjp_33
+ mjs=0.3261                mjd=0.3261                pbsws=0.3954
+ pbswd=0.3954              cjsws=cjswp_33            cjswd=cjswp_33
+ mjsws=0.0496              mjswd=0.0496              pbswgs=0.85
+ pbswgd=0.85               cjswgs=cjswgp_33          cjswgd=cjswgp_33
+ mjswgs=0.518              mjswgd=0.518              tpb=0.0015
+ tcj=0.000866              tpbsw=0.0019              tcjsw=0.00032
+ tpbswg=0.0014             tcjswg=0.000945           xtis=3
+ xtid=3                    dmcg=1.125e-007           dmci=1.125e-007
+ dmdg=0                    dmcgt=0                   dwj=0
+ xgw=0                     xgl=0                     rshg=1
+ gbmin=1e-012              rbpb=50                   rbpd=50
+ rbps=50                   rbdb=50                   rbsb=50
+ ngcon=1                   saref=8.2e-007            sbref=8.2e-007
+ wlod=3e-007               kvth0=2e-009              lkvth0=-1e-007
+ wkvth0=1e-007             pkvth0=0                  llodvth=1
+ wlodvth=1                 stk2=0                    lodk2=1
+ lodeta0=1                 ku0=1.4e-007              lku0=-9e-008
+ wku0=5.5e-007             pku0=-1e-013              llodku0=1
+ wlodku0=1                 kvsat=-0.2                steta0=0
+ tku0=0.3                  wvth0=0+dwvthp_33         minr=1e-3

     4: type=p
+ lmin=3.8e-07              lmax=7e-007-dxlp_33       wmin=1e-005-dxwp_33
+ wmax=0.0009001            version=4.5               binunit=2
+ paramchk=1                mobmod=0                  capmod=2
+ igcmod=0                  igbmod=0                  geomod=0
+ diomod=1                  rdsmod=0                  rbodymod=0
+ rgatemod=0                permod=1                  acnqsmod=0
+ trnqsmod=0                tempmod=0                 wpemod=wpeflag_33
+ tnom=25                   toxe=toxp_33              toxm=toxp_33
+ dtox=4.31e-010            epsrox=3.9                wint=3.99e-008
+ lint=6.95e-008            ll=0                      wl=0
+ lln=1                     wln=1                     lw=0
+ ww=0                      lwn=1                     wwn=1
+ lwl=0                     wwl=0                     llc=0
+ wlc=0                     lwc=0                     wwc=0
+ lwlc=0                    wwlc=0                    xl=-1.5e-08+dxlp_33
+ xw=0+dxwp_33              dlc=4.963e-8              dwc=0
+ xpart=1                   toxref=3e-009             dlcig=6.95e-008
+ vth0=-0.6498625+dvthp_33  lvth0=-2.0823075e-008+dlvthp_33
+ k1=0.7905                 k2=-0.034028125+dk2p_33   lk2=-1.3496438e-009
+ k3=-1.5                   k3b=1.2                   w0=0
+ dvt0=0.9                  dvt1=0.14                 dvt2=-0.012
+ dvt0w=0                   dvt1w=0                   dvt2w=0
+ dsub=0.2                  minv=-0.3                 voffl=0
+ dvtp0=0                   dvtp1=0                   lpe0=1.5e-008
+ lpeb=0                    web=0                     wec=0
+ scref=1e-006              kvth0we=-0.016            lkvth0we=0
+ wkvth0we=0                pkvth0we=0                k2we=0
+ lk2we=0                   wk2we=0                   pk2we=0
+ xj=1.8e-007               ngate=8.8e+019            ndep=8.4e+017
+ nsd=1e+020                phin=0                    cdsc=0
+ cdscb=0                   cdscd=0                   cit=0.0003
+ voff=-0.090981256         lvoff=3.5387659e-009      nfactor=0.7
+ eta0=0.026765625          leta0=-9.6403125e-010     etab=-0.023
+ ud=0                      lud=0                     wud=0
+ pud=0                     ku0we=-0.006              lku0we=0
+ wku0we=0                  pku0we=0                  u0=122.29375+du0p_33
+ lu0=3.856125e-007+dlu0p_33                          ua=4.9719969e-010
+ lua=2.8105367e-016        ub=1.5819861e-018         lub=-3.3153886e-025
+ wub=5.1345021e-031        pub=-1.1603975e-037       uc=4.46625e-011
+ luc=-1.6195725e-017       vsat=69293.75             lvsat=0.0003856125
+ a0=1.2778387              la0=-1.5169995e-007       ags=0.13331752
+ lags=1.7290864e-007       wags=-1.7115007e-013      pags=3.8679917e-020
+ a1=0                      a2=0.99                   b0=0
+ b1=0                      keta=-0.08906875          lketa=1.0411538e-008
+ dwg=0                     dwb=0                     pclm=0.394125
+ lpclm=-7.71225e-009       pdiblc1=0                 pdiblc2=0.00048
+ pdiblcb=0                 drout=0                   pvag=0
+ delta=0.007               pscbe1=8.564e+008         pscbe2=1e-020
+ fprout=0                  pdits=0                   pditsd=0
+ pditsl=0                  rsh=9.68                  rdsw=1005+drdswp_33
+ prwg=0                    prwb=0                    wr=1
+ alpha0=0                  alpha1=0.09               beta0=17
+ agidl=2.76e-012           bgidl=8.66e+008           cgidl=0.25
+ egidl=0.2624              aigbacc=0.01213           bigbacc=0.006537
+ cigbacc=0.2809            nigbacc=4.05              aigbinv=0.35
+ bigbinv=0.03              cigbinv=0.006             eigbinv=1.1
+ nigbinv=1                 aigc=0.01                 bigc=0.00144
+ cigc=1.515e-005           aigsd=0.008379            bigsd=0.0002699
+ cigsd=3.925e-020          nigc=1                    poxedge=1
+ pigcd=2.171               ntox=1                    xrcrg1=12
+ xrcrg2=1                  cgso=cgop_33              cgdo=cgop_33
+ cgbo=0                    cgdl=cglp_33              cgsl=cglp_33
+ clc=1e-007                cle=0.6                   cf=cfp_33
+ ckappas=0.6               ckappad=0.6               acde=0.4
+ moin=5.02                 noff=1                    voffcv=-0.044
+ kt1=-0.08438525           lkt1=-5.0021653e-008      kt1l=0
+ kt2=-0.03                 ute=-0.9016875            lute=-8.0978625e-008
+ ua1=1.8109815e-009        lua1=-4.0905581e-016      ub1=-4.0786832e-018
+ lub1=7.2836031e-025       uc1=3.948225e-011         luc1=-2.2103308e-017
+ prt=0                     at=24874.538              lat=-0.0026614975
+ fnoimod=1                 tnoimod=0                 noia=6.5e+041
+ noib=2.2e+020             noic=5e+009               em=30000000
+ ef=1.2                    jss=3.6e-07               jsd=3.6e-07
+ jsws=1.6e-12              jswd=1.6e-12              jswgs=1.7e-12
+ jswgd=1.7e-12             njs=1                     njd=1
+ ijthsfwd=0.01             ijthdfwd=0.01             ijthsrev=0.01
+ ijthdrev=0.01             bvs=10                    bvd=10
+ xjbvs=1                   xjbvd=1                   pbs=0.7556
+ pbd=0.7556                cjs=cjp_33                cjd=cjp_33
+ mjs=0.3261                mjd=0.3261                pbsws=0.3954
+ pbswd=0.3954              cjsws=cjswp_33            cjswd=cjswp_33
+ mjsws=0.0496              mjswd=0.0496              pbswgs=0.85
+ pbswgd=0.85               cjswgs=cjswgp_33          cjswgd=cjswgp_33
+ mjswgs=0.518              mjswgd=0.518              tpb=0.0015
+ tcj=0.000866              tpbsw=0.0019              tcjsw=0.00032
+ tpbswg=0.0014             tcjswg=0.000945           xtis=3
+ xtid=3                    njtsswg=60                dmcg=1.125e-007
+ dmci=1.125e-007           dmdg=0                    dmcgt=0
+ dwj=0                     xgw=0                     xgl=0
+ rshg=1                    gbmin=1e-012              rbpb=50
+ rbpd=50                   rbps=50                   rbdb=50
+ rbsb=50                   ngcon=1                   saref=8.2e-007
+ sbref=8.2e-007            wlod=3e-007               kvth0=2e-009
+ lkvth0=-1e-007            wkvth0=1e-007             pkvth0=0
+ llodvth=1                 wlodvth=1                 stk2=0
+ lodk2=1                   lodeta0=1                 ku0=1.4e-007
+ lku0=-9e-008              wku0=5.5e-007             pku0=-1e-013
+ llodku0=1                 wlodku0=1                 kvsat=-0.2
+ steta0=0                  tku0=0.3                  wvth0=0+dwvthp_33
+ minr=1e-3

     5: type=p
+ lmin=1e-005-dxlp_33       lmax=0.0009001            wmin=1e-006-dxwp_33
+ wmax=1e-005-dxwp_33       version=4.5               binunit=2
+ paramchk=1                mobmod=0                  capmod=2
+ igcmod=0                  igbmod=0                  geomod=0
+ diomod=1                  rdsmod=0                  rbodymod=0
+ rgatemod=0                permod=1                  acnqsmod=0
+ trnqsmod=0                tempmod=0                 wpemod=wpeflag_33
+ tnom=25                   toxe=toxp_33              toxm=toxp_33
+ dtox=4.31e-010            epsrox=3.9                wint=3.99e-008
+ lint=6.95e-008            ll=0                      wl=0
+ lln=1                     wln=1                     lw=0
+ ww=0                      lwn=1                     wwn=1
+ lwl=0                     wwl=0                     llc=0
+ wlc=0                     lwc=0                     wwc=0
+ lwlc=0                    wwlc=0                    xl=-1.5e-08+dxlp_33
+ xw=0+dxwp_33              dlc=4.963e-8              dwc=0
+ xpart=1                   toxref=3e-009             dlcig=6.95e-008
+ vth0=-0.68884+dvthp_33    k1=0.7905                 k2=-0.033310224+dk2p_33
+ wk2=1.0142853e-010        k3=-1.5                   k3b=1.2
+ w0=0                      dvt0=0.9                  dvt1=0.14
+ dvt2=-0.012               dvt0w=0                   dvt1w=0
+ dvt2w=0                   dsub=0.2                  minv=-0.3
+ voffl=0                   dvtp0=0                   dvtp1=0
+ lpe0=1.5e-008             lpeb=0                    web=0
+ wec=0                     scref=1e-006              kvth0we=-0.016
+ lkvth0we=0                wkvth0we=0                pkvth0we=0
+ k2we=0                    lk2we=0                   wk2we=0
+ pk2we=0                   xj=1.8e-007               ngate=8.8e+019
+ ndep=8.4e+017             nsd=1e+020                phin=0
+ cdsc=0                    cdscb=0                   cdscd=0
+ cit=0.00030431422         lcit=-1.0178356e-017      wcit=-1.4199996e-010
+ pcit=1.0097133e-022       voff=-0.079549627         lvoff=-1.0178358e-015
+ wvoff=1.3388565e-008      pvoff=1.0097133e-020      nfactor=0.8388828
+ lnfactor=-9.9549235e-014  wnfactor=-1.2779995e-007  pnfactor=1.9164298e-027
+ eta0=0.026533667          weta0=-1.521428e-008      etab=-0.023
+ ud=0                      lud=0                     wud=0
+ pud=0                     ku0we=-0.006              lku0we=0
+ wku0we=0                  pku0we=0                  u0=122.40199+du0p_33
+ wu0=-6.5829147e-006       ua=1.056605e-009          wua=1.3005167e-017
+ ub=1.0379241e-018         lub=-4.0713423e-032       wub=-1.9622206e-025
+ pub=4.0388532e-037        uc=-1.8386533e-011        wuc=-6.085712e-018
+ vsat=70000                a0=1.2790253              wa0=-7.9093971e-009
+ ags=0.21454307            wags=-3.345823e-009       a1=0
+ a2=0.99                   b0=0                      b1=0
+ keta=-0.0314601           wketa=4.564284e-009       dwg=0
+ dwb=0                     pclm=0.3                  pdiblc1=0
+ pdiblc2=0.00023259102     wpdiblc2=4.0571414e-012   pdiblcb=0
+ drout=0                   pvag=0                    delta=0.007
+ pscbe1=8.564e+008         pscbe2=1e-020             fprout=0
+ pdits=0                   pditsd=0                  pditsl=0
+ rsh=9.68                  rdsw=1005+drdswp_33       prwg=0
+ prwb=0                    wr=1                      alpha0=0
+ alpha1=0.09               beta0=17                  agidl=2.76e-012
+ bgidl=8.66e+008           cgidl=0.25                egidl=0.2624
+ aigbacc=0.01213           bigbacc=0.006537          cigbacc=0.2809
+ nigbacc=4.05              aigbinv=0.35              bigbinv=0.03
+ cigbinv=0.006             eigbinv=1.1               nigbinv=1
+ aigc=0.01                 bigc=0.00144              cigc=1.515e-005
+ aigsd=0.008379            bigsd=0.0002699           cigsd=3.925e-020
+ nigc=1                    poxedge=1                 pigcd=2.171
+ ntox=1                    xrcrg1=12                 xrcrg2=1
+ cgso=cgop_33              cgdo=cgop_33              cgbo=0
+ cgdl=cglp_33              cgsl=cglp_33              clc=1e-007
+ cle=0.6                   cf=cfp_33                 ckappas=0.6
+ ckappad=0.6               acde=0.4                  moin=5.02
+ noff=1                    voffcv=-0.044             kt1=-0.18359102
+ wkt1=-4.0571414e-009      kt1l=0                    kt2=-0.03
+ ute=-1.0100271            wute=2.6878561e-010       ua1=1.1832918e-009
+ wua1=-1.3185709e-016      ub1=-2.471973e-018        wub1=1.9572664e-026
+ uc1=-1e-012               prt=0                     at=80000
+ fnoimod=1                 tnoimod=0                 noia=6.5e+041
+ noib=2.2e+020             noic=5e+009               em=30000000
+ ef=1.2                    jss=3.6e-07               jsd=3.6e-07
+ jsws=1.6e-12              jswd=1.6e-12              jswgs=1.7e-12
+ jswgd=1.7e-12             njs=1                     njd=1
+ ijthsfwd=0.01             ijthdfwd=0.01             ijthsrev=0.01
+ ijthdrev=0.01             bvs=10                    bvd=10
+ xjbvs=1                   xjbvd=1                   pbs=0.7556
+ pbd=0.7556                cjs=cjp_33                cjd=cjp_33
+ mjs=0.3261                mjd=0.3261                pbsws=0.3954
+ pbswd=0.3954              cjsws=cjswp_33            cjswd=cjswp_33
+ mjsws=0.0496              mjswd=0.0496              pbswgs=0.85
+ pbswgd=0.85               cjswgs=cjswgp_33          cjswgd=cjswgp_33
+ mjswgs=0.518              mjswgd=0.518              tpb=0.0015
+ tcj=0.000866              tpbsw=0.0019              tcjsw=0.00032
+ tpbswg=0.0014             tcjswg=0.000945           xtis=3
+ xtid=3                    dmcg=1.125e-007           dmci=1.125e-007
+ dmdg=0                    dmcgt=0                   dwj=0
+ xgw=0                     xgl=0                     rshg=1
+ gbmin=1e-012              rbpb=50                   rbpd=50
+ rbps=50                   rbdb=50                   rbsb=50
+ ngcon=1                   saref=8.2e-007            sbref=8.2e-007
+ wlod=3e-007               kvth0=2e-009              lkvth0=-1e-007
+ wkvth0=1e-007             pkvth0=0                  llodvth=1
+ wlodvth=1                 stk2=0                    lodk2=1
+ lodeta0=1                 ku0=1.4e-007              lku0=-9e-008
+ wku0=5.5e-007             pku0=-1e-013              llodku0=1
+ wlodku0=1                 kvsat=-0.2                steta0=0
+ tku0=0.3                  lvth0=0+dlvthp_33         wvth0=0+dwvthp_33
+ lu0=0+dlu0p_33            minr=1e-3

     6: type=p
+ lmin=1.2e-006-dxlp_33     lmax=1e-005-dxlp_33       wmin=1e-006-dxwp_33
+ wmax=1e-005-dxwp_33       version=4.5               binunit=2
+ paramchk=1                mobmod=0                  capmod=2
+ igcmod=0                  igbmod=0                  geomod=0
+ diomod=1                  rdsmod=0                  rbodymod=0
+ rgatemod=0                permod=1                  acnqsmod=0
+ trnqsmod=0                tempmod=0                 wpemod=wpeflag_33
+ tnom=25                   toxe=toxp_33              toxm=toxp_33
+ dtox=4.31e-010            epsrox=3.9                wint=3.99e-008
+ lint=6.95e-008            ll=0                      wl=0
+ lln=1                     wln=1                     lw=0
+ ww=0                      lwn=1                     wwn=1
+ lwl=0                     wwl=0                     llc=0
+ wlc=0                     lwc=0                     wwc=0
+ lwlc=0                    wwlc=0                    xl=-1.5e-08+dxlp_33
+ xw=0+dxwp_33              dlc=4.963e-8              dwc=0
+ xpart=1                   toxref=3e-009             dlcig=6.95e-008
+ vth0=-0.68884+dvthp_33    k1=0.7905                 k2=-0.032169282+dk2p_33
+ lk2=-1.1233722e-008       wk2=-3.6876188e-010       pk2=4.6294948e-015
+ k3=-1.5                   k3b=1.2                   w0=0
+ dvt0=0.9                  dvt1=0.14                 dvt2=-0.012
+ dvt0w=0                   dvt1w=0                   dvt2w=0
+ dsub=0.2                  minv=-0.3                 voffl=0
+ dvtp0=0                   dvtp1=0                   lpe0=1.5e-008
+ lpeb=0                    web=0                     wec=0
+ scref=1e-006              kvth0we=-0.016            lkvth0we=0
+ wkvth0we=0                pkvth0we=0                k2we=0
+ lk2we=0                   wk2we=0                   pk2we=0
+ xj=1.8e-007               ngate=8.8e+019            ndep=8.4e+017
+ nsd=1e+020                phin=0                    cdsc=0
+ cdscb=0                   cdscd=0                   cit=0.00031372503
+ lcit=-9.2658811e-011      wcit=-1.6159761e-010      pcit=1.9295854e-016
+ voff=-0.078939799         lvoff=-6.0043605e-009     wvoff=1.5425138e-008
+ pvoff=-2.0052087e-014     nfactor=0.8553909         lnfactor=-1.625389e-007
+ wnfactor=-1.4299072e-007  pnfactor=1.4956829e-013   eta0=0.026533667
+ weta0=-1.521428e-008      etab=-0.023               ud=0
+ lud=0                     wud=0                     pud=0
+ ku0we=-0.006              lku0we=0                  wku0we=0
+ pku0we=0                  u0=122.389+du0p_33        lu0=1.2784153e-007+dlu0p_33
+ wu0=-6.7625757e-006       pu0=1.7689418e-012        ua=1.0845312e-009
+ lua=-2.7496089e-016       wua=-1.464685e-017        pua=2.7226175e-022
+ ub=1.0156393e-018         lub=2.1941557e-025        wub=-1.8036176e-025
+ pub=-1.5616011e-031       uc=-1.939554e-011         luc=9.9346834e-018
+ wuc=-6.6885202e-018       puc=5.9352492e-024        vsat=70000
+ a0=1.2993869              la0=-2.004803e-007        wa0=-2.8640128e-009
+ pa0=-4.9676853e-014       ags=0.20025183            lags=1.4071158e-007
+ wags=-6.4688519e-009      pags=3.0749342e-014       a1=0
+ a2=0.99                   b0=0                      b1=0
+ keta=-0.027561906         lketa=-3.8381614e-008     wketa=4.8054074e-009
+ pketa=-2.3741011e-015     dwg=0                     dwb=0
+ pclm=0.29233285           lpclm=7.5490742e-008      wpclm=-1.5914137e-008
+ ppclm=1.5669059e-013      pdiblc1=0                 pdiblc2=0.00020735666
+ lpdiblc2=2.4845755e-010   wpdiblc2=-1.4886943e-012  ppdiblc2=5.4604297e-017
+ pdiblcb=0                 drout=0                   pvag=0
+ delta=0.007               pscbe1=8.564e+008         pscbe2=1e-020
+ fprout=0                  pdits=0                   pditsd=0
+ pditsl=0                  rsh=9.68                  rdsw=1005+drdswp_33
+ prwg=0                    prwb=0                    wr=1
+ alpha0=0                  alpha1=0.09               beta0=17
+ agidl=2.76e-012           bgidl=8.66e+008           cgidl=0.25
+ egidl=0.2624              aigbacc=0.01213           bigbacc=0.006537
+ cigbacc=0.2809            nigbacc=4.05              aigbinv=0.35
+ bigbinv=0.03              cigbinv=0.006             eigbinv=1.1
+ nigbinv=1                 aigc=0.01                 bigc=0.00144
+ cigc=1.515e-005           aigsd=0.008379            bigsd=0.0002699
+ cigsd=3.925e-020          nigc=1                    poxedge=1
+ pigcd=2.171               ntox=1                    xrcrg1=12
+ xrcrg2=1                  cgso=cgop_33              cgdo=cgop_33
+ cgbo=0                    cgdl=cglp_33              cgsl=cglp_33
+ clc=1e-007                cle=0.6                   cf=cfp_33
+ ckappas=0.6               ckappad=0.6               acde=0.4
+ moin=5.02                 noff=1                    voffcv=-0.044
+ kt1=-0.18454857           lkt1=9.4280256e-009       wkt1=-4.8166797e-009
+ pkt1=7.4784146e-015       kt1l=0                    kt2=-0.03
+ ute=-1.0087201            lute=-1.2868203e-008      wute=-9.0488199e-010
+ pute=1.1555931e-014       ua1=1.1981631e-009        lua1=-1.4642276e-016
+ wua1=-1.3788518e-016      pua1=5.9352521e-023       ub1=-2.4722075e-018
+ lub1=2.3090767e-027       wub1=2.1899142e-026       pub1=-2.2906503e-032
+ uc1=-1e-012               prt=0                     at=85943.182
+ lat=-0.058516568          fnoimod=1                 tnoimod=0
+ noia=6.5e+041             noib=2.2e+020             noic=5e+009
+ em=30000000               ef=1.2                    jss=3.6e-07
+ jsd=3.6e-07               jsws=1.6e-12              jswd=1.6e-12
+ jswgs=1.7e-12             jswgd=1.7e-12             njs=1
+ njd=1                     ijthsfwd=0.01             ijthdfwd=0.01
+ ijthsrev=0.01             ijthdrev=0.01             bvs=10
+ bvd=10                    xjbvs=1                   xjbvd=1
+ pbs=0.7556                pbd=0.7556                cjs=cjp_33
+ cjd=cjp_33                mjs=0.3261                mjd=0.3261
+ pbsws=0.3954              pbswd=0.3954              cjsws=cjswp_33
+ cjswd=cjswp_33            mjsws=0.0496              mjswd=0.0496
+ pbswgs=0.85               pbswgd=0.85               cjswgs=cjswgp_33
+ cjswgd=cjswgp_33          mjswgs=0.518              mjswgd=0.518
+ tpb=0.0015                tcj=0.000866              tpbsw=0.0019
+ tcjsw=0.00032             tpbswg=0.0014             tcjswg=0.000945
+ xtis=3                    xtid=3                    dmcg=1.125e-007
+ dmci=1.125e-007           dmdg=0                    dmcgt=0
+ dwj=0                     xgw=0                     xgl=0
+ rshg=1                    gbmin=1e-012              rbpb=50
+ rbpd=50                   rbps=50                   rbdb=50
+ rbsb=50                   ngcon=1                   saref=8.2e-007
+ sbref=8.2e-007            wlod=3e-007               kvth0=2e-009
+ lkvth0=-1e-007            wkvth0=1e-007             pkvth0=0
+ llodvth=1                 wlodvth=1                 stk2=0
+ lodk2=1                   lodeta0=1                 ku0=1.4e-007
+ lku0=-9e-008              wku0=5.5e-007             pku0=-1e-013
+ llodku0=1                 wlodku0=1                 kvsat=-0.2
+ steta0=0                  tku0=0.3                  lvth0=0+dlvthp_33
+ wvth0=0+dwvthp_33         minr=1e-3

     7: type=p
+ lmin=7e-007-dxlp_33       lmax=1.2e-006-dxlp_33     wmin=1e-006-dxwp_33
+ wmax=1e-005-dxwp_33       version=4.5               binunit=2
+ paramchk=1                mobmod=0                  capmod=2
+ igcmod=0                  igbmod=0                  geomod=0
+ diomod=1                  rdsmod=0                  rbodymod=0
+ rgatemod=0                permod=1                  acnqsmod=0
+ trnqsmod=0                tempmod=0                 wpemod=wpeflag_33
+ tnom=25                   toxe=toxp_33              toxm=toxp_33
+ dtox=4.31e-010            epsrox=3.9                wint=3.99e-008
+ lint=6.95e-008            ll=0                      wl=0
+ lln=1                     wln=1                     lw=0
+ ww=0                      lwn=1                     wwn=1
+ lwl=0                     wwl=0                     llc=0
+ wlc=0                     lwc=0                     wwc=0
+ lwlc=0                    wwlc=0                    xl=-1.5e-08+dxlp_33
+ xw=0+dxwp_33              dlc=4.963e-8              dwc=0
+ xpart=1                   toxref=3e-009             dlcig=6.95e-008
+ vth0=-0.68921019+dvthp_33 lvth0=3.8721919e-010+dlvthp_33
+ wvth0=-5.427238e-009+dwvthp_33                      pvth0=5.6768909e-015
+ k1=0.7905                 k2=-0.050689138+dk2p_33   lk2=8.1380476e-009
+ wk2=1.6240737e-008        pk2=-1.2744041e-014       k3=-1.5
+ k3b=1.2                   w0=0                      dvt0=0.9
+ dvt1=0.14                 dvt2=-0.012               dvt0w=0
+ dvt1w=0                   dvt2w=0                   dsub=0.2
+ minv=-0.3                 voffl=0                   dvtp0=0
+ dvtp1=0                   lpe0=1.5e-008             lpeb=0
+ web=0                     wec=0                     scref=1e-006
+ kvth0we=-0.016            lkvth0we=0                wkvth0we=0
+ pkvth0we=0                k2we=0                    lk2we=0
+ wk2we=0                   pk2we=0                   xj=1.8e-007
+ ngate=8.8e+019            ndep=8.4e+017             nsd=1e+020
+ phin=0                    cdsc=0                    cdscb=0
+ cdscd=0                   cit=0.00014227863         lcit=8.6674123e-011
+ wcit=5.8930888e-011       pcit=-3.7714263e-017      voff=-0.085044257
+ lvoff=3.8090279e-010      wvoff=-6.1733849e-009     pvoff=2.5399684e-015
+ nfactor=0.69999998        lnfactor=1.142232e-014    eta0=0.026533667
+ weta0=-1.521428e-008      etab=-0.023               ud=0
+ lud=0                     wud=0                     pud=0
+ ku0we=-0.006              lku0we=0                  wku0we=0
+ pku0we=0                  u0=121.75418+du0p_33      lu0=7.9187137e-007+dlu0p_33
+ wu0=-8.3942255e-006       pu0=3.4756475e-012        ua=6.5161164e-010
+ lua=1.7787294e-016        wua=1.3945825e-016        pua=1.1106781e-022
+ ub=1.4726387e-018         lub=-2.5860584e-025       wub=-4.2716151e-025
+ pub=1.0199242e-031        uc=-3.7979311e-011        luc=2.9373308e-017
+ wuc=6.7389112e-018        puc=-8.109844e-024        vsat=70000
+ a0=1.2421045              la0=-1.4056288e-007       wa0=-2.7148519e-007
+ pa0=2.313009e-013         ags=0.21646411            lags=1.2375354e-007
+ wags=-2.6575607e-008      pags=5.1781008e-014       a1=0
+ a2=0.99                   b0=0                      b1=0
+ keta=-0.058987594         lketa=-5.5103443e-009     wketa=1.5273105e-008
+ pketa=-1.3323313e-014     dwg=0                     dwb=0
+ pclm=0.36712072           lpclm=-2.7373717e-009     wpclm=8.6258882e-008
+ ppclm=4.9817614e-014      pdiblc1=0                 pdiblc2=0.00041491905
+ lpdiblc2=3.1347288e-011   wpdiblc2=2.3024277e-011   ppdiblc2=2.8963729e-017
+ pdiblcb=0                 drout=0                   pvag=0
+ delta=0.007               pscbe1=8.564e+008         pscbe2=1e-020
+ fprout=0                  pdits=0                   pditsd=0
+ pditsl=0                  rsh=9.68                  rdsw=1005+drdswp_33
+ prwg=0                    prwb=0                    wr=1
+ alpha0=0                  alpha1=0.09               beta0=17
+ agidl=2.76e-012           bgidl=8.66e+008           cgidl=0.25
+ egidl=0.2624              aigbacc=0.01213           bigbacc=0.006537
+ cigbacc=0.2809            nigbacc=4.05              aigbinv=0.35
+ bigbinv=0.03              cigbinv=0.006             eigbinv=1.1
+ nigbinv=1                 aigc=0.01                 bigc=0.00144
+ cigc=1.515e-005           aigsd=0.008379            bigsd=0.0002699
+ cigsd=3.925e-020          nigc=1                    poxedge=1
+ pigcd=2.171               ntox=1                    xrcrg1=12
+ xrcrg2=1                  cgso=cgop_33              cgdo=cgop_33
+ cgbo=0                    cgdl=cglp_33              cgsl=cglp_33
+ clc=1e-007                cle=0.6                   cf=cfp_33
+ ckappas=0.6               ckappad=0.6               acde=0.4
+ moin=5.02                 noff=1                    voffcv=-0.044
+ kt1=-0.1740227            lkt1=-1.5820345e-009      wkt1=-5.088061e-009
+ pkt1=7.7622794e-015       kt1l=0                    kt2=-0.03
+ ute=-0.98379641           lute=-3.8938435e-008      wute=-3.416113e-008
+ pute=4.6341967e-014       ua1=1.0361669e-009        lua1=2.3025215e-017
+ wua1=9.453357e-018        pua1=-9.4763587e-023      ub1=-2.1700385e-018
+ lub1=-3.1375971e-025      uc1=-1e-012               prt=0
+ at=40920                  lat=-0.01142232           fnoimod=1
+ tnoimod=0                 noia=6.5e+041             noib=2.2e+020
+ noic=5e+009               em=30000000               ef=1.2
+ jss=3.6e-07               jsd=3.6e-07               jsws=1.6e-12
+ jswd=1.6e-12              jswgs=1.7e-12             jswgd=1.7e-12
+ njs=1                     njd=1                     ijthsfwd=0.01
+ ijthdfwd=0.01             ijthsrev=0.01             ijthdrev=0.01
+ bvs=10                    bvd=10                    xjbvs=1
+ xjbvd=1                   pbs=0.7556                pbd=0.7556
+ cjs=cjp_33                cjd=cjp_33                mjs=0.3261
+ mjd=0.3261                pbsws=0.3954              pbswd=0.3954
+ cjsws=cjswp_33            cjswd=cjswp_33            mjsws=0.0496
+ mjswd=0.0496              pbswgs=0.85               pbswgd=0.85
+ cjswgs=cjswgp_33          cjswgd=cjswgp_33          mjswgs=0.518
+ mjswgd=0.518              tpb=0.0015                tcj=0.000866
+ tpbsw=0.0019              tcjsw=0.00032             tpbswg=0.0014
+ tcjswg=0.000945           xtis=3                    xtid=3
+ dmcg=1.125e-007           dmci=1.125e-007           dmdg=0
+ dmcgt=0                   dwj=0                     xgw=0
+ xgl=0                     rshg=1                    gbmin=1e-012
+ rbpb=50                   rbpd=50                   rbps=50
+ rbdb=50                   rbsb=50                   ngcon=1
+ saref=8.2e-007            sbref=8.2e-007            wlod=3e-007
+ kvth0=2e-009              lkvth0=-1e-007            wkvth0=1e-007
+ pkvth0=0                  llodvth=1                 wlodvth=1
+ stk2=0                    lodk2=1                   lodeta0=1
+ ku0=1.4e-007              lku0=-9e-008              wku0=5.5e-007
+ pku0=-1e-013              llodku0=1                 wlodku0=1
+ kvsat=-0.2                steta0=0                  tku0=0.3
+ minr=1e-3

     8: type=p
+ lmin=3.8e-07              lmax=7e-007-dxlp_33       wmin=1e-006-dxwp_33
+ wmax=1e-005-dxwp_33       version=4.5               binunit=2
+ paramchk=1                mobmod=0                  capmod=2
+ igcmod=0                  igbmod=0                  geomod=0
+ diomod=1                  rdsmod=0                  rbodymod=0
+ rgatemod=0                permod=1                  acnqsmod=0
+ trnqsmod=0                tempmod=0                 wpemod=wpeflag_33
+ tnom=25                   toxe=toxp_33              toxm=toxp_33
+ dtox=4.31e-010            epsrox=3.9                wint=3.99e-008
+ lint=6.95e-008            ll=0                      wl=0
+ lln=1                     wln=1                     lw=0
+ ww=0                      lwn=1                     wwn=1
+ lwl=0                     wwl=0                     llc=0
+ wlc=0                     lwc=0                     wwc=0
+ lwlc=0                    wwlc=0                    xl=-1.5e-08+dxlp_33
+ xw=0+dxwp_33              dlc=4.963e-8              dwc=0
+ xpart=1                   toxref=3e-009             dlcig=6.95e-008
+ vth0=-0.64985081+dvthp_33 lvth0=-2.1103005e-008+dlvthp_33
+ wvth0=-1.1600889e-010+dwvthp_33                     pvth0=2.7769598e-015
+ k1=0.7905                 k2=-0.032157052+dk2p_33   lk2=-1.9804715e-009
+ wk2=-1.8561422e-008       pk2=6.2579377e-015        k3=-1.5
+ k3b=1.2                   w0=0                      dvt0=0.9
+ dvt1=0.14                 dvt2=-0.012               dvt0w=0
+ dvt1w=0                   dvt2w=0                   dsub=0.2
+ minv=-0.3                 voffl=0                   dvtp0=0
+ dvtp1=0                   lpe0=1.5e-008             lpeb=0
+ web=0                     wec=0                     scref=1e-006
+ kvth0we=-0.016            lkvth0we=0                wkvth0we=0
+ pkvth0we=0                k2we=0                    lk2we=0
+ wk2we=0                   pk2we=0                   xj=1.8e-007
+ ngate=8.8e+019            ndep=8.4e+017             nsd=1e+020
+ phin=0                    cdsc=0                    cdscb=0
+ cdscd=0                   cit=0.00030318875         lcit=-1.1828021e-012
+ wcit=-3.1633024e-011      pcit=1.1733633e-017       voff=-0.088930857
+ lvoff=2.5029861e-009      wvoff=-2.034037e-008      pvoff=1.0275143e-014
+ nfactor=0.7               eta0=0.028479817          leta0=-1.0625981e-009
+ weta0=-1.7005128e-008     peta0=9.7780276e-016      etab=-0.023
+ ud=0                      lud=0                     wud=0
+ pud=0                     ku0we=-0.006              lku0we=0
+ wku0we=0                  pku0we=0                  u0=122.49824+du0p_33
+ lu0=3.856125e-007+dlu0p_33                          wu0=-2.0285707e-006
+ pu0=-1.4130452e-026       ua=5.1326609e-010         lua=2.5340961e-016
+ wua=-1.5938195e-016       pua=2.7423456e-022        ub=1.552923e-018
+ lub=-3.0244103e-025       wub=2.8831255e-025        pub=-2.8865641e-031
+ uc=4.5913716e-011         luc=-1.6432285e-017       wuc=-1.2412317e-017
+ puc=2.3467267e-024        vsat=69221.54             lvsat=0.00042503924
+ wvsat=0.00071633902       pvsat=-3.911211e-010      a0=1.2598158
+ la0=-1.5023327e-007       wa0=1.7879066e-007        pa0=-1.4549717e-014
+ ags=0.15418681            lags=1.5775695e-007       wags=-2.0702768e-007
+ pags=1.5030784e-013       a1=0                      a2=0.99
+ b0=0                      b1=0                      keta=-0.088509601
+ lketa=1.0608671e-008      wketa=-5.5468712e-009     pketa=-1.9556059e-015
+ dwg=0                     dwb=0                     pclm=0.37783529
+ lpclm=-8.5875235e-009     wpclm=1.6159721e-007      ppclm=8.6828885e-015
+ pdiblc1=0                 pdiblc2=0.00044440801     lpdiblc2=1.5246319e-011
+ wpdiblc2=3.530797e-010    ppdiblc2=-1.5124653e-016  pdiblcb=0
+ drout=0                   pvag=0                    delta=0.007
+ pscbe1=8.564e+008         pscbe2=1e-020             fprout=0
+ pdits=0                   pditsd=0                  pditsl=0
+ rsh=9.68                  rdsw=1005+drdswp_33       prwg=0
+ prwb=0                    wr=1                      alpha0=0
+ alpha1=0.09               beta0=17                  agidl=2.76e-012
+ bgidl=8.66e+008           cgidl=0.25                egidl=0.2624
+ aigbacc=0.01213           bigbacc=0.006537          cigbacc=0.2809
+ nigbacc=4.05              aigbinv=0.35              bigbinv=0.03
+ cigbinv=0.006             eigbinv=1.1               nigbinv=1
+ aigc=0.01                 bigc=0.00144              cigc=1.515e-005
+ aigsd=0.008379            bigsd=0.0002699           cigsd=3.925e-020
+ nigc=1                    poxedge=1                 pigcd=2.171
+ ntox=1                    xrcrg1=12                 xrcrg2=1
+ cgso=cgop_33              cgdo=cgop_33              cgbo=0
+ cgdl=cglp_33              cgsl=cglp_33              clc=1e-007
+ cle=0.6                   cf=cfp_33                 ckappas=0.6
+ ckappad=0.6               acde=0.4                  moin=5.02
+ noff=1                    voffcv=-0.044             kt1=-0.079790762
+ lkt1=-5.3032673e-008      wkt1=-4.5578243e-008      pkt1=2.9869919e-014
+ kt1l=0                    kt2=-0.03                 ute=-0.89163559
+ lute=-8.925824e-008       wute=-9.9716927e-008      pute=8.2135432e-014
+ ua1=1.8391922e-009        lua1=-4.1542658e-016      wua1=-2.79856e-016
+ pua1=6.3199323e-023       ub1=-4.1172543e-018       lub1=7.4942011e-025
+ wub1=3.8263249e-025       pub1=-2.0891734e-031      uc1=3.948225e-011
+ luc1=-2.2103308e-017      prt=0                     at=25513.597
+ lat=-0.0030104241         wat=-0.0063396003         pat=3.4614218e-009
+ fnoimod=1                 tnoimod=0                 noia=6.5e+041
+ noib=2.2e+020             noic=5e+009               em=30000000
+ ef=1.2                    jss=3.6e-07               jsd=3.6e-07
+ jsws=1.6e-12              jswd=1.6e-12              jswgs=1.7e-12
+ jswgd=1.7e-12             njs=1                     njd=1
+ ijthsfwd=0.01             ijthdfwd=0.01             ijthsrev=0.01
+ ijthdrev=0.01             bvs=10                    bvd=10
+ xjbvs=1                   xjbvd=1                   pbs=0.7556
+ pbd=0.7556                cjs=cjp_33                cjd=cjp_33
+ mjs=0.3261                mjd=0.3261                pbsws=0.3954
+ pbswd=0.3954              cjsws=cjswp_33            cjswd=cjswp_33
+ mjsws=0.0496              mjswd=0.0496              pbswgs=0.85
+ pbswgd=0.85               cjswgs=cjswgp_33          cjswgd=cjswgp_33
+ mjswgs=0.518              mjswgd=0.518              tpb=0.0015
+ tcj=0.000866              tpbsw=0.0019              tcjsw=0.00032
+ tpbswg=0.0014             tcjswg=0.000945           xtis=3
+ xtid=3                    njtsswg=60                tnjtsswg=0
+ dmcg=1.125e-007           dmci=1.125e-007           dmdg=0
+ dmcgt=0                   dwj=0                     xgw=0
+ xgl=0                     rshg=1                    gbmin=1e-012
+ rbpb=50                   rbpd=50                   rbps=50
+ rbdb=50                   rbsb=50                   ngcon=1
+ saref=8.2e-007            sbref=8.2e-007            wlod=3e-007
+ kvth0=2e-009              lkvth0=-1e-007            wkvth0=1e-007
+ pkvth0=0                  llodvth=1                 wlodvth=1
+ stk2=0                    lodk2=1                   lodeta0=1
+ ku0=1.4e-007              lku0=-9e-008              wku0=5.5e-007
+ pku0=-1e-013              llodku0=1                 wlodku0=1
+ kvsat=-0.2                steta0=0                  tku0=0.3
+ minr=1e-3

     9: type=p
+ lmin=1e-005-dxlp_33       lmax=0.0009001            wmin=6e-007-dxwp_33
+ wmax=1e-006-dxwp_33       version=4.5               binunit=2
+ paramchk=1                mobmod=0                  capmod=2
+ igcmod=0                  igbmod=0                  geomod=0
+ diomod=1                  rdsmod=0                  rbodymod=0
+ rgatemod=0                permod=1                  acnqsmod=0
+ trnqsmod=0                tempmod=0                 wpemod=wpeflag_33
+ tnom=25                   toxe=toxp_33              toxm=toxp_33
+ dtox=4.31e-010            epsrox=3.9                wint=3.99e-008
+ lint=6.95e-008            ll=0                      wl=0
+ lln=1                     wln=1                     lw=0
+ ww=0                      lwn=1                     wwn=1
+ lwl=0                     wwl=0                     llc=0
+ wlc=0                     lwc=0                     wwc=0
+ lwlc=0                    wwlc=0                    xl=-1.5e-08+dxlp_33
+ xw=0+dxwp_33              dlc=4.963e-8              dwc=0
+ xpart=1                   toxref=3e-009             dlcig=6.95e-008
+ vth0=-0.68884+dvthp_33    k1=0.7905                 k2=-0.03515075+dk2p_33
+ wk2=1.7950802e-009        k3=-1.5                   k3b=1.2
+ w0=0                      dvt0=0.9                  dvt1=0.14
+ dvt2=-0.012               dvt0w=0                   dvt1w=0
+ dvt2w=0                   dsub=0.2                  minv=-0.3
+ voffl=0                   dvtp0=0                   dvtp1=0
+ lpe0=1.5e-008             lpeb=0                    web=0
+ wec=0                     scref=1e-006              kvth0we=-0.016
+ lkvth0we=0                wkvth0we=0                pkvth0we=0
+ k2we=0                    lk2we=0                   wk2we=0
+ pk2we=0                   xj=1.8e-007               ngate=8.8e+019
+ ndep=8.4e+017             nsd=1e+020                phin=0
+ cdsc=0                    cdscb=0                   cdscd=0
+ cit=0.00021502498         lcit=2.8079853e-016       wcit=-5.9835993e-011
+ pcit=-1.667856e-022       voff=-0.067601002         lvoff=2.2901302e-014
+ wvoff=2.3934414e-009      pvoff=-1.1913256e-020     nfactor=0.7
+ lnfactor=-2.2901303e-013  wnfactor=-1.3238964e-016  pnfactor=1.1913257e-019
+ eta0=0.01                 etab=-0.0321035           wetab=8.3770407e-009
+ ud=0                      lud=0                     wud=0
+ pud=0                     ku0we=-0.006              lku0we=0
+ wku0we=0                  pku0we=0                  u0=110.36898+du0p_33
+ wu0=4.4898545e-006        ua=1.2351749e-009         lua=3.8839135e-022
+ wua=-1.5131487e-016       pua=-3.5739772e-028       ub=8.909641e-019
+ lub=7.865883e-031         wub=-6.0989511e-026       pub=-3.5739772e-037
+ uc=-2.10985e-011          wuc=-3.5901603e-018       vsat=70000
+ a0=1.2554001              wa0=1.3830494e-008        ags=0.21249098
+ wags=-1.4574854e-009      a1=0                      a2=0.99
+ b0=0                      b1=0                      keta=-0.023899
+ wketa=-2.3934402e-009     dwg=0                     dwb=0
+ pclm=0.2934975            wpclm=5.9836005e-009      pdiblc1=0
+ pdiblc2=0.0002330985      wpdiblc2=3.5901603e-012   pdiblcb=0
+ drout=0                   pvag=0                    delta=0.007
+ pscbe1=8.564e+008         pscbe2=1e-020             fprout=0
+ pdits=0                   pditsd=0                  pditsl=0
+ rsh=9.68                  rdsw=1005+drdswp_33       prwg=0
+ prwb=0                    wr=1                      alpha0=0
+ alpha1=0.09               beta0=17                  agidl=2.76e-012
+ bgidl=8.66e+008           cgidl=0.25                egidl=0.2624
+ aigbacc=0.01213           bigbacc=0.006537          cigbacc=0.2809
+ nigbacc=4.05              aigbinv=0.35              bigbinv=0.03
+ cigbinv=0.006             eigbinv=1.1               nigbinv=1
+ aigc=0.01                 bigc=0.00144              cigc=1.515e-005
+ aigsd=0.008379            bigsd=0.0002699           cigsd=3.925e-020
+ nigc=1                    poxedge=1                 pigcd=2.171
+ ntox=1                    xrcrg1=12                 xrcrg2=1
+ cgso=cgop_33              cgdo=cgop_33              cgbo=0
+ cgdl=cglp_33              cgsl=cglp_33              clc=1e-007
+ cle=0.6                   cf=cfp_33                 ckappas=0.6
+ ckappad=0.6               acde=0.4                  moin=5.02
+ noff=1                    voffcv=-0.044             kt1=-0.1945025
+ wkt1=5.9836005e-009       kt1l=0                    kt2=-0.03
+ ute=-1.009735             ua1=1.01399e-009          wua1=2.3934402e-017
+ ub1=-2.450703e-018        uc1=-1e-012               prt=0
+ at=80000                  fnoimod=1                 tnoimod=0
+ noia=6.5e+041             noib=2.2e+020             noic=5e+009
+ em=30000000               ef=1.2                    jss=3.6e-07
+ jsd=3.6e-07               jsws=1.6e-12              jswd=1.6e-12
+ jswgs=1.7e-12             jswgd=1.7e-12             njs=1
+ njd=1                     ijthsfwd=0.01             ijthdfwd=0.01
+ ijthsrev=0.01             ijthdrev=0.01             bvs=10
+ bvd=10                    xjbvs=1                   xjbvd=1
+ pbs=0.7556                pbd=0.7556                cjs=cjp_33
+ cjd=cjp_33                mjs=0.3261                mjd=0.3261
+ pbsws=0.3954              pbswd=0.3954              cjsws=cjswp_33
+ cjswd=cjswp_33            mjsws=0.0496              mjswd=0.0496
+ pbswgs=0.85               pbswgd=0.85               cjswgs=cjswgp_33
+ cjswgd=cjswgp_33          mjswgs=0.518              mjswgd=0.518
+ tpb=0.0015                tcj=0.000866              tpbsw=0.0019
+ tcjsw=0.00032             tpbswg=0.0014             tcjswg=0.000945
+ xtis=3                    xtid=3                    dmcg=1.125e-007
+ dmci=1.125e-007           dmdg=0                    dmcgt=0
+ dwj=0                     xgw=0                     xgl=0
+ rshg=1                    gbmin=1e-012              rbpb=50
+ rbpd=50                   rbps=50                   rbdb=50
+ rbsb=50                   ngcon=1                   saref=8.2e-007
+ sbref=8.2e-007            wlod=3e-007               kvth0=2e-009
+ lkvth0=-1e-007            wkvth0=1e-007             pkvth0=0
+ llodvth=1                 wlodvth=1                 stk2=0
+ lodk2=1                   lodeta0=1                 ku0=1.4e-007
+ lku0=-9e-008              wku0=5.5e-007             pku0=-1e-013
+ llodku0=1                 wlodku0=1                 kvsat=-0.2
+ steta0=0                  tku0=0.3                  lvth0=0+dlvthp_33
+ wvth0=0+dwvthp_33         lu0=0+dlu0p_33            minr=1e-3

     10: type=p
+ lmin=1.2e-006-dxlp_33     lmax=1e-005-dxlp_33       wmin=6e-007-dxwp_33
+ wmax=1e-006-dxwp_33       version=4.5               binunit=2
+ paramchk=1                mobmod=0                  capmod=2
+ igcmod=0                  igbmod=0                  geomod=0
+ diomod=1                  rdsmod=0                  rbodymod=0
+ rgatemod=0                permod=1                  acnqsmod=0
+ trnqsmod=0                tempmod=0                 wpemod=wpeflag_33
+ tnom=25                   toxe=toxp_33              toxm=toxp_33
+ dtox=4.31e-010            epsrox=3.9                wint=3.99e-008
+ lint=6.95e-008            ll=0                      wl=0
+ lln=1                     wln=1                     lw=0
+ ww=0                      lwn=1                     wwn=1
+ lwl=0                     wwl=0                     llc=0
+ wlc=0                     lwc=0                     wwc=0
+ lwlc=0                    wwlc=0                    xl=-1.5e-08+dxlp_33
+ xw=0+dxwp_33              dlc=4.963e-8              dwc=0
+ xpart=1                   toxref=3e-009             dlcig=6.95e-008
+ vth0=-0.68884+dvthp_33    k1=0.7905                 k2=-0.034752646+dk2p_33
+ lk2=-3.9197323e-009       wk2=2.0084499e-009        pk2=-2.1008386e-015
+ k3=-1.5                   k3b=1.2                   w0=0
+ dvt0=0.9                  dvt1=0.14                 dvt2=-0.012
+ dvt0w=0                   dvt1w=0                   dvt2w=0
+ dsub=0.2                  minv=-0.3                 voffl=0
+ dvtp0=0                   dvtp1=0                   lpe0=1.5e-008
+ lpeb=0                    web=0                     wec=0
+ scref=1e-006              kvth0we=-0.016            lkvth0we=0
+ wkvth0we=0                pkvth0we=0                k2we=0
+ lk2we=0                   wk2we=0                   pk2we=0
+ xj=1.8e-007               ngate=8.8e+019            ndep=8.4e+017
+ nsd=1e+020                phin=0                    cdsc=0
+ cdscb=0                   cdscd=0                   cit=0.00021086775
+ lcit=4.0932375e-011       wcit=-6.6948333e-011      pcit=7.0027931e-017
+ voff=-0.0626834           lvoff=-4.8418686e-008     wvoff=4.6600009e-010
+ pvoff=1.8977575e-014      nfactor=0.69335294        lnfactor=6.5446685e-008
+ wnfactor=6.1166116e-009   pnfactor=-6.022404e-014   eta0=0.01
+ etab=-0.0321035           wetab=8.3770407e-009      ud=0
+ lud=0                     wud=0                     pud=0
+ ku0we=-0.006              lku0we=0                  wku0we=0
+ pku0we=0                  u0=110.04454+du0p_33      lu0=3.1944381e-006+dlu0p_33
+ wu0=4.5967954e-006        pu0=-1.0529403e-012       ua=1.2511467e-009
+ lua=-1.5725776e-016       wua=-1.6796647e-016       pua=1.6395134e-022
+ ub=8.6555612e-019         lub=2.5016776e-025        wub=-4.2255211e-026
+ pub=-1.8445828e-031       uc=-2.3690084e-011        luc=2.5516735e-017
+ wuc=-2.7366813e-018       puc=-8.4033544e-024       vsat=70000
+ a0=1.2586653              la0=-3.2148862e-008       wa0=3.4608013e-008
+ pa0=-2.0457545e-013       ags=0.19599859            lags=1.623841e-007
+ wags=-2.5550168e-009      pags=1.0806294e-014       a1=0
+ a2=0.99                   b0=0                      b1=0
+ keta=-0.019352317         lketa=-4.4766638e-008     wketa=-2.7490565e-009
+ pketa=3.5013977e-015      dwg=0                     dwb=0
+ pclm=0.26250743           lpclm=3.0512821e-007      wpclm=1.1531214e-008
+ ppclm=-5.4621804e-014     pdiblc1=0                 pdiblc2=0.00019673615
+ lpdiblc2=3.5802369e-010   wpdiblc2=8.2842963e-012   ppdiblc2=-4.6218463e-017
+ pdiblcb=0                 drout=0                   pvag=0
+ delta=0.007               pscbe1=8.564e+008         pscbe2=1e-020
+ fprout=0                  pdits=0                   pditsd=0
+ pditsl=0                  rsh=9.68                  rdsw=1005+drdswp_33
+ prwg=0                    prwb=0                    wr=1
+ alpha0=0                  alpha1=0.09               beta0=17
+ agidl=2.76e-012           bgidl=8.66e+008           cgidl=0.25
+ egidl=0.2624              aigbacc=0.01213           bigbacc=0.006537
+ cigbacc=0.2809            nigbacc=4.05              aigbinv=0.35
+ bigbinv=0.03              cigbinv=0.006             eigbinv=1.1
+ nigbinv=1                 aigc=0.01                 bigc=0.00144
+ cigc=1.515e-005           aigsd=0.008379            bigsd=0.0002699
+ cigsd=3.925e-020          nigc=1                    poxedge=1
+ pigcd=2.171               ntox=1                    xrcrg1=12
+ xrcrg2=1                  cgso=cgop_33              cgdo=cgop_33
+ cgbo=0                    cgdl=cglp_33              cgsl=cglp_33
+ clc=1e-007                cle=0.6                   cf=cfp_33
+ ckappas=0.6               ckappad=0.6               acde=0.4
+ moin=5.02                 noff=1                    voffcv=-0.044
+ kt1=-0.19798586           lkt1=3.4297146e-008       wkt1=7.548312e-009
+ pkt1=-1.540615e-014       kt1l=0                    kt2=-0.03
+ ute=-1.0081577            lute=-1.5530297e-008      wute=-1.422465e-009
+ pute=1.4005591e-014       ua1=1.0284937e-009        lua1=-1.4280378e-016
+ wua1=1.8244545e-017       pua1=5.6022335e-023       ub1=-2.4484093e-018
+ lub1=-2.2583884e-026      uc1=-1e-012               prt=0
+ at=85943.182              lat=-0.058516568          fnoimod=1
+ tnoimod=0                 noia=6.5e+041             noib=2.2e+020
+ noic=5e+009               em=30000000               ef=1.2
+ jss=3.6e-07               jsd=3.6e-07               jsws=1.6e-12
+ jswd=1.6e-12              jswgs=1.7e-12             jswgd=1.7e-12
+ njs=1                     njd=1                     ijthsfwd=0.01
+ ijthdfwd=0.01             ijthsrev=0.01             ijthdrev=0.01
+ bvs=10                    bvd=10                    xjbvs=1
+ xjbvd=1                   pbs=0.7556                pbd=0.7556
+ cjs=cjp_33                cjd=cjp_33                mjs=0.3261
+ mjd=0.3261                pbsws=0.3954              pbswd=0.3954
+ cjsws=cjswp_33            cjswd=cjswp_33            mjsws=0.0496
+ mjswd=0.0496              pbswgs=0.85               pbswgd=0.85
+ cjswgs=cjswgp_33          cjswgd=cjswgp_33          mjswgs=0.518
+ mjswgd=0.518              tpb=0.0015                tcj=0.000866
+ tpbsw=0.0019              tcjsw=0.00032             tpbswg=0.0014
+ tcjswg=0.000945           xtis=3                    xtid=3
+ dmcg=1.125e-007           dmci=1.125e-007           dmdg=0
+ dmcgt=0                   dwj=0                     xgw=0
+ xgl=0                     rshg=1                    gbmin=1e-012
+ rbpb=50                   rbpd=50                   rbps=50
+ rbdb=50                   rbsb=50                   ngcon=1
+ saref=8.2e-007            sbref=8.2e-007            wlod=3e-007
+ kvth0=2e-009              lkvth0=-1e-007            wkvth0=1e-007
+ pkvth0=0                  llodvth=1                 wlodvth=1
+ stk2=0                    lodk2=1                   lodeta0=1
+ ku0=1.4e-007              lku0=-9e-008              wku0=5.5e-007
+ pku0=-1e-013              llodku0=1                 wlodku0=1
+ kvsat=-0.2                steta0=0                  tku0=0.3
+ lvth0=0+dlvthp_33         wvth0=0+dwvthp_33         minr=1e-3

     11: type=p
+ lmin=7e-007-dxlp_33       lmax=1.2e-006-dxlp_33     wmin=6e-007-dxwp_33
+ wmax=1e-006-dxwp_33       version=4.5               binunit=2
+ paramchk=1                mobmod=0                  capmod=2
+ igcmod=0                  igbmod=0                  geomod=0
+ diomod=1                  rdsmod=0                  rbodymod=0
+ rgatemod=0                permod=1                  acnqsmod=0
+ trnqsmod=0                tempmod=0                 wpemod=wpeflag_33
+ tnom=25                   toxe=toxp_33              toxm=toxp_33
+ dtox=4.31e-010            epsrox=3.9                wint=3.99e-008
+ lint=6.95e-008            ll=0                      wl=0
+ lln=1                     wln=1                     lw=0
+ ww=0                      lwn=1                     wwn=1
+ lwl=0                     wwl=0                     llc=0
+ wlc=0                     lwc=0                     wwc=0
+ lwlc=0                    wwlc=0                    xl=-1.5e-08+dxlp_33
+ xw=0+dxwp_33              dlc=4.963e-8              dwc=0
+ xpart=1                   toxref=3e-009             dlcig=6.95e-008
+ vth0=-0.69070563+dvthp_33 lvth0=1.9514463e-009+dlvthp_33
+ wvth0=-4.0511369e-009+dwvthp_33                     pvth0=4.2374892e-015
+ k1=0.7905                 k2=-0.026649343+dk2p_33   lk2=-1.2395787e-008
+ wk2=-5.8806826e-009       pk2=6.151194e-015         k3=-1.5
+ k3b=1.2                   w0=0                      dvt0=0.9
+ dvt1=0.14                 dvt2=-0.012               dvt0w=0
+ dvt1w=0                   dvt2w=0                   dsub=0.2
+ minv=-0.3                 voffl=0                   dvtp0=0
+ dvtp1=0                   lpe0=1.5e-008             lpeb=0
+ web=0                     wec=0                     scref=1e-006
+ kvth0we=-0.016            lkvth0we=0                wkvth0we=0
+ pkvth0we=0                k2we=0                    lk2we=0
+ wk2we=0                   pk2we=0                   xj=1.8e-007
+ ngate=8.8e+019            ndep=8.4e+017             nsd=1e+020
+ phin=0                    cdsc=0                    cdscb=0
+ cdscd=0                   cit=0.00022052154         lcit=3.0834512e-011
+ wcit=-1.3068234e-011      pcit=1.3669347e-017       voff=-0.11346693
+ lvoff=4.7008858e-009      wvoff=1.9981158e-008      pvoff=-1.43528e-015
+ nfactor=0.81698774        lnfactor=-6.3875315e-008  wnfactor=-1.0765214e-007
+ pnfactor=5.8778076e-014   eta0=0.01                 etab=-0.0321035
+ wetab=8.3770407e-009      ud=0                      lud=0
+ wud=0                     pud=0                     ku0we=-0.006
+ lku0we=0                  wku0we=0                  pku0we=0
+ u0=104.47006+du0p_33      lu0=9.0253461e-006+dlu0p_33
+ wu0=7.5106153e-006        pu0=-4.100796e-012        ua=1.0310484e-009
+ lua=7.2965086e-017        wua=-2.0969945e-016       pua=2.0760403e-022
+ ub=8.5352117e-019         lub=2.6275631e-025        wub=1.4255047e-025
+ pub=-3.7776502e-031       uc=-2.6052229e-011        luc=2.7987538e-017
+ wuc=-4.2363902e-018       puc=-6.8346589e-024       vsat=70000
+ a0=0.86223568             la0=3.8251651e-007        wa0=7.8070065e-008
+ pa0=-2.5003675e-013       ags=0.24369004            lags=1.1249884e-007
+ wags=-5.1628909e-008      pags=6.2137584e-014       a1=0
+ a2=0.99                   b0=0                      b1=0
+ keta=-0.048010762         lketa=-1.4789904e-008     wketa=5.1722243e-009
+ pketa=-4.784262e-015      dwg=0                     dwb=0
+ pclm=0.5235389            lpclm=3.2089295e-008      wpclm=-5.7677122e-008
+ ppclm=1.7770116e-014      pdiblc1=0                 pdiblc2=0.00049315649
+ lpdiblc2=4.7968018e-011   wpdiblc2=-4.8969812e-011  ppdiblc2=1.3669334e-017
+ pdiblcb=0                 drout=0                   pvag=0
+ delta=0.007               pscbe1=8.564e+008         pscbe2=1e-020
+ fprout=0                  pdits=0                   pditsd=0
+ pditsl=0                  rsh=9.68                  rdsw=1005+drdswp_33
+ prwg=0                    prwb=0                    wr=1
+ alpha0=0                  alpha1=0.09               beta0=17
+ agidl=2.76e-012           bgidl=8.66e+008           cgidl=0.25
+ egidl=0.2624              aigbacc=0.01213           bigbacc=0.006537
+ cigbacc=0.2809            nigbacc=4.05              aigbinv=0.35
+ bigbinv=0.03              cigbinv=0.006             eigbinv=1.1
+ nigbinv=1                 aigc=0.01                 bigc=0.00144
+ cigc=1.515e-005           aigsd=0.008379            bigsd=0.0002699
+ cigsd=3.925e-020          nigc=1                    poxedge=1
+ pigcd=2.171               ntox=1                    xrcrg1=12
+ xrcrg2=1                  cgso=cgop_33              cgdo=cgop_33
+ cgbo=0                    cgdl=cglp_33              cgsl=cglp_33
+ clc=1e-007                cle=0.6                   cf=cfp_33
+ ckappas=0.6               ckappad=0.6               acde=0.4
+ moin=5.02                 noff=1                    voffcv=-0.044
+ kt1=-0.17884973           lkt1=1.4280756e-008       wkt1=-6.4622885e-010
+ pkt1=-6.83466e-015        kt1l=0                    kt2=-0.03
+ ute=-1.0481265            lute=2.6277047e-008       wute=2.5035384e-008
+ pute=-1.366932e-014       ua1=8.8320141e-010        lua1=9.1719916e-018
+ wua1=1.5021222e-016       pua1=-8.2015851e-023      ub1=-2.1988817e-018
+ lub1=-2.8358976e-025      wub1=2.6541481e-026       pub1=-2.7762389e-032
+ uc1=-1e-012               prt=0                     at=40920
+ lat=-0.01142232           fnoimod=1                 tnoimod=0
+ noia=6.5e+041             noib=2.2e+020             noic=5e+009
+ em=30000000               ef=1.2                    jss=3.6e-07
+ jsd=3.6e-07               jsws=1.6e-12              jswd=1.6e-12
+ jswgs=1.7e-12             jswgd=1.7e-12             njs=1
+ njd=1                     ijthsfwd=0.01             ijthdfwd=0.01
+ ijthsrev=0.01             ijthdrev=0.01             bvs=10
+ bvd=10                    xjbvs=1                   xjbvd=1
+ pbs=0.7556                pbd=0.7556                cjs=cjp_33
+ cjd=cjp_33                mjs=0.3261                mjd=0.3261
+ pbsws=0.3954              pbswd=0.3954              cjsws=cjswp_33
+ cjswd=cjswp_33            mjsws=0.0496              mjswd=0.0496
+ pbswgs=0.85               pbswgd=0.85               cjswgs=cjswgp_33
+ cjswgd=cjswgp_33          mjswgs=0.518              mjswgd=0.518
+ tpb=0.0015                tcj=0.000866              tpbsw=0.0019
+ tcjsw=0.00032             tpbswg=0.0014             tcjswg=0.000945
+ xtis=3                    xtid=3                    dmcg=1.125e-007
+ dmci=1.125e-007           dmdg=0                    dmcgt=0
+ dwj=0                     xgw=0                     xgl=0
+ rshg=1                    gbmin=1e-012              rbpb=50
+ rbpd=50                   rbps=50                   rbdb=50
+ rbsb=50                   ngcon=1                   saref=8.2e-007
+ sbref=8.2e-007            wlod=3e-007               kvth0=2e-009
+ lkvth0=-1e-007            wkvth0=1e-007             pkvth0=0
+ llodvth=1                 wlodvth=1                 stk2=0
+ lodk2=1                   lodeta0=1                 ku0=1.4e-007
+ lku0=-9e-008              wku0=5.5e-007             pku0=-1e-013
+ llodku0=1                 wlodku0=1                 kvsat=-0.2
+ steta0=0                  tku0=0.3                  minr=1e-3

     12: type=p
+ lmin=3.8e-07              lmax=7e-007-dxlp_33       wmin=6e-007-dxwp_33
+ wmax=1e-006-dxwp_33       version=4.5               binunit=2
+ paramchk=1                mobmod=0                  capmod=2
+ igcmod=0                  igbmod=0                  geomod=0
+ diomod=1                  rdsmod=0                  rbodymod=0
+ rgatemod=0                permod=1                  acnqsmod=0
+ trnqsmod=0                tempmod=0                 wpemod=wpeflag_33
+ tnom=25                   toxe=toxp_33              toxm=toxp_33
+ dtox=4.31e-010            epsrox=3.9                wint=3.99e-008
+ lint=6.95e-008            ll=0                      wl=0
+ lln=1                     wln=1                     lw=0
+ ww=0                      lwn=1                     wwn=1
+ lwl=0                     wwl=0                     llc=0
+ wlc=0                     lwc=0                     wwc=0
+ lwlc=0                    wwlc=0                    xl=-1.5e-08+dxlp_33
+ xw=0+dxwp_33              dlc=4.963e-8              dwc=0
+ xpart=1                   toxref=3e-009             dlcig=6.95e-008
+ vth0=-0.66328505+dvthp_33 lvth0=-1.3020187e-008+dlvthp_33
+ wvth0=1.2246186e-008+dwvthp_33                      pvth0=-4.6608493e-015
+ k1=0.7905                 k2=-0.064609722+dk2p_33   lk2=8.3305796e-009
+ wk2=1.1301525e-008        pk2=-3.2302916e-015       k3=-1.5
+ k3b=1.2                   w0=0                      dvt0=0.9
+ dvt1=0.14                 dvt2=-0.012               dvt0w=0
+ dvt1w=0                   dvt2w=0                   dsub=0.2
+ minv=-0.3                 voffl=0                   dvtp0=0
+ dvtp1=0                   lpe0=1.5e-008             lpeb=0
+ web=0                     wec=0                     scref=1e-006
+ kvth0we=-0.016            lkvth0we=0                wkvth0we=0
+ pkvth0we=0                k2we=0                    lk2we=0
+ wk2we=0                   pk2we=0                   xj=1.8e-007
+ ngate=8.8e+019            ndep=8.4e+017             nsd=1e+020
+ phin=0                    cdsc=0                    cdscb=0
+ cdscd=0                   cit=0.00022825316         lcit=2.6613047e-011
+ wcit=3.7322708e-011       pcit=-1.3844107e-017      voff=-0.14759606
+ lvoff=2.3335393e-008      wvoff=3.3643353e-008      pvoff=-8.8948382e-015
+ nfactor=0.68714128        lnfactor=7.0208518e-009   wnfactor=1.183259e-008
+ pnfactor=-6.4605878e-015  eta0=0.01                 etab=-0.0321035
+ wetab=8.3770407e-009      ud=0                      lud=0
+ wud=0                     pud=0                     ku0we=-0.006
+ lku0we=0                  wku0we=0                  pku0we=0
+ u0=110.20886+du0p_33      lu0=5.8919623e-006+dlu0p_33
+ wu0=9.2801156e-006        pu0=-5.0669431e-012       ua=-8.3996146e-010
+ lua=1.0945365e-015        wua=1.085858e-015         pua=-4.9977037e-022
+ ub=3.5485013e-018         lub=-1.2087028e-024       wub=-1.5480186e-024
+ pub=5.4528569e-031        uc=5.4765149e-011         luc=-1.613875e-017
+ wuc=-2.0557406e-017       puc=2.0766157e-024        vsat=73673.912
+ lvsat=-0.0020059562       wvsat=-0.0033807343       pvsat=1.8458809e-009
+ a0=2.1670193              la0=-3.2989536e-007       wa0=-6.5601801e-007
+ pa0=1.5077534e-013        ags=-0.10305207           lags=3.0182003e-007
+ wags=2.9683531e-008       pags=1.7740992e-014       a1=0
+ a2=0.99                   b0=0                      b1=0
+ keta=-0.10073926          lketa=1.3999854e-008      wketa=5.7068581e-009
+ pketa=-5.0761721e-015     dwg=0                     dwb=0
+ pclm=0.53970078           lpclm=2.3264908e-008      wpclm=1.2648584e-008
+ ppclm=-2.0627719e-014     pdiblc1=0                 pdiblc2=0.0012138848
+ lpdiblc2=-3.4554962e-010  wpdiblc2=-3.5499281e-010  ppdiblc2=1.8075789e-016
+ pdiblcb=0                 drout=0                   pvag=0
+ delta=0.007               pscbe1=8.564e+008         pscbe2=1e-020
+ fprout=0                  pdits=0                   pditsd=0
+ pditsl=0                  rsh=9.68                  rdsw=1005+drdswp_33
+ prwg=0                    prwb=0                    wr=1
+ alpha0=0                  alpha1=0.09               beta0=17
+ agidl=2.76e-012           bgidl=8.66e+008           cgidl=0.25
+ egidl=0.2624              aigbacc=0.01213           bigbacc=0.006537
+ cigbacc=0.2809            nigbacc=4.05              aigbinv=0.35
+ bigbinv=0.03              cigbinv=0.006             eigbinv=1.1
+ nigbinv=1                 aigc=0.01                 bigc=0.00144
+ cigc=1.515e-005           aigsd=0.008379            bigsd=0.0002699
+ cigsd=3.925e-020          nigc=1                    poxedge=1
+ pigcd=2.171               ntox=1                    xrcrg1=12
+ xrcrg2=1                  cgso=cgop_33              cgdo=cgop_33
+ cgbo=0                    cgdl=cglp_33              cgsl=cglp_33
+ clc=1e-007                cle=0.6                   cf=cfp_33
+ ckappas=0.6               ckappad=0.6               acde=0.4
+ moin=5.02                 noff=1                    voffcv=-0.044
+ kt1=-0.094019653          lkt1=-3.2036467e-008      wkt1=-3.2484818e-008
+ pkt1=1.0549209e-014       kt1l=0                    kt2=-0.03
+ ute=-1                    ua1=1.5349843e-009        lua1=-3.4670144e-016
+ wua1=7.613623e-020        pua1=-4.1550779e-026      ub1=-2.9528181e-018
+ lub1=1.2805954e-025       wub1=-6.8888168e-025      pub1=3.6285866e-031
+ uc1=5.6014856e-011        luc1=-3.1130112e-017      wuc1=-1.5213304e-017
+ puc1=8.3064641e-024       prt=0                     at=155.46686
+ lat=0.010835115           wat=0.016994951           pat=-9.2792434e-009
+ fnoimod=1                 tnoimod=0                 noia=6.5e+041
+ noib=2.2e+020             noic=5e+009               em=30000000
+ ef=1.2                    jss=3.6e-07               jsd=3.6e-07
+ jsws=1.6e-12              jswd=1.6e-12              jswgs=1.7e-12
+ jswgd=1.7e-12             njs=1                     njd=1
+ ijthsfwd=0.01             ijthdfwd=0.01             ijthsrev=0.01
+ ijthdrev=0.01             bvs=10                    bvd=10
+ xjbvs=1                   xjbvd=1                   pbs=0.7556
+ pbd=0.7556                cjs=cjp_33                cjd=cjp_33
+ mjs=0.3261                mjd=0.3261                pbsws=0.3954
+ pbswd=0.3954              cjsws=cjswp_33            cjswd=cjswp_33
+ mjsws=0.0496              mjswd=0.0496              pbswgs=0.85
+ pbswgd=0.85               cjswgs=cjswgp_33          cjswgd=cjswgp_33
+ mjswgs=0.518              mjswgd=0.518              tpb=0.0015
+ tcj=0.000866              tpbsw=0.0019              tcjsw=0.00032
+ tpbswg=0.0014             tcjswg=0.000945           xtis=3
+ xtid=3                    njtsswg=60                dmcg=1.125e-007
+ dmci=1.125e-007           dmdg=0                    dmcgt=0
+ dwj=0                     xgw=0                     xgl=0
+ rshg=1                    gbmin=1e-012              rbpb=50
+ rbpd=50                   rbps=50                   rbdb=50
+ rbsb=50                   ngcon=1                   saref=8.2e-007
+ sbref=8.2e-007            wlod=3e-007               kvth0=2e-009
+ lkvth0=-1e-007            wkvth0=1e-007             pkvth0=0
+ llodvth=1                 wlodvth=1                 stk2=0
+ lodk2=1                   lodeta0=1                 ku0=1.4e-007
+ lku0=-9e-008              wku0=5.5e-007             pku0=-1e-013
+ llodku0=1                 wlodku0=1                 kvsat=-0.2
+ steta0=0                  tku0=0.3                  minr=1e-3

     13: type=p
+ lmin=1e-005-dxlp_33       lmax=0.0009001            wmin=4e-07
+ wmax=6e-007-dxwp_33       version=4.5               binunit=2
+ paramchk=1                mobmod=0                  capmod=2
+ igcmod=0                  igbmod=0                  geomod=0
+ diomod=1                  rdsmod=0                  rbodymod=0
+ rgatemod=0                permod=1                  acnqsmod=0
+ trnqsmod=0                tempmod=0                 wpemod=wpeflag_33
+ tnom=25                   toxe=toxp_33              toxm=toxp_33
+ dtox=4.31e-010            epsrox=3.9                wint=3.99e-008
+ lint=6.95e-008            ll=0                      wl=0
+ lln=1                     wln=1                     lw=0
+ ww=0                      lwn=1                     wwn=1
+ lwl=0                     wwl=0                     llc=0
+ wlc=0                     lwc=0                     wwc=0
+ lwlc=0                    wwlc=0                    xl=-1.5e-08+dxlp_33
+ xw=0+dxwp_33              dlc=4.963e-8              dwc=0
+ xpart=1                   toxref=3e-009             dlcig=6.95e-008
+ vth0=-0.68884+dvthp_33    k1=0.7905                 k2=-0.0344217+dk2p_33
+ wk2=1.4158283e-009        k3=-1.5                   k3b=1.2
+ w0=0                      dvt0=0.9                  dvt1=0.14
+ dvt2=-0.012               dvt0w=0                   dvt1w=0
+ dvt2w=0                   dsub=0.2                  minv=-0.3
+ voffl=0                   dvtp0=0                   dvtp1=0
+ lpe0=1.5e-008             lpeb=0                    web=0
+ wec=0                     scref=1e-006              kvth0we=-0.016
+ lkvth0we=0                wkvth0we=0                pkvth0we=0
+ k2we=0                    lk2we=0                   wk2we=0
+ pk2we=0                   xj=1.8e-007               ngate=8.8e+019
+ ndep=8.4e+017             nsd=1e+020                phin=0
+ cdsc=0                    cdscb=0                   cdscd=0
+ cit=3.596e-005            lcit=-1.0357102e-016      wcit=3.3313608e-011
+ pcit=3.3163442e-023       voff=-0.0679631           lvoff=-1.5937833e-014
+ wvoff=2.5818046e-009      pvoff=8.2908611e-021      nfactor=0.7
+ eta0=0.01                 etab=-0.016               ud=0
+ lud=0                     wud=0                     pud=0
+ ku0we=-0.006              lku0we=0                  wku0we=0
+ pku0we=0                  u0=117.399+du0p_33        wu0=8.328402e-007
+ ua=1.5628529e-009         lua=-2.986477e-022        wua=-3.2177292e-016
+ pua=-3.4565192e-036       ub=5.3915865e-019         lub=4.183059e-031
+ wub=1.2201968e-025        pub=-1.6581722e-037       uc=-3.9207e-011
+ wuc=5.8298814e-018        vsat=70000                a0=1.2306798
+ wa0=2.669003e-008         ags=0.19953053            wags=5.2845376e-009
+ a1=0                      a2=0.99                   b0=0
+ b1=0                      keta=-0.0325025           wketa=2.0821005e-009
+ dwg=0                     dwb=0                     pclm=0.28899
+ wpclm=8.328402e-009       pdiblc1=0                 pdiblc2=0.000231995
+ wpdiblc2=4.164201e-012    pdiblcb=0                 drout=0
+ pvag=0                    delta=0.007               pscbe1=8.564e+008
+ pscbe2=1e-020             fprout=0                  pdits=0
+ pditsd=0                  pditsl=0                  rsh=9.68
+ rdsw=1005+drdswp_33       prwg=0                    prwb=0
+ wr=1                      alpha0=0                  alpha1=0.09
+ beta0=17                  agidl=2.76e-012           bgidl=8.66e+008
+ cgidl=0.25                egidl=0.2624              aigbacc=0.01213
+ bigbacc=0.006537          cigbacc=0.2809            nigbacc=4.05
+ aigbinv=0.35              bigbinv=0.03              cigbinv=0.006
+ eigbinv=1.1               nigbinv=1                 aigc=0.01
+ bigc=0.00144              cigc=1.515e-005           aigsd=0.008379
+ bigsd=0.0002699           cigsd=3.925e-020          nigc=1
+ poxedge=1                 pigcd=2.171               ntox=1
+ xrcrg1=12                 xrcrg2=1                  cgso=cgop_33
+ cgdo=cgop_33              cgbo=0                    cgdl=cglp_33
+ cgsl=cglp_33              clc=1e-007                cle=0.6
+ cf=cfp_33                 ckappas=0.6               ckappad=0.6
+ acde=0.4                  moin=5.02                 noff=1
+ voffcv=-0.044             kt1=-0.1966085            wkt1=7.0791417e-009
+ kt1l=0                    kt2=-0.03                 ute=-1.0093107
+ wute=-2.2070265e-010      ua1=1.016773e-009         wua1=2.2486685e-017
+ ub1=-2.450703e-018        uc1=-1e-012               prt=0
+ at=80000                  fnoimod=1                 tnoimod=0
+ noia=6.5e+041             noib=2.2e+020             noic=5e+009
+ em=30000000               ef=1.2                    jss=3.6e-07
+ jsd=3.6e-07               jsws=1.6e-12              jswd=1.6e-12
+ jswgs=1.7e-12             jswgd=1.7e-12             njs=1
+ njd=1                     ijthsfwd=0.01             ijthdfwd=0.01
+ ijthsrev=0.01             ijthdrev=0.01             bvs=10
+ bvd=10                    xjbvs=1                   xjbvd=1
+ pbs=0.7556                pbd=0.7556                cjs=cjp_33
+ cjd=cjp_33                mjs=0.3261                mjd=0.3261
+ pbsws=0.3954              pbswd=0.3954              cjsws=cjswp_33
+ cjswd=cjswp_33            mjsws=0.0496              mjswd=0.0496
+ pbswgs=0.85               pbswgd=0.85               cjswgs=cjswgp_33
+ cjswgd=cjswgp_33          mjswgs=0.518              mjswgd=0.518
+ tpb=0.0015                tcj=0.000866              tpbsw=0.0019
+ tcjsw=0.00032             tpbswg=0.0014             tcjswg=0.000945
+ xtis=3                    xtid=3                    dmcg=1.125e-007
+ dmci=1.125e-007           dmdg=0                    dmcgt=0
+ dwj=0                     xgw=0                     xgl=0
+ rshg=1                    gbmin=1e-012              rbpb=50
+ rbpd=50                   rbps=50                   rbdb=50
+ rbsb=50                   ngcon=1                   saref=8.2e-007
+ sbref=8.2e-007            wlod=3e-007               kvth0=2e-009
+ lkvth0=-1e-007            wkvth0=1e-007             pkvth0=0
+ llodvth=1                 wlodvth=1                 stk2=0
+ lodk2=1                   lodeta0=1                 ku0=1.4e-007
+ lku0=-9e-008              wku0=5.5e-007             pku0=-1e-013
+ llodku0=1                 wlodku0=1                 kvsat=-0.2
+ steta0=0                  tku0=0.3                  lvth0=0+dlvthp_33
+ wvth0=0+dwvthp_33         lu0=0+dlu0p_33            minr=1e-3

     14: type=p
+ lmin=1.2e-006-dxlp_33     lmax=1e-005-dxlp_33       wmin=4e-07
+ wmax=6e-007-dxwp_33       version=4.5               binunit=2
+ paramchk=1                mobmod=0                  capmod=2
+ igcmod=0                  igbmod=0                  geomod=0
+ diomod=1                  rdsmod=0                  rbodymod=0
+ rgatemod=0                permod=1                  acnqsmod=0
+ trnqsmod=0                tempmod=0                 wpemod=wpeflag_33
+ tnom=25                   toxe=toxp_33              toxm=toxp_33
+ dtox=4.31e-010            epsrox=3.9                wint=3.99e-008
+ lint=6.95e-008            ll=0                      wl=0
+ lln=1                     wln=1                     lw=0
+ ww=0                      lwn=1                     wwn=1
+ lwl=0                     wwl=0                     llc=0
+ wlc=0                     lwc=0                     wwc=0
+ lwlc=0                    wwlc=0                    xl=-1.5e-08+dxlp_33
+ xw=0+dxwp_33              dlc=4.963e-8              dwc=0
+ xpart=1                   toxref=3e-009             dlcig=6.95e-008
+ vth0=-0.68884+dvthp_33    k1=0.7905                 k2=-0.033461187+dk2p_33
+ lk2=-9.4572137e-009       wk2=1.3366328e-009        pk2=7.7975921e-016
+ k3=-1.5                   k3b=1.2                   w0=0
+ dvt0=0.9                  dvt1=0.14                 dvt2=-0.012
+ dvt0w=0                   dvt1w=0                   dvt2w=0
+ dsub=0.2                  minv=-0.3                 voffl=0
+ dvtp0=0                   dvtp1=0                   lpe0=1.5e-008
+ lpeb=0                    web=0                     wec=0
+ scref=1e-006              kvth0we=-0.016            lkvth0we=0
+ wkvth0we=0                pkvth0we=0                k2we=0
+ lk2we=0                   wk2we=0                   pk2we=0
+ xj=1.8e-007               ngate=8.8e+019            ndep=8.4e+017
+ nsd=1e+020                phin=0                    cdsc=0
+ cdscb=0                   cdscd=0                   cit=1.0518421e-005
+ lcit=2.5049769e-010       wcit=3.7273386e-011       pcit=-3.8987945e-017
+ voff=-0.066902933         lvoff=-1.0438419e-008     wvoff=2.661001e-009
+ pvoff=-7.7975921e-016     nfactor=0.70596749        lnfactor=-5.8755901e-008
+ wnfactor=-4.4547487e-010  pnfactor=4.3861455e-015   eta0=0.01
+ etab=-0.016               ud=0                      lud=0
+ wud=0                     pud=0                     ku0we=-0.006
+ lku0we=0                  wku0we=0                  pku0we=0
+ u0=117.28014+du0p_33      lu0=1.1703314e-006+dlu0p_33
+ wu0=8.328402e-007         pu0=-3.3752135e-027       ua=1.5208108e-009
+ lua=4.1394547e-016        wua=-3.0824575e-016       pua=-1.3318858e-022
+ ub=5.7302315e-019         lub=-3.3342947e-025       wub=1.0992044e-025
+ pub=1.19129e-031          uc=-3.9587007e-011        luc=3.7415492e-018
+ wuc=5.5328981e-018        puc=2.9240971e-024        vsat=70000
+ a0=1.2925636              la0=-6.0930812e-007       wa0=1.6974125e-008
+ pa0=9.5662799e-014        ags=0.18319371            lags=1.6085235e-007
+ wags=4.1060784e-009       pags=1.1603109e-014       a1=0
+ a2=0.99                   b0=0                      b1=0
+ keta=-0.027783079         lketa=-4.646742e-008      wketa=1.6366257e-009
+ pketa=4.3861446e-015      dwg=0                     dwb=0
+ pclm=0.26561951           lpclm=2.3010587e-007      wpclm=9.9123126e-009
+ ppclm=-1.5595184e-014     pdiblc1=0                 pdiblc2=0.00018467479
+ lpdiblc2=4.6591476e-010   wpdiblc2=1.4558615e-011   ppdiblc2=-1.023434e-016
+ pdiblcb=0                 drout=0                   pvag=0
+ delta=0.007               pscbe1=8.564e+008         pscbe2=1e-020
+ fprout=0                  pdits=0                   pditsd=0
+ pditsl=0                  rsh=9.68                  rdsw=1005+drdswp_33
+ prwg=0                    prwb=0                    wr=1
+ alpha0=0                  alpha1=0.09               beta0=17
+ agidl=2.76e-012           bgidl=8.66e+008           cgidl=0.25
+ egidl=0.2624              aigbacc=0.01213           bigbacc=0.006537
+ cigbacc=0.2809            nigbacc=4.05              aigbinv=0.35
+ bigbinv=0.03              cigbinv=0.006             eigbinv=1.1
+ nigbinv=1                 aigc=0.01                 bigc=0.00144
+ cigc=1.515e-005           aigsd=0.008379            bigsd=0.0002699
+ cigsd=3.925e-020          nigc=1                    poxedge=1
+ pigcd=2.171               ntox=1                    xrcrg1=12
+ xrcrg2=1                  cgso=cgop_33              cgdo=cgop_33
+ cgbo=0                    cgdl=cglp_33              cgsl=cglp_33
+ clc=1e-007                cle=0.6                   cf=cfp_33
+ ckappas=0.6               ckappad=0.6               acde=0.4
+ moin=5.02                 noff=1                    voffcv=-0.044
+ kt1=-0.19946271           lkt1=2.8102582e-008       wkt1=8.3165719e-009
+ pkt1=-1.2183738e-014      kt1l=0                    kt2=-0.03
+ ute=-1.0142235            lute=4.8370655e-008       wute=1.7329521e-009
+ pute=-1.9235685e-014      ua1=1.0228128e-009        lua1=-5.9468048e-017
+ wua1=2.1199758e-017       pua1=1.2671087e-023       ub1=-2.4484093e-018
+ lub1=-2.2583884e-026      uc1=-1e-012               prt=0
+ at=85943.182              lat=-0.058516568          fnoimod=1
+ tnoimod=0                 noia=6.5e+041             noib=2.2e+020
+ noic=5e+009               em=30000000               ef=1.2
+ jss=3.6e-07               jsd=3.6e-07               jsws=1.6e-12
+ jswd=1.6e-12              jswgs=1.7e-12             jswgd=1.7e-12
+ njs=1                     njd=1                     ijthsfwd=0.01
+ ijthdfwd=0.01             ijthsrev=0.01             ijthdrev=0.01
+ bvs=10                    bvd=10                    xjbvs=1
+ xjbvd=1                   pbs=0.7556                pbd=0.7556
+ cjs=cjp_33                cjd=cjp_33                mjs=0.3261
+ mjd=0.3261                pbsws=0.3954              pbswd=0.3954
+ cjsws=cjswp_33            cjswd=cjswp_33            mjsws=0.0496
+ mjswd=0.0496              pbswgs=0.85               pbswgd=0.85
+ cjswgs=cjswgp_33          cjswgd=cjswgp_33          mjswgs=0.518
+ mjswgd=0.518              tpb=0.0015                tcj=0.000866
+ tpbsw=0.0019              tcjsw=0.00032             tpbswg=0.0014
+ tcjswg=0.000945           xtis=3                    xtid=3
+ dmcg=1.125e-007           dmci=1.125e-007           dmdg=0
+ dmcgt=0                   dwj=0                     xgw=0
+ xgl=0                     rshg=1                    gbmin=1e-012
+ rbpb=50                   rbpd=50                   rbps=50
+ rbdb=50                   rbsb=50                   ngcon=1
+ saref=8.2e-007            sbref=8.2e-007            wlod=3e-007
+ kvth0=2e-009              lkvth0=-1e-007            wkvth0=1e-007
+ pkvth0=0                  llodvth=1                 wlodvth=1
+ stk2=0                    lodk2=1                   lodeta0=1
+ ku0=1.4e-007              lku0=-9e-008              wku0=5.5e-007
+ pku0=-1e-013              llodku0=1                 wlodku0=1
+ kvsat=-0.2                steta0=0                  tku0=0.3
+ lvth0=0+dlvthp_33         wvth0=0+dwvthp_33         minr=1e-3

     15: type=p
+ lmin=7e-007-dxlp_33       lmax=1.2e-006-dxlp_33     wmin=4e-07
+ wmax=6e-007-dxwp_33       version=4.5               binunit=2
+ paramchk=1                mobmod=0                  capmod=2
+ igcmod=0                  igbmod=0                  geomod=0
+ diomod=1                  rdsmod=0                  rbodymod=0
+ rgatemod=0                permod=1                  acnqsmod=0
+ trnqsmod=0                tempmod=0                 wpemod=wpeflag_33
+ tnom=25                   toxe=toxp_33              toxm=toxp_33
+ dtox=4.31e-010            epsrox=3.9                wint=3.99e-008
+ lint=6.95e-008            ll=0                      wl=0
+ lln=1                     wln=1                     lw=0
+ ww=0                      lwn=1                     wwn=1
+ lwl=0                     wwl=0                     llc=0
+ wlc=0                     lwc=0                     wwc=0
+ lwlc=0                    wwlc=0                    xl=-1.5e-08+dxlp_33
+ xw=0+dxwp_33              dlc=4.963e-8              dwc=0
+ xpart=1                   toxref=3e-009             dlcig=6.95e-008
+ vth0=-0.70024157+dvthp_33 lvth0=1.1926044e-008+dlvthp_33
+ wvth0=9.094615e-010+dwvthp_33                       pvth0=-9.5129673e-016
+ k1=0.7905                 k2=-0.05069796+dk2p_33    lk2=8.5724512e-009
+ wk2=6.629408e-009         pk2=-4.7564836e-015       k3=-1.5
+ k3b=1.2                   w0=0                      dvt0=0.9
+ dvt1=0.14                 dvt2=-0.012               dvt0w=0
+ dvt1w=0                   dvt2w=0                   dsub=0.2
+ minv=-0.3                 voffl=0                   dvtp0=0
+ dvtp1=0                   lpe0=1.5e-008             lpeb=0
+ web=0                     wec=0                     scref=1e-006
+ kvth0we=-0.016            lkvth0we=0                wkvth0we=0
+ pkvth0we=0                k2we=0                    lk2we=0
+ wk2we=0                   pk2we=0                   xj=1.8e-007
+ ngate=8.8e+019            ndep=8.4e+017             nsd=1e+020
+ phin=0                    cdsc=0                    cdscb=0
+ cdscd=0                   cit=0.00010798531         lcit=1.4854732e-010
+ wcit=4.547311e-011        pcit=-4.7564855e-017      voff=-0.07664075
+ lvoff=-2.5266286e-010     wvoff=8.2417949e-010      pvoff=1.1415561e-015
+ nfactor=0.57224436        lnfactor=8.1118491e-008   wnfactor=1.9663366e-008
+ pnfactor=-1.6647702e-014  eta0=0.01                 etab=-0.016
+ ud=0                      lud=0                     wud=0
+ pud=0                     ku0we=-0.006              lku0we=0
+ wku0we=0                  pku0we=0                  u0=117.307+du0p_33
+ lu0=1.142232e-006+dlu0p_33                          wu0=8.328402e-007
+ pu0=-5.1441331e-026       ua=1.2887356e-009         lua=6.5669618e-016
+ wua=-3.4374833e-016       pua=-9.6052887e-023       ub=8.5492059e-019
+ lub=-6.2829419e-025       wub=1.418225e-025         pub=8.5759448e-032
+ uc=-6.7688923e-011        luc=3.3136154e-017        wuc=1.7423018e-017
+ puc=-9.5129686e-024       vsat=70000                a0=0.96677819
+ la0=-2.685366e-007        wa0=2.3687052e-008        pa0=8.8641078e-014
+ ags=0.097966465           lags=2.5000005e-007       wags=2.4176494e-008
+ pags=-9.3905449e-015      a1=0                      a2=0.99
+ b0=0                      b1=0                      keta=-0.055394021
+ lketa=-1.7586374e-008     wketa=9.0129958e-009      pketa=-3.3295385e-015
+ dwg=0                     dwb=0                     pclm=0.44936853
+ lpclm=3.7904398e-008      wpclm=-1.9093694e-008     ppclm=1.4745099e-014
+ pdiblc1=0                 pdiblc2=0.00076017354     lpdiblc2=-1.3605693e-010
+ wpdiblc2=-1.8787208e-010  ppdiblc2=1.0939911e-016   pdiblcb=0
+ drout=0                   pvag=0                    delta=0.007
+ pscbe1=8.564e+008         pscbe2=1e-020             fprout=0
+ pdits=0                   pditsd=0                  pditsl=0
+ rsh=9.68                  rdsw=1005+drdswp_33       prwg=0
+ prwb=0                    wr=1                      alpha0=0
+ alpha1=0.09               beta0=17                  agidl=2.76e-012
+ bgidl=8.66e+008           cgidl=0.25                egidl=0.2624
+ aigbacc=0.01213           bigbacc=0.006537          cigbacc=0.2809
+ nigbacc=4.05              aigbinv=0.35              bigbinv=0.03
+ cigbinv=0.006             eigbinv=1.1               nigbinv=1
+ aigc=0.01                 bigc=0.00144              cigc=1.515e-005
+ aigsd=0.008379            bigsd=0.0002699           cigsd=3.925e-020
+ nigc=1                    poxedge=1                 pigcd=2.171
+ ntox=1                    xrcrg1=12                 xrcrg2=1
+ cgso=cgop_33              cgdo=cgop_33              cgbo=0
+ cgdl=cglp_33              cgsl=cglp_33              clc=1e-007
+ cle=0.6                   cf=cfp_33                 ckappas=0.6
+ ckappad=0.6               acde=0.4                  moin=5.02
+ noff=1                    voffcv=-0.044             kt1=-0.16669483
+ lkt1=-6.1726217e-009      wkt1=-6.9692068e-009      pkt1=3.8051869e-015
+ kt1l=0                    kt2=-0.03                 ute=-1.0029458
+ lute=3.6574269e-008       wute=1.532426e-009        pute=-1.9025935e-014
+ ua1=1.1254029e-009        lua1=-1.6677728e-016      wua1=2.4219002e-017
+ pua1=9.5129578e-024       ub1=-2.1123522e-018       lub1=-3.7409961e-025
+ wub1=-1.8471163e-026      pub1=1.9320837e-032       uc1=-1e-012
+ prt=0                     at=40920                  lat=-0.01142232
+ fnoimod=1                 tnoimod=0                 noia=6.5e+041
+ noib=2.2e+020             noic=5e+009               em=30000000
+ ef=1.2                    jss=3.6e-07               jsd=3.6e-07
+ jsws=1.6e-12              jswd=1.6e-12              jswgs=1.7e-12
+ jswgd=1.7e-12             njs=1                     njd=1
+ ijthsfwd=0.01             ijthdfwd=0.01             ijthsrev=0.01
+ ijthdrev=0.01             bvs=10                    bvd=10
+ xjbvs=1                   xjbvd=1                   pbs=0.7556
+ pbd=0.7556                cjs=cjp_33                cjd=cjp_33
+ mjs=0.3261                mjd=0.3261                pbsws=0.3954
+ pbswd=0.3954              cjsws=cjswp_33            cjswd=cjswp_33
+ mjsws=0.0496              mjswd=0.0496              pbswgs=0.85
+ pbswgd=0.85               cjswgs=cjswgp_33          cjswgd=cjswgp_33
+ mjswgs=0.518              mjswgd=0.518              tpb=0.0015
+ tcj=0.000866              tpbsw=0.0019              tcjsw=0.00032
+ tpbswg=0.0014             tcjswg=0.000945           xtis=3
+ xtid=3                    dmcg=1.125e-007           dmci=1.125e-007
+ dmdg=0                    dmcgt=0                   dwj=0
+ xgw=0                     xgl=0                     rshg=1
+ gbmin=1e-012              rbpb=50                   rbpd=50
+ rbps=50                   rbdb=50                   rbsb=50
+ ngcon=1                   saref=8.2e-007            sbref=8.2e-007
+ wlod=3e-007               kvth0=2e-009              lkvth0=-1e-007
+ wkvth0=1e-007             pkvth0=0                  llodvth=1
+ wlodvth=1                 stk2=0                    lodk2=1
+ lodeta0=1                 ku0=1.4e-007              lku0=-9e-008
+ wku0=5.5e-007             pku0=-1e-013              llodku0=1
+ wlodku0=1                 kvsat=-0.2                steta0=0
+ tku0=0.3                  minr=1e-3

     16: type=p
+ lmin=3.8e-07              lmax=7e-007-dxlp_33       wmin=4e-07
+ wmax=6e-007-dxwp_33       version=4.5               binunit=2
+ paramchk=1                mobmod=0                  capmod=2
+ igcmod=0                  igbmod=0                  geomod=0
+ diomod=1                  rdsmod=0                  rbodymod=0
+ rgatemod=0                permod=1                  acnqsmod=0
+ trnqsmod=0                tempmod=0                 wpemod=wpeflag_33
+ tnom=25                   toxe=toxp_33              toxm=toxp_33
+ dtox=4.31e-010            epsrox=3.9                wint=3.99e-008
+ lint=6.95e-008            ll=0                      wl=0
+ lln=1                     wln=1                     lw=0
+ ww=0                      lwn=1                     wwn=1
+ lwl=0                     wwl=0                     llc=0
+ wlc=0                     lwc=0                     wwc=0
+ lwlc=0                    wwlc=0                    xl=-1.5e-08+dxlp_33
+ xw=0+dxwp_33              dlc=4.963e-8              dwc=0
+ xpart=1                   toxref=3e-009             dlcig=6.95e-008
+ vth0=-0.65373519+dvthp_33 lvth0=-1.3466441e-008+dlvthp_33
+ wvth0=7.2783467e-009+dwvthp_33                      pvth0=-4.428708e-015
+ k1=0.7905                 k2=-0.032097638+dk2p_33   lk2=-1.5833249e-009
+ wk2=-5.6112608e-009       pk2=1.9269215e-015        k3=-1.5
+ k3b=1.2                   w0=0                      dvt0=0.9
+ dvt1=0.14                 dvt2=-0.012               dvt0w=0
+ dvt1w=0                   dvt2w=0                   dsub=0.2
+ minv=-0.3                 voffl=0                   dvtp0=0
+ dvtp1=0                   lpe0=1.5e-008             lpeb=0
+ web=0                     wec=0                     scref=1e-006
+ kvth0we=-0.016            lkvth0we=0                wkvth0we=0
+ pkvth0we=0                k2we=0                    lk2we=0
+ wk2we=0                   pk2we=0                   xj=1.8e-007
+ ngate=8.8e+019            ndep=8.4e+017             nsd=1e+020
+ phin=0                    cdsc=0                    cdscb=0
+ cdscd=0                   cit=0.00038005            wcit=-4.164201e-011
+ voff=-0.10693811          lvoff=1.6289694e-008      wvoff=1.2493083e-008
+ pvoff=-5.2296654e-015     nfactor=0.66206668        lnfactor=3.2075508e-008
+ wnfactor=2.4876402e-008   pnfactor=-1.949402e-014   eta0=0.019822445
+ leta0=-5.3630551e-009     weta0=-5.109636e-009      peta0=2.7898613e-015
+ etab=-0.016               ud=0                      lud=0
+ wud=0                     pud=0                     ku0we=-0.006
+ lku0we=0                  wku0we=0                  pku0we=0
+ u0=137.47176+du0p_33      lu0=-9.8677275e-006+dlu0p_33
+ wu0=-4.9020454e-006       pu0=3.1312475e-012        ua=2.9365562e-009
+ lua=-2.4301386e-016       wua=-8.7868642e-016       pua=1.9602331e-022
+ ub=-6.6211517e-019        lub=2.0000733e-025        wub=6.4234407e-025
+ pub=-1.8752533e-031       uc=2.4857883e-011         luc=-1.7394402e-017
+ wuc=-4.9996457e-018       puc=2.7298059e-024        vsat=67717.739
+ lvsat=0.0012461145        wvsat=-0.00028233283      pvsat=1.5415372e-010
+ a0=-0.11029259            la0=3.1954404e-007        wa0=5.2863965e-007
+ pa0=-1.8706304e-013       ags=0.47092211            lags=4.6366271e-008
+ wags=-2.6889784e-007      pags=1.5062804e-013       a1=0
+ a2=0.99                   b0=0                      b1=0
+ keta=-0.10159113          lketa=7.6372484e-009      wketa=6.1500035e-009
+ pketa=-1.7663448e-015     dwg=0                     dwb=0
+ pclm=0.57045915           lpclm=-2.8211083e-008     wpclm=-3.3519215e-009
+ ppclm=6.1500913e-015      pdiblc1=0                 pdiblc2=0.00050180025
+ lpdiblc2=5.0148844e-012   wpdiblc2=1.5433556e-011   ppdiblc2=-1.6057647e-018
+ pdiblcb=0                 drout=0                   pvag=0
+ delta=0.007               pscbe1=8.564e+008         pscbe2=1e-020
+ fprout=0                  pdits=0                   pditsd=0
+ pditsl=0                  rsh=9.68                  rdsw=1005+drdswp_33
+ prwg=0                    prwb=0                    wr=1
+ alpha0=0                  alpha1=0.09               beta0=17
+ agidl=2.76e-012           bgidl=8.66e+008           cgidl=0.25
+ egidl=0.2624              aigbacc=0.01213           bigbacc=0.006537
+ cigbacc=0.2809            nigbacc=4.05              aigbinv=0.35
+ bigbinv=0.03              cigbinv=0.006             eigbinv=1.1
+ nigbinv=1                 aigc=0.01                 bigc=0.00144
+ cigc=1.515e-005           aigsd=0.008379            bigsd=0.0002699
+ cigsd=3.925e-020          nigc=1                    poxedge=1
+ pigcd=2.171               ntox=1                    xrcrg1=12
+ xrcrg2=1                  cgso=cgop_33              cgdo=cgop_33
+ cgbo=0                    cgdl=cglp_33              cgsl=cglp_33
+ clc=1e-007                cle=0.6                   cf=cfp_33
+ ckappas=0.6               ckappad=0.6               acde=0.4
+ moin=5.02                 noff=1                    voffcv=-0.044
+ kt1=-0.12740729           lkt1=-2.7623621e-008      wkt1=-1.511657e-008
+ pkt1=8.2536473e-015       kt1l=0                    kt2=-0.03
+ ute=-0.92465294           lute=-6.1736561e-009      wute=-3.9195542e-008
+ pute=3.2115359e-015       ua1=1.3985453e-009        lua1=-3.1591303e-016
+ wua1=7.1051677e-017       pua1=-1.6057683e-023      ub1=-4.0594966e-018
+ lub1=6.8904126e-025       wub1=-1.1318751e-025      pub1=7.1035963e-032
+ uc1=2.7225425e-011        luc1=-1.5411082e-017      wuc1=-2.3704194e-019
+ puc1=1.294249e-025        prt=0                     at=37661.644
+ lat=-0.0096432575         wat=-0.002515762          pat=1.373606e-009
+ fnoimod=1                 tnoimod=0                 noia=6.5e+041
+ noib=2.2e+020             noic=5e+009               em=30000000
+ ef=1.2                    jss=3.6e-07               jsd=3.6e-07
+ jsws=1.6e-12              jswd=1.6e-12              jswgs=1.7e-12
+ jswgd=1.7e-12             njs=1                     njd=1
+ ijthsfwd=0.01             ijthdfwd=0.01             ijthsrev=0.01
+ ijthdrev=0.01             bvs=10                    bvd=10
+ xjbvs=1                   xjbvd=1                   pbs=0.7556
+ pbd=0.7556                cjs=cjp_33                cjd=cjp_33
+ mjs=0.3261                mjd=0.3261                pbsws=0.3954
+ pbswd=0.3954              cjsws=cjswp_33            cjswd=cjswp_33
+ mjsws=0.0496              mjswd=0.0496              pbswgs=0.85
+ pbswgd=0.85               cjswgs=cjswgp_33          cjswgd=cjswgp_33
+ mjswgs=0.518              mjswgd=0.518              tpb=0.0015
+ tcj=0.000866              tpbsw=0.0019              tcjsw=0.00032
+ tpbswg=0.0014             tcjswg=0.000945           xtis=3
+ xtid=3                    dmcg=1.125e-007           dmci=1.125e-007
+ dmdg=0                    dmcgt=0                   dwj=0
+ xgw=0                     xgl=0                     rshg=1
+ gbmin=1e-012              rbpb=50                   rbpd=50
+ rbps=50                   rbdb=50                   rbsb=50
+ ngcon=1                   saref=8.2e-007            sbref=8.2e-007
+ wlod=3e-007               kvth0=2e-009              lkvth0=-1e-007
+ wkvth0=1e-007             pkvth0=0                  llodvth=1
+ wlodvth=1                 stk2=0                    lodk2=1
+ lodeta0=1                 ku0=1.4e-007              lku0=-9e-008
+ wku0=5.5e-007             pku0=-1e-013              llodku0=1
+ wlodku0=1                 kvsat=-0.2                steta0=0
+ tku0=0.3                  minr=1e-3

     }
endsection mos_33

//  *************************************************************
//                                                              *
//                1.0V NATIVE NMOS DEVICE LIB                   *
//                                                              *
//  *************************************************************
//

section mos_na
//
//  *****************************************************************************************
//
//             *
//                                1.0V NATIVE NMOS DEVICE MODELS
//             *
//
//             *
//  *****************************************************************************************

model nch_na bsim4  {
     1: type=n
+ lmin=1.0000e-05-dxl_na    lmax=2.001e-05            wmin=1.0000e-05-dxw_na
+ wmax=9.001e-04            version=4.5               binunit=2
+ paramchk=1                mobmod=0                  capmod=2
+ igcmod=1                  igbmod=1                  geomod=0
+ diomod=1                  rdsmod=0                  rbodymod=0
+ rgatemod=0                permod=1                  acnqsmod=0
+ trnqsmod=0                tnom=25                   toxe=toxn_na
+ toxm=toxn_na              dtox=4e-010               epsrox=3.9
+ wint=6e-009               lint=2.5e-009             ll=0
+ wl=0                      lln=1                     wln=1
+ lw=0                      ww=0                      lwn=1
+ wwn=1                     lwl=0                     wwl=0
+ llc=0                     wlc=0                     lwc=0
+ wwc=0                     lwlc=0                    wwlc=0
+ dlc=1.43e-008             dwc=0                     xpart=1
+ toxref=3e-009             dlcig=1.2e-009            xl=-5.5e-08+dxl_na
+ xw=1.5e-8+dxw_na          vth0=-0.1207+dvthn_na     lvth0=0+dlvthn_na
+ wvth0=0+dwvthn_na         pvth0=0+dpvthn_na         k1=0.1432
+ k2=-0.036                 k3=-2.45                  k3b=1.2
+ w0=-5e-008                dvt0=0.1                  dvt1=0.1
+ dvt2=0                    dvt0w=0                   dvt1w=0
+ dvt2w=0                   dsub=0.3                  minv=0
+ voffl=0                   dvtp0=0.0001              dvtp1=2
+ lpe0=5.081e-007           lpeb=0                    xj=1.5e-007
+ ngate=2e020               ndep=2.3687e017           nsd=1e020
+ phin=0                    cdsc=0                    cdscb=0
+ cdscd=0                   cit=0                     voff=-0.06843
+ nfactor=1.2               eta0=0.0021               etab=0
+ u0=0.05124                ua=3.515e-010             ub=2.422e-018
+ uc=2.733e-011             vsat=111700               a0=8.31
+ ags=1.228                 a1=0                      a2=1
+ b0=0                      b1=0                      keta=0
+ dwg=0                     dwb=0                     pclm=1.32
+ pdiblc1=0.001             pdiblc2=0.01125           pdiblcb=0
+ drout=0.56                pvag=1.5                  delta=0.0075
+ pscbe1=5.545e008          pscbe2=1e-020             fprout=1000
+ pdits=0                   pditsd=0                  pditsl=0
+ rsh=10.5                  rdsw=135                  prwg=0
+ prwb=0                    wr=1                      alpha0=0
+ alpha1=0.03               beta0=8.7                 agidl=9e-008
+ bgidl=2.3e009             cgidl=0.5                 egidl=0.53
+ aigbacc=0.01157           bigbacc=0.002437          cigbacc=0.1416
+ nigbacc=4.05              aigbinv=0.35              bigbinv=0.03
+ cigbinv=0.006             eigbinv=1.1               nigbinv=1
+ aigc=0.0109               bigc=0.001801             cigc=0
+ aigsd=0.00744             bigsd=0.0002354           cigsd=0.001463
+ nigc=1                    poxedge=1                 pigcd=2.3
+ ntox=ntoxn_na             xrcrg1=12                 xrcrg2=1
+ cgso=cgon_na              cgdo=cgon_na              cgbo=0
+ cgdl=cgln_na              cgsl=cgln_na              clc=1e-007
+ cle=0.6                   cf=cfn_na                 ckappas=0.6
+ acde=1.2                  moin=12.6                 noff=1.686
+ voffcv=-0.05472           kt1=-0.4088               kt1l=0
+ kt2=-0.04464              ute=-2.266                ua1=2.039e-009
+ ub1=-6.915e-018           uc1=-6.421e-011           prt=0
+ at=179600                 jss=9.00e-07              jsws=1.50e-12
+ jswgs=9.0e-12             njs=1                     ijthsfwd=0.01
+ ijthsrev=0.01             bvs=10                    xjbvs=1
+ pbs=0.49                  cjs=cjn_na                mjs=0.313
+ pbsws=0.500               cjsws=cjswn_na            mjsws=0.01
+ pbswgs=0.479              cjswgs=cjswgn_na          mjswgs=0.414
+ tpb=2.6e-03               tcj=2.1e-03               tpbsw=5.0e-04
+ tcjsw=4.6e-04             tpbswg=2.4e-03            tcjswg=2.9e-03
+ xtis=3                    dmcg=1.025e-007           dmci=1.025e-007
+ dmdg=0                    dmcgt=0                   dwj=0
+ xgw=0                     xgl=0                     rshg=0.1
+ gbmin=1e-012              rbpb=50                   rbpd=50
+ rbps=50                   rbdb=50                   rbsb=50
+ ngcon=1                   saref=6.3e-07             sbref=6.3e-07
+ kvsat=0.18                wlod=8.0e-07              tku0=0.01
+ ku0=-7.16e-08             llodku0=1                 wlodku0=1
+ lku0=3.057e-07            wku0=9.0e-07              pku0=-1.0e-13
+ kvth0=3.5e-09             stk2=1.35e-09             steta0=0
+ lkvth0=-2.68e-11          wkvth0=2.5e-06            pkvth0=0
+ llodvth=1                 wlodvth=1                 lodk2=0.5
+ lodeta0=1                 fnoimod=1                 noia=4.446e+41
+ noib=1.15e+25             noic=0                    em=3.12e+07
+ ef=0.8                    tnoimod=0                 wpemod=0
+ ud=0                      minr=1e-3

     2: type=n
+ lmin=1.2000e-06-dxl_na    lmax=1.0000e-05-dxl_na    wmin=1.0000e-05-dxw_na
+ wmax=9.001e-04            version=4.5               binunit=2
+ paramchk=1                mobmod=0                  capmod=2
+ igcmod=1                  igbmod=1                  geomod=0
+ diomod=1                  rdsmod=0                  rbodymod=0
+ rgatemod=0                permod=1                  acnqsmod=0
+ trnqsmod=0                tnom=25                   toxe=toxn_na
+ toxm=toxn_na              dtox=4e-010               epsrox=3.9
+ wint=6e-009               lint=2.5e-009             ll=0
+ wl=0                      lln=1                     wln=1
+ lw=0                      ww=0                      lwn=1
+ wwn=1                     lwl=0                     wwl=0
+ llc=0                     wlc=0                     lwc=0
+ wwc=0                     lwlc=0                    wwlc=0
+ dlc=1.43e-008             dwc=0                     xpart=1
+ toxref=3e-009             dlcig=1.2e-009            xl=-5.5e-08+dxl_na
+ xw=1.5e-8+dxw_na          vth0=-0.1207+dvthn_na     lvth0=0+dlvthn_na
+ wvth0=0+dwvthn_na         pvth0=0+dpvthn_na         k1=0.1432
+ k2=-0.036066068           lk2=6.5671773e-010        k3=-2.45
+ k3b=1.2                   w0=-5e-008                dvt0=0.1
+ dvt1=0.1                  dvt2=0                    dvt0w=0
+ dvt1w=0                   dvt2w=0                   dsub=0.3
+ minv=0                    voffl=0                   dvtp0=0.0001
+ dvtp1=2                   lpe0=5.081e-007           lpeb=0
+ xj=1.5e-007               ngate=2e020               ndep=2.3687e017
+ nsd=1e020                 phin=0                    cdsc=0
+ cdscb=0                   cdscd=0                   cit=0
+ voff=-0.068168318         lvoff=-2.6011173e-009     nfactor=1.2
+ eta0=0.0021               etab=0                    u0=0.051364364
+ lu0=-1.2361745e-009       ua=4.1369477e-010         lua=-6.1821604e-016
+ ub=2.3915568e-018         lub=3.0260523e-025        uc=2.733e-011
+ vsat=111700               a0=8.8424318              la0=-5.2923723e-006
+ ags=1.098325              lags=1.2889695e-006       a1=0
+ a2=1                      b0=0                      b1=0
+ keta=0                    dwg=0                     dwb=0
+ pclm=1.34565              lpclm=-2.54961e-007       pdiblc1=0.001
+ pdiblc2=0.012202159       lpdiblc2=-9.4644614e-009  pdiblcb=0
+ drout=0.56                pvag=1.5                  delta=0.0075
+ pscbe1=5.545e008          pscbe2=1e-020             fprout=1000
+ pdits=0                   pditsd=0                  pditsl=0
+ rsh=10.5                  rdsw=135                  prwg=0
+ prwb=0                    wr=1                      alpha0=0
+ alpha1=0.03               beta0=8.7                 agidl=9e-008
+ bgidl=2.3e009             cgidl=0.5                 egidl=0.53
+ aigbacc=0.01157           bigbacc=0.002437          cigbacc=0.1416
+ nigbacc=4.05              aigbinv=0.35              bigbinv=0.03
+ cigbinv=0.006             eigbinv=1.1               nigbinv=1
+ aigc=0.0109               bigc=0.001801             cigc=0
+ aigsd=0.00744             bigsd=0.0002354           cigsd=0.001463
+ nigc=1                    poxedge=1                 pigcd=2.3
+ ntox=ntoxn_na             xrcrg1=12                 xrcrg2=1
+ cgso=cgon_na              cgdo=cgon_na              cgbo=0
+ cgdl=cgln_na              lcgdl=2.8972841e-017      cgsl=cgln_na
+ lcgsl=2.8972841e-017      clc=1e-007                cle=0.6
+ cf=cfn_na                 ckappas=0.6               acde=1.2
+ moin=12.6                 noff=1.686                voffcv=-0.05472
+ kt1=-0.39828091           lkt1=-1.0455976e-007      kt1l=0
+ kt2=-0.04961325           lkt2=4.9434105e-008       ute=-2.2630205
+ lute=-2.9616682e-008      ua1=2.1552023e-009        lua1=-1.1550506e-015
+ ub1=-7.3092068e-018       lub1=3.9184158e-024       uc1=-6.421e-011
+ prt=0                     at=180390.23              lat=-0.0078548591
+ jss=9.00e-07              jsws=1.50e-12             jswgs=9.0e-12
+ njs=1                     ijthsfwd=0.01             ijthsrev=0.01
+ bvs=10                    xjbvs=1                   pbs=0.49
+ cjs=cjn_na                mjs=0.313                 pbsws=0.500
+ cjsws=cjswn_na            mjsws=0.01                pbswgs=0.479
+ cjswgs=cjswgn_na          mjswgs=0.414              tpb=2.6e-03
+ tcj=2.1e-03               tpbsw=5.0e-04             tcjsw=4.6e-04
+ tpbswg=2.4e-03            tcjswg=2.9e-03            xtis=3
+ dmcg=1.025e-007           dmci=1.025e-007           dmdg=0
+ dmcgt=0                   dwj=0                     xgw=0
+ xgl=0                     rshg=0.1                  gbmin=1e-012
+ rbpb=50                   rbpd=50                   rbps=50
+ rbdb=50                   rbsb=50                   ngcon=1
+ saref=6.3e-07             sbref=6.3e-07             kvsat=0.18
+ wlod=8.0e-07              tku0=0.01                 ku0=-7.16e-08
+ llodku0=1                 wlodku0=1                 lku0=3.057e-07
+ wku0=9.0e-07              pku0=-1.0e-13             kvth0=3.5e-09
+ stk2=1.35e-09             steta0=0                  lkvth0=-2.68e-11
+ wkvth0=2.5e-06            pkvth0=0                  llodvth=1
+ wlodvth=1                 lodk2=0.5                 lodeta0=1
+ fnoimod=1                 noia=4.446e+41            noib=1.15e+25
+ noic=0                    em=3.12e+07               ef=0.8
+ tnoimod=0                 wpemod=0                  ud=0
+ minr=1e-3

     3: type=n
+ lmin=5.0000e-07-dxl_na    lmax=1.2000e-06-dxl_na    wmin=1.0000e-05-dxw_na
+ wmax=9.001e-04            version=4.5               binunit=2
+ paramchk=1                mobmod=0                  capmod=2
+ igcmod=1                  igbmod=1                  geomod=0
+ diomod=1                  rdsmod=0                  rbodymod=0
+ rgatemod=0                permod=1                  acnqsmod=0
+ trnqsmod=0                tnom=25                   toxe=toxn_na
+ toxm=toxn_na              dtox=4e-010               epsrox=3.9
+ wint=6e-009               lint=2.5e-009             ll=0
+ wl=0                      lln=1                     wln=1
+ lw=0                      ww=0                      lwn=1
+ wwn=1                     lwl=0                     wwl=0
+ llc=0                     wlc=0                     lwc=0
+ wwc=0                     lwlc=0                    wwlc=0
+ dlc=1.43e-008             dwc=0                     xpart=1
+ toxref=3e-009             dlcig=1.2e-009            xl=-5.5e-08+dxl_na
+ xw=1.5e-8+dxw_na          vth0=-0.1207+dvthn_na     lvth0=0+dlvthn_na
+ wvth0=0+dwvthn_na         pvth0=0+dpvthn_na         k1=0.12044571
+ lk1=2.5939886e-008        k2=-0.030140857           lk2=-6.0980229e-009
+ k3=-2.45                  k3b=1.2                   w0=-5e-008
+ dvt0=0.1                  dvt1=0.1                  dvt2=0
+ dvt0w=0                   dvt1w=0                   dvt2w=0
+ dsub=0.3                  minv=0                    voffl=0
+ dvtp0=0.0001              dvtp1=2                   lpe0=5.081e-007
+ lpeb=0                    xj=1.5e-007               ngate=2e020
+ ndep=2.3687e017           nsd=1e020                 phin=0
+ cdsc=0                    cdscb=0                   cdscd=0
+ cit=0                     voff=-0.046218571         lvoff=-2.7623829e-008
+ nfactor=1.2               eta0=0.00144              leta0=7.524e-010
+ etab=0                    u0=0.051468               lu0=-1.35432e-009
+ ua=3.6514286e-012         lua=-1.5076663e-016       ub=2.7311714e-018
+ lub=-8.4555429e-026       uc=2.733e-011             vsat=111700
+ a0=5.9788571              la0=-2.0278971e-006       ags=0.7242
+ lags=1.715472e-006        a1=0                      a2=1
+ b0=0                      b1=0                      keta=0
+ dwg=0                     dwb=0                     pclm=0.75051429
+ lpclm=4.2349371e-007      pdiblc1=0.001             pdiblc2=0.0033594286
+ lpdiblc2=6.1625143e-010   pdiblcb=0                 drout=0.56
+ pvag=1.5                  delta=0.0075              pscbe1=5.545e008
+ pscbe2=1e-020             fprout=1000               pdits=0
+ pditsd=0                  pditsl=0                  rsh=10.5
+ rdsw=135                  prwg=0                    prwb=0
+ wr=1                      alpha0=0                  alpha1=0.03
+ beta0=8.7                 agidl=9e-008              bgidl=2.3e009
+ cgidl=0.5                 egidl=0.53                aigbacc=0.01157
+ bigbacc=0.002437          cigbacc=0.1416            nigbacc=4.05
+ aigbinv=0.35              bigbinv=0.03              cigbinv=0.006
+ eigbinv=1.1               nigbinv=1                 aigc=0.0109
+ bigc=0.001801             cigc=0                    aigsd=0.00744
+ bigsd=0.0002354           cigsd=0.001463            nigc=1
+ poxedge=1                 pigcd=2.3                 ntox=ntoxn_na
+ xrcrg1=12                 xrcrg2=1                  cgso=cgon_na
+ cgdo=cgon_na              cgbo=0                    cgdl=cgln_na
+ lcgdl=-1.6122857e-017     cgsl=cgln_na              lcgsl=-1.6122857e-017
+ clc=1e-007                cle=0.6                   cf=cfn_na
+ ckappas=0.6               acde=1.2                  moin=12.6
+ noff=1.686                voffcv=-0.05472           kt1=-0.50508571
+ lkt1=1.7197714e-008       kt1l=0                    kt2=0.017880857
+ lkt2=-2.7509177e-008      ute=-2.4172286            lute=1.4618057e-007
+ ua1=1.3248514e-009        lua1=-2.0845063e-016      ub1=-4.5678286e-018
+ lub1=7.9324457e-025       uc1=-6.421e-011           prt=0
+ at=217122.86              lat=-0.049730057          jss=9.00e-07
+ jsws=1.50e-12             jswgs=9.0e-12             njs=1
+ ijthsfwd=0.01             ijthsrev=0.01             bvs=10
+ xjbvs=1                   pbs=0.49                  cjs=cjn_na
+ mjs=0.313                 pbsws=0.500               cjsws=cjswn_na
+ mjsws=0.01                pbswgs=0.479              cjswgs=cjswgn_na
+ mjswgs=0.414              tpb=2.6e-03               tcj=2.1e-03
+ tpbsw=5.0e-04             tcjsw=4.6e-04             tpbswg=2.4e-03
+ tcjswg=2.9e-03            xtis=3                    dmcg=1.025e-007
+ dmci=1.025e-007           dmdg=0                    dmcgt=0
+ dwj=0                     xgw=0                     xgl=0
+ rshg=0.1                  gbmin=1e-012              rbpb=50
+ rbpd=50                   rbps=50                   rbdb=50
+ rbsb=50                   ngcon=1                   saref=6.3e-07
+ sbref=6.3e-07             kvsat=0.18                wlod=8.0e-07
+ tku0=0.01                 ku0=-7.16e-08             llodku0=1
+ wlodku0=1                 lku0=3.057e-07            wku0=9.0e-07
+ pku0=-1.0e-13             kvth0=3.5e-09             stk2=1.35e-09
+ steta0=0                  lkvth0=-2.68e-11          wkvth0=2.5e-06
+ pkvth0=0                  llodvth=1                 wlodvth=1
+ lodk2=0.5                 lodeta0=1                 fnoimod=1
+ noia=4.446e+41            noib=1.15e+25             noic=0
+ em=3.12e+07               ef=0.8                    tnoimod=0
+ wpemod=0                  ud=0                      minr=1e-3

     4: type=n
+ lmin=3.0000e-07-dxl_na    lmax=5.0000e-07-dxl_na    wmin=1.0000e-05-dxw_na
+ wmax=9.001e-04            version=4.5               binunit=2
+ paramchk=1                mobmod=0                  capmod=2
+ igcmod=1                  igbmod=1                  geomod=0
+ diomod=1                  rdsmod=0                  rbodymod=0
+ rgatemod=0                permod=1                  acnqsmod=0
+ trnqsmod=0                tnom=25                   toxe=toxn_na
+ toxm=toxn_na              dtox=4e-010               epsrox=3.9
+ wint=6e-009               lint=2.5e-009             ll=0
+ wl=0                      lln=1                     wln=1
+ lw=0                      ww=0                      lwn=1
+ wwn=1                     lwl=0                     wwl=0
+ llc=0                     wlc=0                     lwc=0
+ wwc=0                     lwlc=0                    wwlc=0
+ dlc=1.43e-008             dwc=0                     xpart=1
+ toxref=3e-009             dlcig=1.2e-009            xl=-5.5e-08+dxl_na
+ xw=1.5e-8+dxw_na          vth0=-0.1111+dvthn_na     lvth0=-4.224e-009+dlvthn_na
+ wvth0=0+dwvthn_na         pvth0=0+dpvthn_na         k1=0.19668
+ lk1=-7.6032e-009          k2=-0.0596                lk2=6.864e-009
+ k3=-2.45                  k3b=1.2                   w0=-5e-008
+ dvt0=0.1                  dvt1=0.1                  dvt2=0
+ dvt0w=0                   dvt1w=0                   dvt2w=0
+ dsub=0.3                  minv=0                    voffl=0
+ dvtp0=0.0001              dvtp1=2                   lpe0=5.081e-007
+ lpeb=0                    xj=1.5e-007               ngate=2e020
+ ndep=2.3687e017           nsd=1e020                 phin=0
+ cdsc=0                    cdscb=0                   cdscd=0
+ cit=0                     voff=-0.0856              lvoff=-1.0296e-008
+ nfactor=1.2               eta0=0.00315              etab=0
+ u0=0.05187                lu0=-1.5312e-009          ua=-3.39e-010
+ ub=2.6614e-018            lub=-5.3856e-026          uc=2.733e-011
+ vsat=111700               a0=1.814                  la0=-1.9536e-007
+ ags=6.0306                lags=-6.19344e-007        a1=0
+ a2=1                      b0=0                      b1=0
+ keta=0                    dwg=0                     dwb=0
+ pclm=2.6046               lpclm=-3.92304e-007       pdiblc1=0.001
+ pdiblc2=0.007472          lpdiblc2=-1.19328e-009    pdiblcb=0
+ drout=0.56                pvag=1.5                  delta=0.0075
+ pscbe1=5.545e008          pscbe2=1e-020             fprout=1000
+ pdits=0                   pditsd=0                  pditsl=0
+ rsh=10.5                  rdsw=135                  prwg=0
+ prwb=0                    wr=1                      alpha0=0
+ agidl=9e-008              bgidl=2.3e009             cgidl=0.5
+ egidl=0.53                aigbacc=0.01157           bigbacc=0.002437
+ cigbacc=0.1416            nigbacc=4.05              aigbinv=0.35
+ bigbinv=0.03              cigbinv=0.006             eigbinv=1.1
+ nigbinv=1                 aigc=0.0109               bigc=0.001801
+ cigc=0                    aigsd=0.00744             bigsd=0.0002354
+ cigsd=0.001463            nigc=1                    poxedge=1
+ pigcd=2.3                 ntox=ntoxn_na             xrcrg1=12
+ xrcrg2=1                  cgso=cgon_na              cgdo=cgon_na
+ cgbo=0                    cgdl=cgln_na              cgsl=cgln_na
+ clc=1e-007                cle=0.6                   cf=cfn_na
+ ckappas=0.6               acde=1.2                  moin=12.6
+ noff=1.686                voffcv=-0.05472           kt1=-0.48832
+ lkt1=9.8208e-009          kt1l=0                    kt2=-0.04464
+ ute=-2.235                lute=6.6e-008             ua1=8.511e-010
+ ub1=-2.765e-018           uc1=-6.421e-011           prt=0
+ at=141576                 lat=-0.01648944           jss=9.00e-07
+ jsws=1.50e-12             jswgs=9.0e-12             njs=1
+ ijthsfwd=0.01             ijthsrev=0.01             bvs=10
+ xjbvs=1                   pbs=0.49                  cjs=cjn_na
+ mjs=0.313                 pbsws=0.500               cjsws=cjswn_na
+ mjsws=0.01                pbswgs=0.479              cjswgs=cjswgn_na
+ mjswgs=0.414              tpb=2.6e-03               tcj=2.1e-03
+ tpbsw=5.0e-04             tcjsw=4.6e-04             tpbswg=2.4e-03
+ tcjswg=2.9e-03            xtis=3                    dmcg=1.025e-007
+ dmci=1.025e-007           dmdg=0                    dmcgt=0
+ dwj=0                     xgw=0                     xgl=0
+ rshg=0.1                  gbmin=1e-012              rbpb=50
+ rbpd=50                   rbps=50                   rbdb=50
+ rbsb=50                   ngcon=1                   alpha1=0.03
+ beta0=8.7                 saref=6.3e-07             sbref=6.3e-07
+ kvsat=0.18                wlod=8.0e-07              tku0=0.01
+ ku0=-7.16e-08             llodku0=1                 wlodku0=1
+ lku0=3.057e-07            wku0=9.0e-07              pku0=-1.0e-13
+ kvth0=3.5e-09             stk2=1.35e-09             steta0=0
+ lkvth0=-2.68e-11          wkvth0=2.5e-06            pkvth0=0
+ llodvth=1                 wlodvth=1                 lodk2=0.5
+ lodeta0=1                 fnoimod=1                 noia=4.446e+41
+ noib=1.15e+25             noic=0                    em=3.12e+07
+ ef=0.8                    tnoimod=0                 wpemod=0
+ ud=0                      minr=1e-3

     5: type=n
+ lmin=2.0e-07              lmax=3.0000e-07-dxl_na    wmin=1.0000e-05-dxw_na
+ wmax=9.001e-04            version=4.5               binunit=2
+ paramchk=1                mobmod=0                  capmod=2
+ igcmod=1                  igbmod=1                  geomod=0
+ diomod=1                  rdsmod=0                  rbodymod=0
+ rgatemod=0                permod=1                  acnqsmod=0
+ trnqsmod=0                tnom=25                   toxe=toxn_na
+ toxm=toxn_na              dtox=4e-010               epsrox=3.9
+ wint=6e-009               lint=2.5e-009             ll=0
+ wl=0                      lln=1                     wln=1
+ lw=0                      ww=0                      lwn=1
+ wwn=1                     lwl=0                     wwl=0
+ llc=0                     wlc=0                     lwc=0
+ wwc=0                     lwlc=0                    wwlc=0
+ dlc=1.43e-008             dwc=0                     xpart=1
+ toxref=3e-009             dlcig=1.2e-009            xl=-5.5e-08+dxl_na
+ xw=1.5e-8+dxw_na          vth0=-0.1399+dvthn_na     lvth0=2.688e-009+dlvthn_na
+ wvth0=0+dwvthn_na         pvth0=0+dpvthn_na         k1=0.19356
+ lk1=-6.8544e-009          k2=-0.07874               lk2=1.14576e-008
+ k3=-2.45                  k3b=1.2                   w0=-5e-008
+ dvt0=0.1                  dvt1=0.1                  dvt2=0
+ dvt0w=0                   dvt1w=0                   dvt2w=0
+ dsub=0.3                  minv=0                    voffl=0
+ dvtp0=0.0001              dvtp1=2                   lpe0=5.081e-007
+ lpeb=0                    xj=1.5e-007               ngate=2e020
+ ndep=2.3687e017           nsd=1e020                 phin=0
+ cdsc=0                    cdscb=0                   cdscd=0
+ cit=0                     voff=-0.1054              lvoff=-5.544e-009
+ nfactor=1.2               eta0=0.00462              leta0=-3.528e-010
+ etab=0                    u0=0.054604               lu0=-2.18736e-009
+ ua=-6.3356e-010           lua=7.06944e-017          ub=3.3694e-018
+ lub=-2.23776e-025         uc=2.733e-011             vsat=111700
+ a0=0.6808                 la0=7.6608e-008           ags=6.9073
+ lags=-8.29752e-007        a1=0                      a2=1
+ b0=0                      b1=0                      keta=0
+ dwg=0                     dwb=0                     pclm=1.31776
+ lpclm=-8.34624e-008       pdiblc1=0.001             pdiblc2=-0.005809
+ lpdiblc2=1.99416e-009     pdiblcb=0                 drout=0.56
+ pvag=1.5                  delta=0.0075              pscbe1=5.545e008
+ pscbe2=1e-020             fprout=1000               pdits=0
+ pditsd=0                  pditsl=0                  rsh=10.5
+ rdsw=135                  prwg=0                    prwb=0
+ wr=1                      alpha0=0                  agidl=9e-008
+ bgidl=2.3e009             cgidl=0.5                 egidl=0.53
+ aigbacc=0.01157           bigbacc=0.002437          cigbacc=0.1416
+ nigbacc=4.05              aigbinv=0.35              bigbinv=0.03
+ cigbinv=0.006             eigbinv=1.1               nigbinv=1
+ aigc=0.0109               bigc=0.001801             cigc=0
+ aigsd=0.00744             bigsd=0.0002354           cigsd=0.001463
+ nigc=1                    poxedge=1                 pigcd=2.3
+ ntox=ntoxn_na             xrcrg1=12                 xrcrg2=1
+ cgso=cgon_na              cgdo=cgon_na              cgbo=0
+ cgdl=cgln_na              cgsl=cgln_na              clc=1e-007
+ cle=0.6                   cf=cfn_na                 ckappas=0.6
+ acde=1.2                  moin=12.6                 noff=1.686
+ voffcv=-0.05472           kt1=-0.4383               lkt1=-2.184e-009
+ kt1l=0                    kt2=-0.04464              ute=-2.0692
+ lute=2.6208e-008          ua1=9.3132e-010           lua1=-1.92528e-017
+ ub1=-3.0534e-018          lub1=6.9216e-026          uc1=-6.421e-011
+ prt=0                     at=96768                  lat=-0.00573552
+ jss=9.00e-07              jsws=1.50e-12             jswgs=9.0e-12
+ njs=1                     ijthsfwd=0.01             ijthsrev=0.01
+ bvs=10                    xjbvs=1                   pbs=0.49
+ cjs=cjn_na                mjs=0.313                 pbsws=0.500
+ cjsws=cjswn_na            mjsws=0.01                pbswgs=0.479
+ cjswgs=cjswgn_na          mjswgs=0.414              tpb=2.6e-03
+ tcj=2.1e-03               tpbsw=5.0e-04             tcjsw=4.6e-04
+ tpbswg=2.4e-03            tcjswg=2.9e-03            xtis=3
+ dmcg=1.025e-007           dmci=1.025e-007           dmdg=0
+ dmcgt=0                   dwj=0                     xgw=0
+ xgl=0                     rshg=0.1                  gbmin=1e-012
+ rbpb=50                   rbpd=50                   rbps=50
+ rbdb=50                   rbsb=50                   ngcon=1
+ alpha1=0.03               beta0=8.7                 saref=6.3e-07
+ sbref=6.3e-07             kvsat=0.18                wlod=8.0e-07
+ tku0=0.01                 ku0=-7.16e-08             llodku0=1
+ wlodku0=1                 lku0=3.057e-07            wku0=9.0e-07
+ pku0=-1.0e-13             kvth0=3.5e-09             stk2=1.35e-09
+ steta0=0                  lkvth0=-2.68e-11          wkvth0=2.5e-06
+ pkvth0=0                  llodvth=1                 wlodvth=1
+ lodk2=0.5                 lodeta0=1                 fnoimod=1
+ noia=4.446e+41            noib=1.15e+25             noic=0
+ em=3.12e+07               ef=0.8                    tnoimod=0
+ wpemod=0                  ud=0                      minr=1e-3

     6: type=n
+ lmin=1.0000e-05-dxl_na    lmax=2.001e-05            wmin=1.0000e-06-dxw_na
+ wmax=1.0000e-05-dxw_na    version=4.5               binunit=2
+ paramchk=1                mobmod=0                  capmod=2
+ igcmod=1                  igbmod=1                  geomod=0
+ diomod=1                  rdsmod=0                  rbodymod=0
+ rgatemod=0                permod=1                  acnqsmod=0
+ trnqsmod=0                tnom=25                   toxe=toxn_na
+ toxm=toxn_na              dtox=4e-010               epsrox=3.9
+ wint=6e-009               lint=2.5e-009             ll=0
+ wl=0                      lln=1                     wln=1
+ lw=0                      ww=0                      lwn=1
+ wwn=1                     lwl=0                     wwl=0
+ llc=0                     wlc=0                     lwc=0
+ wwc=0                     lwlc=0                    wwlc=0
+ dlc=1.43e-008             dwc=0                     xpart=1
+ toxref=3e-009             dlcig=1.2e-009            xl=-5.5e-08+dxl_na
+ xw=1.5e-8+dxw_na          vth0=-0.1207+dvthn_na     lvth0=0+dlvthn_na
+ wvth0=0+dwvthn_na         pvth0=0+dpvthn_na         k1=0.1432
+ k2=-0.037531247           wk2=1.531706e-008         k3=-2.45
+ k3b=1.2                   w0=-5e-008                dvt0=0.1
+ dvt1=0.1                  dvt2=0                    dvt0w=0
+ dvt1w=0                   dvt2w=0                   dsub=0.3
+ minv=0                    voffl=0                   dvtp0=0.0001
+ dvtp1=2                   lpe0=5.081e-007           lpeb=0
+ xj=1.5e-007               ngate=2e020               ndep=2.3687e017
+ nsd=1e020                 phin=0                    cdsc=0
+ cdscb=0                   cdscd=0                   cit=0
+ voff=-0.068716412         wvoff=2.8649815e-009      nfactor=1.2
+ eta0=0.0021               etab=0                    u0=0.052118182
+ wu0=-8.7844568e-009       ua=3.7674217e-010         wua=-2.5249739e-016
+ ub=2.4284638e-018         wub=-6.4657169e-026       uc=2.733e-011
+ vsat=111700               a0=8.3803214              wa0=-7.0342541e-007
+ ags=1.2418191             wags=-1.3823257e-007      a1=0
+ a2=1                      b0=0                      b1=0
+ keta=0                    dwg=0                     dwb=0
+ pclm=1.32                 pdiblc1=0.001             pdiblc2=0.0106482
+ wpdiblc2=6.0198054e-009   pdiblcb=0                 drout=0.56
+ pvag=1.5                  delta=0.0075              pscbe1=5.545e008
+ pscbe2=1e-020             fprout=1000               pdits=0
+ pditsd=0                  pditsl=0                  rsh=10.5
+ rdsw=135                  prwg=0                    prwb=0
+ wr=1                      alpha0=0                  alpha1=0.03
+ beta0=8.7                 agidl=9e-008              bgidl=2.3e009
+ cgidl=0.5                 egidl=0.53                aigbacc=0.01157
+ bigbacc=0.002437          cigbacc=0.1416            nigbacc=4.05
+ aigbinv=0.35              bigbinv=0.03              cigbinv=0.006
+ eigbinv=1.1               nigbinv=1                 aigc=0.0109
+ bigc=0.001801             cigc=0                    aigsd=0.00744
+ bigsd=0.0002354           cigsd=0.001463            nigc=1
+ poxedge=1                 pigcd=2.3                 ntox=ntoxn_na
+ xrcrg1=12                 xrcrg2=1                  cgso=cgon_na
+ cgdo=cgon_na              cgbo=0                    cgdl=cgln_na
+ cgsl=cgln_na              clc=1e-007                cle=0.6
+ cf=cfn_na                 ckappas=0.6               acde=1.2
+ moin=12.6                 noff=1.686                voffcv=-0.05472
+ kt1=-0.40424192           wkt1=-4.5594452e-008      kt1l=0
+ kt2=-0.04464              ute=-2.2735782            wute=7.5804957e-008
+ ua1=2.0776712e-009        wua1=-3.8682824e-016      ub1=-6.915e-018
+ uc1=-6.421e-011           prt=0                     at=179600
+ jss=9.00e-07              jsws=1.50e-12             jswgs=9.0e-12
+ njs=1                     ijthsfwd=0.01             ijthsrev=0.01
+ bvs=10                    xjbvs=1                   pbs=0.49
+ cjs=cjn_na                mjs=0.313                 pbsws=0.500
+ cjsws=cjswn_na            mjsws=0.01                pbswgs=0.479
+ cjswgs=cjswgn_na          mjswgs=0.414              tpb=2.6e-03
+ tcj=2.1e-03               tpbsw=5.0e-04             tcjsw=4.6e-04
+ tpbswg=2.4e-03            tcjswg=2.9e-03            xtis=3
+ dmcg=1.025e-007           dmci=1.025e-007           dmdg=0
+ dmcgt=0                   dwj=0                     xgw=0
+ xgl=0                     rshg=0.1                  gbmin=1e-012
+ rbpb=50                   rbpd=50                   rbps=50
+ rbdb=50                   rbsb=50                   ngcon=1
+ saref=6.3e-07             sbref=6.3e-07             kvsat=0.18
+ wlod=8.0e-07              tku0=0.01                 ku0=-7.16e-08
+ llodku0=1                 wlodku0=1                 lku0=3.057e-07
+ wku0=9.0e-07              pku0=-1.0e-13             kvth0=3.5e-09
+ stk2=1.35e-09             steta0=0                  lkvth0=-2.68e-11
+ wkvth0=2.5e-06            pkvth0=0                  llodvth=1
+ wlodvth=1                 lodk2=0.5                 lodeta0=1
+ fnoimod=1                 noia=4.446e+41            noib=1.15e+25
+ noic=0                    em=3.12e+07               ef=0.8
+ tnoimod=0                 wpemod=0                  ud=0
+ minr=1e-3

     7: type=n
+ lmin=1.2000e-06-dxl_na    lmax=1.0000e-05-dxl_na    wmin=1.0000e-06-dxw_na
+ wmax=1.0000e-05-dxw_na    version=4.5               binunit=2
+ paramchk=1                mobmod=0                  capmod=2
+ igcmod=1                  igbmod=1                  geomod=0
+ diomod=1                  rdsmod=0                  rbodymod=0
+ rgatemod=0                permod=1                  acnqsmod=0
+ trnqsmod=0                tnom=25                   toxe=toxn_na
+ toxm=toxn_na              dtox=4e-010               epsrox=3.9
+ wint=6e-009               lint=2.5e-009             ll=0
+ wl=0                      lln=1                     wln=1
+ lw=0                      ww=0                      lwn=1
+ wwn=1                     lwl=0                     wwl=0
+ llc=0                     wlc=0                     lwc=0
+ wwc=0                     lwlc=0                    wwlc=0
+ dlc=1.43e-008             dwc=0                     xpart=1
+ toxref=3e-009             dlcig=1.2e-009            xl=-5.5e-08+dxl_na
+ xw=1.5e-8+dxw_na          vth0=-0.12068556+dvthn_na lvth0=-1.4350498e-010+dlvthn_na
+ wvth0=-1.4441452e-010+dwvthn_na                     pvth0=1.4354804e-015+dpvthn_na
+ k1=0.14392186             lk1=-7.1752492e-009       wk1=-7.2207262e-009
+ pk1=7.1774018e-014        k2=-0.038002276           lk2=4.6820326e-009
+ wk2=1.9367888e-008        pk2=-4.0265224e-014       k3=-2.45
+ k3b=1.2                   w0=-5e-008                dvt0=0.1
+ dvt1=0.1                  dvt2=0                    dvt0w=0
+ dvt1w=0                   dvt2w=0                   dsub=0.3
+ minv=0                    voffl=0                   dvtp0=0.0001
+ dvtp1=2                   lpe0=5.081e-007           lpeb=0
+ xj=1.5e-007               ngate=2e020               ndep=2.3687e017
+ nsd=1e020                 phin=0                    cdsc=0
+ cdscb=0                   cdscd=0                   cit=0
+ voff=-0.068573259         lvoff=-1.4229413e-009     wvoff=4.0506247e-009
+ pvoff=-1.1785294e-014     nfactor=1.2               eta0=0.0021
+ etab=0                    u0=0.052270554            lu0=-1.5145742e-009
+ wu0=-9.0646209e-009       pu0=2.7848319e-015        ua=4.4220695e-010
+ lua=-6.5071992e-016       wua=-2.8520728e-016       pua=3.251363e-022
+ ub=2.3930109e-018         lub=3.5240146e-025        wub=-1.4545329e-026
+ pub=-4.9811169e-031       uc=2.733e-011             vsat=111700
+ a0=8.9054914              la0=-5.2201893e-006       wa0=-6.307849e-007
+ pa0=-7.2204662e-013       ags=1.1152192             lags=1.2584029e-006
+ wags=-1.6899286e-007      pags=3.0575732e-013       a1=0
+ a2=1                      b0=0                      b1=0
+ keta=0                    dwg=0                     dwb=0
+ pclm=1.3485086            lpclm=-2.8337499e-007     wpclm=-2.8594076e-008
+ ppclm=2.8422511e-013      pdiblc1=0.001             pdiblc2=0.011574372
+ lpdiblc2=-9.2061524e-009  wpdiblc2=6.2797515e-009   ppdiblc2=-2.5838647e-015
+ pdiblcb=0                 drout=0.56                pvag=1.5
+ delta=0.0075              pscbe1=5.545e008          pscbe2=1e-020
+ fprout=1000               pdits=0                   pditsd=0
+ pditsl=0                  rsh=10.5                  rdsw=135
+ prwg=0                    prwb=0                    wr=1
+ alpha0=0                  alpha1=0.03               beta0=8.7
+ agidl=9e-008              bgidl=2.3e009             cgidl=0.5
+ egidl=0.53                aigbacc=0.01157           bigbacc=0.002437
+ cigbacc=0.1416            nigbacc=4.05              aigbinv=0.35
+ bigbinv=0.03              cigbinv=0.006             eigbinv=1.1
+ nigbinv=1                 aigc=0.0109               bigc=0.001801
+ cigc=0                    aigsd=0.00744             bigsd=0.0002354
+ cigsd=0.001463            nigc=1                    poxedge=1
+ pigcd=2.3                 ntox=ntoxn_na             xrcrg1=12
+ xrcrg2=1                  cgso=cgon_na              cgdo=cgon_na
+ cgbo=0                    cgdl=cgln_na              lcgdl=3.2201703e-017
+ wcgdl=3.2493268e-018      pcgdl=-3.2298308e-023     cgsl=cgln_na
+ lcgsl=3.2201703e-017      wcgsl=3.2493268e-018      pcgsl=-3.2298308e-023
+ clc=1e-007                cle=0.6                   cf=cfn_na
+ ckappas=0.6               acde=1.2                  moin=12.6
+ noff=1.686                voffcv=-0.05472           kt1=-0.39284939
+ lkt1=-1.1324182e-007      wkt1=-5.4331531e-008      pkt1=8.6846562e-014
+ kt1l=0                    kt2=-0.049795446          lkt2=5.1245138e-008
+ wkt2=1.8225113e-009       pkt2=-1.8115762e-014      ute=-2.2702522
+ lute=-3.3060801e-008      wute=7.2339008e-008       pute=3.4451529e-014
+ ua1=2.1919591e-009        lua1=-1.1360218e-015      wua1=-3.6767887e-016
+ pua1=-1.903447e-022       ub1=-7.3002558e-018       lub1=3.8294427e-024
+ wub1=-8.9537005e-026      pub1=8.8999783e-031       uc1=-6.421e-011
+ prt=0                     at=180390.23              lat=-0.0078548591
+ jss=9.00e-07              jsws=1.50e-12             jswgs=9.0e-12
+ njs=1                     ijthsfwd=0.01             ijthsrev=0.01
+ bvs=10                    xjbvs=1                   pbs=0.49
+ cjs=cjn_na                mjs=0.313                 pbsws=0.500
+ cjsws=cjswn_na            mjsws=0.01                pbswgs=0.479
+ cjswgs=cjswgn_na          mjswgs=0.414              tpb=2.6e-03
+ tcj=2.1e-03               tpbsw=5.0e-04             tcjsw=4.6e-04
+ tpbswg=2.4e-03            tcjswg=2.9e-03            xtis=3
+ dmcg=1.025e-007           dmci=1.025e-007           dmdg=0
+ dmcgt=0                   dwj=0                     xgw=0
+ xgl=0                     rshg=0.1                  gbmin=1e-012
+ rbpb=50                   rbpd=50                   rbps=50
+ rbdb=50                   rbsb=50                   ngcon=1
+ saref=6.3e-07             sbref=6.3e-07             kvsat=0.18
+ wlod=8.0e-07              tku0=0.01                 ku0=-7.16e-08
+ llodku0=1                 wlodku0=1                 lku0=3.057e-07
+ wku0=9.0e-07              pku0=-1.0e-13             kvth0=3.5e-09
+ stk2=1.35e-09             steta0=0                  lkvth0=-2.68e-11
+ wkvth0=2.5e-06            pkvth0=0                  llodvth=1
+ wlodvth=1                 lodk2=0.5                 lodeta0=1
+ fnoimod=1                 noia=4.446e+41            noib=1.15e+25
+ noic=0                    em=3.12e+07               ef=0.8
+ tnoimod=0                 wpemod=0                  ud=0
+ minr=1e-3

     8: type=n
+ lmin=5.0000e-07-dxl_na    lmax=1.2000e-06-dxl_na    wmin=1.0000e-06-dxw_na
+ wmax=1.0000e-05-dxw_na    version=4.5               binunit=2
+ paramchk=1                mobmod=0                  capmod=2
+ igcmod=1                  igbmod=1                  geomod=0
+ diomod=1                  rdsmod=0                  rbodymod=0
+ rgatemod=0                permod=1                  acnqsmod=0
+ trnqsmod=0                tnom=25                   toxe=toxn_na
+ toxm=toxn_na              dtox=4e-010               epsrox=3.9
+ wint=6e-009               lint=2.5e-009             ll=0
+ wl=0                      lln=1                     wln=1
+ lw=0                      ww=0                      lwn=1
+ wwn=1                     lwl=0                     wwl=0
+ llc=0                     wlc=0                     lwc=0
+ wwc=0                     lwlc=0                    wwlc=0
+ dlc=1.43e-008             dwc=0                     xpart=1
+ toxref=3e-009             dlcig=1.2e-009            xl=-5.5e-08+dxl_na
+ xw=1.5e-8+dxw_na          vth0=-0.12060129+dvthn_na lvth0=-2.3957371e-010+dlvthn_na
+ wvth0=-9.8737549e-010+dwvthn_na                     pvth0=2.3964559e-015+dpvthn_na
+ k1=0.11233765             lk1=2.8830742e-008        wk1=8.1104934e-008
+ pk1=-2.8917234e-014       k2=-0.027613711           lk2=-7.1609316e-009
+ wk2=-2.5279042e-008       pk2=1.0632276e-014        k3=-2.45
+ k3b=1.2                   w0=-5e-008                dvt0=0.1
+ dvt1=0.1                  dvt2=0                    dvt0w=0
+ dvt1w=0                   dvt2w=0                   dsub=0.3
+ minv=0                    voffl=0                   dvtp0=0.0001
+ dvtp1=2                   lpe0=5.081e-007           lpeb=0
+ xj=1.5e-007               ngate=2e020               ndep=2.3687e017
+ nsd=1e020                 phin=0                    cdsc=0
+ cdscb=0                   cdscd=0                   cit=0
+ voff=-0.045930472         lvoff=-2.7235719e-008     wvoff=-2.8818624e-009
+ pvoff=-3.8822585e-015     nfactor=1.2               eta0=0.0013723309
+ leta0=8.2954274e-010      weta0=6.7689367e-010      peta0=-7.7165879e-016
+ etab=0                    u0=0.052326122            lu0=-1.5779221e-009
+ wu0=-8.5837966e-009       pu0=2.2366921e-015        ua=1.8390116e-011
+ lua=-1.6756873e-016       wua=-1.4743109e-016       pua=1.6807144e-022
+ ub=2.7632069e-018         lub=-6.9622e-026          wub=-3.2045112e-025
+ pub=-1.4937908e-031       uc=2.733e-011             vsat=111700
+ a0=6.1757062              la0=-2.1082342e-006       wa0=-1.9690815e-006
+ pa0=8.0361153e-013        ags=0.69564793            lags=1.7367142e-006
+ wags=2.8560632e-007       pags=-2.1248575e-013      a1=0
+ a2=1                      b0=0                      b1=0
+ keta=0                    dwg=0                     dwb=0
+ pclm=0.72235387           lpclm=4.3044135e-007      wpclm=2.8168867e-007
+ ppclm=-6.949722e-014      pdiblc1=0.001             pdiblc2=0.0027824011
+ lpdiblc2=8.1669477e-010   wpdiblc2=5.772006e-009    ppdiblc2=-2.0050347e-015
+ pdiblcb=0                 drout=0.56                pvag=1.5
+ delta=0.0075              pscbe1=5.545e008          pscbe2=1e-020
+ fprout=1000               pdits=0                   pditsd=0
+ pditsl=0                  rsh=10.5                  rdsw=135
+ prwg=0                    prwb=0                    wr=1
+ alpha0=0                  alpha1=0.03               beta0=8.7
+ agidl=9e-008              bgidl=2.3e009             cgidl=0.5
+ egidl=0.53                aigbacc=0.01157           bigbacc=0.002437
+ cigbacc=0.1416            nigbacc=4.05              aigbinv=0.35
+ bigbinv=0.03              cigbinv=0.006             eigbinv=1.1
+ nigbinv=1                 aigc=0.0109               bigc=0.001801
+ cigc=0                    aigsd=0.00744             bigsd=0.0002354
+ cigsd=0.001463            nigc=1                    poxedge=1
+ pigcd=2.3                 ntox=ntoxn_na             xrcrg1=12
+ xrcrg2=1                  cgso=cgon_na              cgdo=cgon_na
+ cgbo=0                    cgdl=cgln_na              lcgdl=-1.791966e-017
+ wcgdl=-4.084868e-017      pcgdl=1.7973419e-023      cgsl=cgln_na
+ lcgsl=-1.791966e-017      wcgsl=-4.084868e-017      pcgsl=1.7973419e-023
+ clc=1e-007                cle=0.6                   cf=cfn_na
+ ckappas=0.6               acde=1.2                  moin=12.6
+ noff=1.686                voffcv=-0.05472           kt1=-0.50864302
+ lkt1=1.8762929e-008       wkt1=3.5583739e-008       pkt1=-1.5656845e-014
+ kt1l=0                    kt2=0.020171327           lkt2=-2.8516984e-008
+ wkt2=-2.291157e-008       pkt2=1.0081091e-014       ute=-2.4339261
+ lute=1.535275e-007        wute=1.6702571e-007       pute=-7.3491313e-014
+ ua1=1.3999739e-009        lua1=-2.3315866e-016      wua1=-7.5145008e-016
+ pua1=2.4715448e-022       ub1=-4.6803556e-018       lub1=8.4275647e-025
+ wub1=1.1256081e-024       pub1=-4.9526755e-031      uc1=-6.421e-011
+ prt=0                     at=216466.48              lat=-0.048981789
+ wat=0.0065657285          pat=-7.4849305e-009       jss=9.00e-07
+ jsws=1.50e-12             jswgs=9.0e-12             njs=1
+ ijthsfwd=0.01             ijthsrev=0.01             bvs=10
+ xjbvs=1                   pbs=0.49                  cjs=cjn_na
+ mjs=0.313                 pbsws=0.500               cjsws=cjswn_na
+ mjsws=0.01                pbswgs=0.479              cjswgs=cjswgn_na
+ mjswgs=0.414              tpb=2.6e-03               tcj=2.1e-03
+ tpbsw=5.0e-04             tcjsw=4.6e-04             tpbswg=2.4e-03
+ tcjswg=2.9e-03            xtis=3                    dmcg=1.025e-007
+ dmci=1.025e-007           dmdg=0                    dmcgt=0
+ dwj=0                     xgw=0                     xgl=0
+ rshg=0.1                  gbmin=1e-012              rbpb=50
+ rbpd=50                   rbps=50                   rbdb=50
+ rbsb=50                   ngcon=1                   saref=6.3e-07
+ sbref=6.3e-07             kvsat=0.18                wlod=8.0e-07
+ tku0=0.01                 ku0=-7.16e-08             llodku0=1
+ wlodku0=1                 lku0=3.057e-07            wku0=9.0e-07
+ pku0=-1.0e-13             kvth0=3.5e-09             stk2=1.35e-09
+ steta0=0                  lkvth0=-2.68e-11          wkvth0=2.5e-06
+ pkvth0=0                  llodvth=1                 wlodvth=1
+ lodk2=0.5                 lodeta0=1                 fnoimod=1
+ noia=4.446e+41            noib=1.15e+25             noic=0
+ em=3.12e+07               ef=0.8                    tnoimod=0
+ wpemod=0                  ud=0                      minr=1e-3

     9: type=n
+ lmin=3.0000e-07-dxl_na    lmax=5.0000e-07-dxl_na    wmin=1.0000e-06-dxw_na
+ wmax=1.0000e-05-dxw_na    version=4.5               binunit=2
+ paramchk=1                mobmod=0                  capmod=2
+ igcmod=1                  igbmod=1                  geomod=0
+ diomod=1                  rdsmod=0                  rbodymod=0
+ rgatemod=0                permod=1                  acnqsmod=0
+ trnqsmod=0                tnom=25                   toxe=toxn_na
+ toxm=toxn_na              dtox=4e-010               epsrox=3.9
+ wint=6e-009               lint=2.5e-009             ll=0
+ wl=0                      lln=1                     wln=1
+ lw=0                      ww=0                      lwn=1
+ wwn=1                     lwl=0                     wwl=0
+ llc=0                     wlc=0                     lwc=0
+ wwc=0                     lwlc=0                    wwlc=0
+ dlc=1.43e-008             dwc=0                     xpart=1
+ toxref=3e-009             dlcig=1.2e-009            xl=-5.5e-08+dxl_na
+ xw=1.5e-8+dxw_na          vth0=-0.11194698+dvthn_na lvth0=-4.047472e-009+dlvthn_na
+ wvth0=8.4723187e-009+dwvthn_na                      pvth0=-1.7658096e-015+dpvthn_na
+ k1=0.19530255             lk1=-7.6738112e-009       wk1=1.3778666e-008
+ pk1=7.0632383e-016        k2=-0.059488556           lk2=6.864e-009
+ wk2=-1.1147788e-009       k3=-2.45                  k3b=1.2
+ w0=-5e-008                dvt0=0.1                  dvt1=0.1
+ dvt2=0                    dvt0w=0                   dvt1w=0
+ dvt2w=0                   dsub=0.3                  minv=0
+ voffl=0                   dvtp0=0.0001              dvtp1=2
+ lpe0=5.081e-007           lpeb=0                    xj=1.5e-007
+ ngate=2e020               ndep=2.3687e017           nsd=1e020
+ phin=0                    cdsc=0                    cdscb=0
+ cdscd=0                   cit=0                     voff=-0.08401526
+ lvoff=-1.0478412e-008     wvoff=-1.5852154e-008     pvoff=1.8246699e-015
+ nfactor=1.2               eta0=0.0032576553         weta0=-1.0768763e-009
+ etab=0                    u0=0.05200195             lu0=-1.4352865e-009
+ wu0=-1.3198981e-009       pu0=-9.5942321e-016       ua=-3.6347766e-010
+ lua=4.5308853e-019        wua=2.4485001e-016        pua=-4.5322446e-024
+ ub=2.6948779e-018         lub=-3.9557232e-026       wub=-3.3487954e-025
+ pub=-1.4303058e-031       uc=2.733e-011             vsat=111700
+ a0=1.8090073              la0=-1.8688666e-007       wa0=4.9942089e-008
+ pa0=-8.475886e-014        ags=5.7740326             lags=-4.9777505e-007
+ wags=2.5664437e-006       pags=-1.2160542e-012      a1=0
+ a2=1                      b0=0                      b1=0
+ keta=0                    dwg=0                     dwb=0
+ pclm=2.6315473            lpclm=-4.0960374e-007     wpclm=-2.6955351e-007
+ ppclm=1.7304934e-013      pdiblc1=0.001             pdiblc2=0.0073241801
+ lpdiblc2=-1.181688e-009   wpdiblc2=1.4786426e-009   ppdiblc2=-1.1595483e-016
+ pdiblcb=0                 drout=0.56                pvag=1.5
+ delta=0.0075              pscbe1=5.545e008          pscbe2=1e-020
+ fprout=1000               pdits=0                   pditsd=0
+ pditsl=0                  rsh=10.5                  rdsw=135
+ prwg=0                    prwb=0                    wr=1
+ alpha0=0                  agidl=9e-008              bgidl=2.3e009
+ cgidl=0.5                 egidl=0.53                aigbacc=0.01157
+ bigbacc=0.002437          cigbacc=0.1416            nigbacc=4.05
+ aigbinv=0.35              bigbinv=0.03              cigbinv=0.006
+ eigbinv=1.1               nigbinv=1                 aigc=0.0109
+ bigc=0.001801             cigc=0                    aigsd=0.00744
+ bigsd=0.0002354           cigsd=0.001463            nigc=1
+ poxedge=1                 pigcd=2.3                 ntox=ntoxn_na
+ xrcrg1=12                 xrcrg2=1                  cgso=cgon_na
+ cgdo=cgon_na              cgbo=0                    cgdl=cgln_na
+ cgsl=cgln_na              clc=1e-007                cle=0.6
+ cf=cfn_na                 ckappas=0.6               acde=1.2
+ moin=12.6                 noff=1.686                voffcv=-0.05472
+ kt1=-0.48956372           lkt1=1.0368037e-008       wkt1=1.2440931e-008
+ pkt1=-5.4740097e-015      kt1l=0                    kt2=-0.04464
+ ute=-2.2210917            lute=5.9880363e-008       wute=-1.3912439e-007
+ pute=6.1214732e-014       ua1=8.6552091e-010        lua1=2.0006507e-018
+ wua1=-1.4425237e-016      pua1=-2.0012509e-023      ub1=-2.7206005e-018
+ lub1=-1.9535765e-026      wub1=-4.4412787e-025      pub1=1.9541626e-031
+ uc1=-6.421e-011           prt=0                     at=143283.55
+ lat=-0.0167813            wat=-0.01708064           pat=2.9194718e-009
+ jss=9.00e-07              jsws=1.50e-12             jswgs=9.0e-12
+ njs=1                     ijthsfwd=0.01             ijthsrev=0.01
+ bvs=10                    xjbvs=1                   pbs=0.49
+ cjs=cjn_na                mjs=0.313                 pbsws=0.500
+ cjsws=cjswn_na            mjsws=0.01                pbswgs=0.479
+ cjswgs=cjswgn_na          mjswgs=0.414              tpb=2.6e-03
+ tcj=2.1e-03               tpbsw=5.0e-04             tcjsw=4.6e-04
+ tpbswg=2.4e-03            tcjswg=2.9e-03            xtis=3
+ dmcg=1.025e-007           dmci=1.025e-007           dmdg=0
+ dmcgt=0                   dwj=0                     xgw=0
+ xgl=0                     rshg=0.1                  gbmin=1e-012
+ rbpb=50                   rbpd=50                   rbps=50
+ rbdb=50                   rbsb=50                   ngcon=1
+ alpha1=0.03               beta0=8.7                 saref=6.3e-07
+ sbref=6.3e-07             kvsat=0.18                wlod=8.0e-07
+ tku0=0.01                 ku0=-7.16e-08             llodku0=1
+ wlodku0=1                 lku0=3.057e-07            wku0=9.0e-07
+ pku0=-1.0e-13             kvth0=3.5e-09             stk2=1.35e-09
+ steta0=0                  lkvth0=-2.68e-11          wkvth0=2.5e-06
+ pkvth0=0                  llodvth=1                 wlodvth=1
+ lodk2=0.5                 lodeta0=1                 fnoimod=1
+ noia=4.446e+41            noib=1.15e+25             noic=0
+ em=3.12e+07               ef=0.8                    tnoimod=0
+ wpemod=0                  ud=0                      minr=1e-3

     10: type=n
+ lmin=2.0e-07              lmax=3.0000e-07-dxl_na    wmin=1.0000e-06-dxw_na
+ wmax=1.0000e-05-dxw_na    version=4.5               binunit=2
+ paramchk=1                mobmod=0                  capmod=2
+ igcmod=1                  igbmod=1                  geomod=0
+ diomod=1                  rdsmod=0                  rbodymod=0
+ rgatemod=0                permod=1                  acnqsmod=0
+ trnqsmod=0                tnom=25                   toxe=toxn_na
+ toxm=toxn_na              dtox=4e-010               epsrox=3.9
+ wint=6e-009               lint=2.5e-009             ll=0
+ wl=0                      lln=1                     wln=1
+ lw=0                      ww=0                      lwn=1
+ wwn=1                     lwl=0                     wwl=0
+ llc=0                     wlc=0                     lwc=0
+ wwc=0                     lwlc=0                    wwlc=0
+ dlc=1.43e-008             dwc=0                     xpart=1
+ toxref=3e-009             dlcig=1.2e-009            xl=-5.5e-08+dxl_na
+ xw=1.5e-8+dxw_na          vth0=-0.14047951+dvthn_na lvth0=2.800336e-009+dlvthn_na
+ wvth0=5.7968496e-009+dwvthn_na                      pvth0=-1.123697e-015+dpvthn_na
+ k1=0.18898632             lk1=-6.1579168e-009       wk1=4.5750521e-008
+ pk1=-6.9669214e-015       k2=-0.076193049           lk2=1.0873078e-008
+ wk2=-2.5477154e-008       pk2=5.8469701e-015        k3=-2.45
+ k3b=1.2                   w0=-5e-008                dvt0=0.1
+ dvt1=0.1                  dvt2=0                    dvt0w=0
+ dvt1w=0                   dvt2w=0                   dsub=0.3
+ minv=0                    voffl=0                   dvtp0=0.0001
+ dvtp1=2                   lpe0=5.081e-007           lpeb=0
+ xj=1.5e-007               ngate=2e020               ndep=2.3687e017
+ nsd=1e020                 phin=0                    cdsc=0
+ cdscb=0                   cdscd=0                   cit=0
+ voff=-0.10295268          lvoff=-5.9334315e-009     wvoff=-2.4480542e-008
+ pvoff=3.895483e-015       nfactor=1.2               eta0=0.0061109484
+ leta0=-6.8479033e-010     weta0=-1.4913956e-008     peta0=3.3208992e-015
+ etab=0                    u0=0.054377322            lu0=-2.0053757e-009
+ wu0=2.26746e-009          pu0=-1.8203892e-015       ua=-7.7302604e-010
+ lua=9.8744699e-017        wua=1.3950788e-015        pua=-2.8058714e-022
+ ub=3.5913305e-018         lub=-2.5470585e-025       wub=-2.2199705e-024
+ pub=3.0939124e-031        uc=2.733e-011             vsat=111700
+ a0=0.95091904             la0=1.9054523e-008        wa0=-2.7020008e-006
+ pa0=5.7570743e-013        ags=7.4837464             lags=-9.0810636e-007
+ wags=-5.7661932e-006      pags=7.8377866e-013       a1=0
+ a2=1                      b0=0                      b1=0
+ keta=0                    dwg=0                     dwb=0
+ pclm=1.2241489            lpclm=-7.1828135e-008     wpclm=9.3639188e-007
+ ppclm=-1.1637755e-013     pdiblc1=0.001             pdiblc2=-0.0065037447
+ lpdiblc2=2.1370139e-009   wpdiblc2=6.9495309e-009   ppdiblc2=-1.428968e-015
+ pdiblcb=0                 drout=0.56                pvag=1.5
+ delta=0.0075              pscbe1=5.545e008          pscbe2=1e-020
+ fprout=1000               pdits=0                   pditsd=0
+ pditsl=0                  rsh=10.5                  rdsw=135
+ prwg=0                    prwb=0                    wr=1
+ alpha0=0                  agidl=9e-008              bgidl=2.3e009
+ cgidl=0.5                 egidl=0.53                aigbacc=0.01157
+ bigbacc=0.002437          cigbacc=0.1416            nigbacc=4.05
+ aigbinv=0.35              bigbinv=0.03              cigbinv=0.006
+ eigbinv=1.1               nigbinv=1                 aigc=0.0109
+ bigc=0.001801             cigc=0                    aigsd=0.00744
+ bigsd=0.0002354           cigsd=0.001463            nigc=1
+ poxedge=1                 pigcd=2.3                 ntox=ntoxn_na
+ xrcrg1=12                 xrcrg2=1                  cgso=cgon_na
+ cgdo=cgon_na              cgbo=0                    cgdl=cgln_na
+ cgsl=cgln_na              clc=1e-007                cle=0.6
+ cf=cfn_na                 ckappas=0.6               acde=1.2
+ moin=12.6                 noff=1.686                voffcv=-0.05472
+ kt1=-0.43515727           lkt1=-2.689512e-009       wkt1=-3.1436762e-008
+ pkt1=5.0566365e-015       kt1l=0                    kt2=-0.04464
+ ute=-2.0938961            lute=2.9353408e-008       wute=2.4703498e-007
+ pute=-3.1463516e-014      ua1=9.1142048e-010        lua1=-9.0152459e-018
+ wua1=1.990549e-016        pua1=-1.0240625e-022      ub1=-2.9624613e-018
+ lub1=3.8510827e-026       wub1=-9.0965948e-025      pub1=3.0714385e-031
+ uc1=-6.421e-011           prt=0                     at=96554.25
+ lat=-0.0055662671         wat=0.0021381457          pat=-1.6930368e-009
+ jss=9.00e-07              jsws=1.50e-12             jswgs=9.0e-12
+ njs=1                     ijthsfwd=0.01             ijthsrev=0.01
+ bvs=10                    xjbvs=1                   pbs=0.49
+ cjs=cjn_na                mjs=0.313                 pbsws=0.500
+ cjsws=cjswn_na            mjsws=0.01                pbswgs=0.479
+ cjswgs=cjswgn_na          mjswgs=0.414              tpb=2.6e-03
+ tcj=2.1e-03               tpbsw=5.0e-04             tcjsw=4.6e-04
+ tpbswg=2.4e-03            tcjswg=2.9e-03            xtis=3
+ dmcg=1.025e-007           dmci=1.025e-007           dmdg=0
+ dmcgt=0                   dwj=0                     xgw=0
+ xgl=0                     rshg=0.1                  gbmin=1e-012
+ rbpb=50                   rbpd=50                   rbps=50
+ rbdb=50                   rbsb=50                   ngcon=1
+ alpha1=0.03               beta0=8.7                 saref=6.3e-07
+ sbref=6.3e-07             kvsat=0.18                wlod=8.0e-07
+ tku0=0.01                 ku0=-7.16e-08             llodku0=1
+ wlodku0=1                 lku0=3.057e-07            wku0=9.0e-07
+ pku0=-1.0e-13             kvth0=3.5e-09             stk2=1.35e-09
+ steta0=0                  lkvth0=-2.68e-11          wkvth0=2.5e-06
+ pkvth0=0                  llodvth=1                 wlodvth=1
+ lodk2=0.5                 lodeta0=1                 fnoimod=1
+ noia=4.446e+41            noib=1.15e+25             noic=0
+ em=3.12e+07               ef=0.8                    tnoimod=0
+ wpemod=0                  ud=0                      minr=1e-3

     11: type=n
+ lmin=1.0000e-05-dxl_na    lmax=2.001e-05            wmin=5.0e-07
+ wmax=1.0000e-06-dxw_na    version=4.5               binunit=2
+ paramchk=1                mobmod=0                  capmod=2
+ igcmod=1                  igbmod=1                  geomod=0
+ diomod=1                  rdsmod=0                  rbodymod=0
+ rgatemod=0                permod=1                  acnqsmod=0
+ trnqsmod=0                tnom=25                   toxe=toxn_na
+ toxm=toxn_na              dtox=4e-010               epsrox=3.9
+ wint=6e-009               lint=2.5e-009             ll=0
+ wl=0                      lln=1                     wln=1
+ lw=0                      ww=0                      lwn=1
+ wwn=1                     lwl=0                     wwl=0
+ llc=0                     wlc=0                     lwc=0
+ wwc=0                     lwlc=0                    wwlc=0
+ dlc=1.43e-008             dwc=0                     xpart=1
+ toxref=3e-009             dlcig=1.2e-009            xl=-5.5e-08+dxl_na
+ xw=1.5e-8+dxw_na          vth0=-0.1207+dvthn_na     lvth0=0+dlvthn_na
+ wvth0=0+dwvthn_na         pvth0=0+dpvthn_na         k1=0.14184231
+ lk1=-4.6681323e-024       wk1=1.3617654e-009        pk1=4.6821367e-030
+ k2=-0.024084738           lk2=-4.6681323e-024       wk2=1.8302127e-009
+ pk2=4.6821367e-030        k3=-2.45                  k3b=1.2
+ w0=-5e-008                dvt0=0.1                  dvt1=0.1
+ dvt2=0                    dvt0w=0                   dvt1w=0
+ dvt2w=0                   dsub=0.3                  minv=0
+ voffl=0                   dvtp0=0.0001              dvtp1=2
+ lpe0=5.081e-007           lpeb=0                    xj=1.5e-007
+ ngate=2e020               ndep=2.3687e017           nsd=1e020
+ phin=0                    cdsc=0                    cdscb=0
+ cdscd=0                   cit=0                     voff=-0.069504046
+ lvoff=-9.3362645e-024     wvoff=3.6549783e-009      pvoff=9.3642733e-030
+ nfactor=1.2               eta0=0.0021               etab=0
+ u0=0.041948               lu0=-4.6681323e-024       wu0=1.416236e-009
+ pu0=4.6821367e-030        ua=-3.7788923e-010        lua=-1.1129695e-030
+ wua=5.043979e-016         pua=1.1163084e-036        ub=3.0797754e-018
+ lub=2.0730672e-039        wub=-7.1792271e-025       pub=-2.0792864e-045
+ uc=2.733e-011             vsat=111700               a0=7.1429831
+ la0=-1.1950419e-021       wa0=5.3762497e-007        pa0=1.198627e-027
+ ags=1.1083446             lags=1.8672529e-023       wags=-4.3576492e-009
+ pags=-1.8728547e-029      a1=0                      a2=1
+ b0=0                      b1=0                      keta=0
+ dwg=0                     dwb=0                     pclm=1.32
+ pdiblc1=0.001             pdiblc2=0.022976846       lpdiblc2=1.8672529e-023
+ wpdiblc2=-6.3458267e-009  ppdiblc2=-1.8728547e-029  pdiblcb=0
+ drout=0.56                pvag=1.5                  delta=0.0075
+ pscbe1=5.545e008          pscbe2=1e-020             fprout=1000
+ pdits=0                   pditsd=0                  pditsl=0
+ rsh=10.5                  rdsw=135                  prwg=0
+ prwb=0                    wr=1                      alpha0=0
+ alpha1=0.03               beta0=8.7                 agidl=9e-008
+ bgidl=2.3e009             cgidl=0.5                 egidl=0.53
+ aigbacc=0.01157           bigbacc=0.002437          cigbacc=0.1416
+ nigbacc=4.05              aigbinv=0.35              bigbinv=0.03
+ cigbinv=0.006             eigbinv=1.1               nigbinv=1
+ aigc=0.0109               bigc=0.001801             cigc=0
+ aigsd=0.00744             bigsd=0.0002354           cigsd=0.001463
+ nigc=1                    poxedge=1                 pigcd=2.3
+ ntox=ntoxn_na             xrcrg1=12                 xrcrg2=1
+ cgso=cgon_na              cgdo=cgon_na              cgbo=0
+ cgdl=cgln_na              cgsl=cgln_na              clc=1e-007
+ cle=0.6                   cf=cfn_na                 ckappas=0.6
+ acde=1.2                  moin=12.6                 noff=1.686
+ voffcv=-0.05472           kt1=-0.45637985           lkt1=-1.8672529e-023
+ wkt1=6.6998857e-009       pkt1=1.8728547e-029       kt1l=0
+ kt2=-0.067913018          lkt2=-7.4690116e-023      wkt2=2.3342838e-008
+ pkt2=7.4914186e-029       ute=-2.1610708            lute=1.4938023e-022
+ wute=-3.7040018e-008      pute=-1.4982837e-028      ua1=1.9575646e-009
+ lua1=1.1129695e-030       wua1=-2.6636131e-016      pua1=-1.1163084e-036
+ ub1=-6.5391908e-018       lub1=1.0365336e-039       wub1=-3.7693666e-025
+ pub1=-1.0396432e-045      uc1=-6.421e-011           prt=0
+ at=179600                 jss=9.00e-07              jsws=1.50e-12
+ jswgs=9.0e-12             njs=1                     ijthsfwd=0.01
+ ijthsrev=0.01             bvs=10                    xjbvs=1
+ pbs=0.49                  cjs=cjn_na                mjs=0.313
+ pbsws=0.500               cjsws=cjswn_na            mjsws=0.01
+ pbswgs=0.479              cjswgs=cjswgn_na          mjswgs=0.414
+ tpb=2.6e-03               tcj=2.1e-03               tpbsw=5.0e-04
+ tcjsw=4.6e-04             tpbswg=2.4e-03            tcjswg=2.9e-03
+ xtis=3                    dmcg=1.025e-007           dmci=1.025e-007
+ dmdg=0                    dmcgt=0                   dwj=0
+ xgw=0                     xgl=0                     rshg=0.1
+ gbmin=1e-012              rbpb=50                   rbpd=50
+ rbps=50                   rbdb=50                   rbsb=50
+ ngcon=1                   saref=6.3e-07             sbref=6.3e-07
+ kvsat=0.18                wlod=8.0e-07              tku0=0.01
+ ku0=-7.16e-08             llodku0=1                 wlodku0=1
+ lku0=3.057e-07            wku0=9.0e-07              pku0=-1.0e-13
+ kvth0=3.5e-09             stk2=1.35e-09             steta0=0
+ lkvth0=-2.68e-11          wkvth0=2.5e-06            pkvth0=0
+ llodvth=1                 wlodvth=1                 lodk2=0.5
+ lodeta0=1                 fnoimod=1                 noia=4.446e+41
+ noib=1.15e+25             noic=0                    em=3.12e+07
+ ef=0.8                    tnoimod=0                 wpemod=0
+ ud=0                      minr=1e-3

     12: type=n
+ lmin=1.2000e-06-dxl_na    lmax=1.0000e-05-dxl_na    wmin=5.0e-07
+ wmax=1.0000e-06-dxw_na    version=4.5               binunit=2
+ paramchk=1                mobmod=0                  capmod=2
+ igcmod=1                  igbmod=1                  geomod=0
+ diomod=1                  rdsmod=0                  rbodymod=0
+ rgatemod=0                permod=1                  acnqsmod=0
+ trnqsmod=0                tnom=25                   toxe=toxn_na
+ toxm=toxn_na              dtox=4e-010               epsrox=3.9
+ wint=6e-009               lint=2.5e-009             ll=0
+ wl=0                      lln=1                     wln=1
+ lw=0                      ww=0                      lwn=1
+ wwn=1                     lwl=0                     wwl=0
+ llc=0                     wlc=0                     lwc=0
+ wwc=0                     lwlc=0                    wwlc=0
+ dlc=1.43e-008             dwc=0                     xpart=1
+ toxref=3e-009             dlcig=1.2e-009            xl=-5.5e-08+dxl_na
+ xw=1.5e-8+dxw_na          vth0=-0.12033707+dvthn_na lvth0=-3.6074901e-009+dlvthn_na
+ wvth0=-4.9394944e-010+dwvthn_na                     pvth0=4.9098575e-015+dpvthn_na
+ k1=0.13518915             lk1=6.6132367e-008        wk1=1.5381759e-009
+ pk1=-1.7535205e-015       k2=-0.020511428           lk2=-3.5518702e-008
+ wk2=1.8245675e-009        pk2=5.6112657e-017        k3=-2.45
+ k3b=1.2                   w0=-5e-008                dvt0=0.1
+ dvt1=0.1                  dvt2=0                    dvt0w=0
+ dvt1w=0                   dvt2w=0                   dsub=0.3
+ minv=0                    voffl=0                   dvtp0=0.0001
+ dvtp1=2                   lpe0=5.081e-007           lpeb=0
+ xj=1.5e-007               ngate=2e020               ndep=2.3687e017
+ nsd=1e020                 phin=0                    cdsc=0
+ cdscb=0                   cdscd=0                   cit=0
+ voff=-0.069068763         lvoff=-4.32671e-009       wvoff=4.5476155e-009
+ pvoff=-8.8728139e-015     nfactor=1.2               eta0=0.0021
+ etab=0                    u0=0.041574809            lu0=3.7095142e-009
+ wu0=1.6632107e-009        pu0=-2.4549287e-015       ua=-4.1018352e-010
+ lua=3.2100521e-016        wua=5.6974035e-016        pua=-6.49504e-022
+ ub=3.1870099e-018         lub=-1.0659113e-024       wub=-8.1092633e-025
+ pub=9.2445602e-031        uc=2.733e-011             vsat=111700
+ a0=7.6711377              la0=-5.249857e-006        wa0=6.0727185e-007
+ pa0=-6.922899e-013        ags=0.95163926            lags=1.5576512e-006
+ wags=-4.9221629e-009      pags=5.6112657e-015       a1=0
+ a2=1                      b0=0                      b1=0
+ keta=0                    dwg=0                     dwb=0
+ pclm=1.32                 pdiblc1=0.001             pdiblc2=0.024844613
+ lpdiblc2=-1.8565598e-008  wpdiblc2=-7.0302995e-009  ppdiblc2=6.8036596e-015
+ pdiblcb=0                 drout=0.56                pvag=1.5
+ delta=0.0075              pscbe1=5.545e008          pscbe2=1e-020
+ fprout=1000               pdits=0                   pditsd=0
+ pditsl=0                  rsh=10.5                  rdsw=135
+ prwg=0                    prwb=0                    wr=1
+ alpha0=0                  alpha1=0.03               beta0=8.7
+ agidl=9e-008              bgidl=2.3e009             cgidl=0.5
+ egidl=0.53                aigbacc=0.01157           bigbacc=0.002437
+ cigbacc=0.1416            nigbacc=4.05              aigbinv=0.35
+ bigbinv=0.03              cigbinv=0.006             eigbinv=1.1
+ nigbinv=1                 aigc=0.0109               bigc=0.001801
+ cigc=0                    aigsd=0.00744             bigsd=0.0002354
+ cigsd=0.001463            nigc=1                    poxedge=1
+ pigcd=2.3                 ntox=ntoxn_na             xrcrg1=12
+ xrcrg2=1                  cgso=cgon_na              cgdo=cgon_na
+ cgbo=0                    cgdl=cgln_na              cgsl=cgln_na
+ clc=1e-007                cle=0.6                   cf=cfn_na
+ ckappas=0.6               acde=1.2                  moin=12.6
+ noff=1.686                voffcv=-0.05472           kt1=-0.4545636
+ lkt1=-1.8053497e-008      wkt1=7.5678254e-009       pkt1=-8.627321e-015
+ kt1l=0                    kt2=-0.074266319          lkt2=6.3151803e-008
+ wkt2=2.6366796e-008       pkt2=-3.0058147e-014      ute=-2.1502252
+ lute=-1.0780472e-007      wute=-4.8048035e-008      pute=1.0941968e-013
+ ua1=2.1253473e-009        lua1=-1.6677599e-015      wua1=-3.0086721e-016
+ pua1=3.4298861e-022       ub1=-6.9489909e-018       lub1=4.073413e-024
+ wub1=-4.4185573e-025      pub1=6.4529555e-031       uc1=-6.421e-011
+ prt=0                     at=180685.71              lat=-0.010791962
+ wat=-0.00029636967        pat=2.9459145e-009        jss=9.00e-07
+ jsws=1.50e-12             jswgs=9.0e-12             njs=1
+ ijthsfwd=0.01             ijthsrev=0.01             bvs=10
+ xjbvs=1                   pbs=0.49                  cjs=cjn_na
+ mjs=0.313                 pbsws=0.500               cjsws=cjswn_na
+ mjsws=0.01                pbswgs=0.479              cjswgs=cjswgn_na
+ mjswgs=0.414              tpb=2.6e-03               tcj=2.1e-03
+ tpbsw=5.0e-04             tcjsw=4.6e-04             tpbswg=2.4e-03
+ tcjswg=2.9e-03            xtis=3                    dmcg=1.025e-007
+ dmci=1.025e-007           dmdg=0                    dmcgt=0
+ dwj=0                     xgw=0                     xgl=0
+ rshg=0.1                  gbmin=1e-012              rbpb=50
+ rbpd=50                   rbps=50                   rbdb=50
+ rbsb=50                   ngcon=1                   saref=6.3e-07
+ sbref=6.3e-07             kvsat=0.18                wlod=8.0e-07
+ tku0=0.01                 ku0=-7.16e-08             llodku0=1
+ wlodku0=1                 lku0=3.057e-07            wku0=9.0e-07
+ pku0=-1.0e-13             kvth0=3.5e-09             stk2=1.35e-09
+ steta0=0                  lkvth0=-2.68e-11          wkvth0=2.5e-06
+ pkvth0=0                  llodvth=1                 wlodvth=1
+ lodk2=0.5                 lodeta0=1                 fnoimod=1
+ noia=4.446e+41            noib=1.15e+25             noic=0
+ em=3.12e+07               ef=0.8                    tnoimod=0
+ wpemod=0                  ud=0                      minr=1e-3

     13: type=n
+ lmin=5.0000e-07-dxl_na    lmax=1.2000e-06-dxl_na    wmin=5.0e-07
+ wmax=1.0000e-06-dxw_na    version=4.5               binunit=2
+ paramchk=1                mobmod=0                  capmod=2
+ igcmod=1                  igbmod=1                  geomod=0
+ diomod=1                  rdsmod=0                  rbodymod=0
+ rgatemod=0                permod=1                  acnqsmod=0
+ trnqsmod=0                tnom=25                   toxe=toxn_na
+ toxm=toxn_na              dtox=4e-010               epsrox=3.9
+ wint=6e-009               lint=2.5e-009             ll=0
+ wl=0                      lln=1                     wln=1
+ lw=0                      ww=0                      lwn=1
+ wwn=1                     lwl=0                     wwl=0
+ llc=0                     wlc=0                     lwc=0
+ wwc=0                     lwlc=0                    wwlc=0
+ dlc=1.43e-008             dwc=0                     xpart=1
+ toxref=3e-009             dlcig=1.2e-009            xl=-5.5e-08+dxl_na
+ xw=1.5e-8+dxw_na          vth0=-0.12709407+dvthn_na lvth0=4.0954813e-009+dlvthn_na
+ wvth0=5.5248767e-009+dwvthn_na                      pvth0=-1.9516043e-015+dpvthn_na
+ k1=0.19449718             lk1=-1.4787829e-009       wk1=-1.3010696e-009
+ pk1=1.4832193e-015        k2=-0.056030296           lk2=4.9728073e-009
+ wk2=3.2227929e-009        pk2=-1.5378642e-015       k3=-2.45
+ k3b=1.2                   w0=-5e-008                dvt0=0.1
+ dvt1=0.1                  dvt2=0                    dvt0w=0
+ dvt1w=0                   dvt2w=0                   dsub=0.3
+ minv=0                    voffl=0                   dvtp0=0.0001
+ dvtp1=2                   lpe0=5.081e-007           lpeb=0
+ xj=1.5e-007               ngate=2e020               ndep=2.3687e017
+ nsd=1e020                 phin=0                    cdsc=0
+ cdscb=0                   cdscd=0                   cit=0
+ voff=-0.041809194         lvoff=-3.5402619e-008     wvoff=-7.015504e-009
+ pvoff=4.3091424e-015      nfactor=1.2               eta0=0.003254941
+ leta0=-1.3166328e-009     weta0=-1.2113642e-009     peta0=1.3809552e-015
+ etab=0                    u0=0.043481876            lu0=1.5354582e-009
+ wu0=2.8698233e-010        pu0=-8.8602837e-016       ua=-1.286e-010
+ ub=2.4437143e-018         lub=-2.1855429e-025       uc=2.6957915e-011
+ luc=4.2417721e-019        wuc=3.7320153e-019        puc=-4.2544974e-025
+ vsat=111700               a0=4.275325               la0=-1.3786305e-006
+ wa0=-6.2999157e-008       pa0=7.1819039e-014        ags=1.391742
+ lags=1.0559341e-006       wags=-4.12576e-007        pags=4.7033664e-013
+ a1=0                      a2=1                      b0=0
+ b1=0                      keta=0                    dwg=0
+ dwb=0                     pclm=0.78711745           lpclm=6.0748611e-007
+ wpclm=2.167308e-007       ppclm=-2.4707311e-013     pdiblc1=0.001
+ pdiblc2=0.010530452       lpdiblc2=-2.2474557e-009  wpdiblc2=-1.9992895e-009
+ ppdiblc2=1.0683082e-015   pdiblcb=0                 drout=0.56
+ pvag=1.5                  delta=0.0075              pscbe1=5.545e008
+ pscbe2=1e-020             fprout=1000               pdits=0
+ pditsd=0                  pditsl=0                  rsh=10.5
+ rdsw=135                  prwg=0                    prwb=0
+ wr=1                      alpha0=0                  alpha1=0.03
+ beta0=8.7                 agidl=9e-008              bgidl=2.3e009
+ cgidl=0.5                 egidl=0.53                aigbacc=0.01157
+ bigbacc=0.002437          cigbacc=0.1416            nigbacc=4.05
+ aigbinv=0.35              bigbinv=0.03              cigbinv=0.006
+ eigbinv=1.1               nigbinv=1                 aigc=0.0109
+ bigc=0.001801             cigc=0                    aigsd=0.00744
+ bigsd=0.0002354           cigsd=0.001463            nigc=1
+ poxedge=1                 pigcd=2.3                 ntox=ntoxn_na
+ xrcrg1=12                 xrcrg2=1                  cgso=cgon_na
+ cgdo=cgon_na              cgbo=0                    cgdl=cgln_na
+ cgsl=cgln_na              clc=1e-007                cle=0.6
+ cf=cfn_na                 ckappas=0.6               acde=1.2
+ moin=12.6                 noff=1.686                voffcv=-0.05472
+ kt1=-0.47316571           lkt1=3.1529143e-009       kt1l=0
+ kt2=-0.0026717143         lkt2=-1.8466046e-008      ute=-2.2882231
+ lute=4.9512881e-008       wute=2.088559e-008        pute=3.0835348e-014
+ ua1=6.5077143e-010        lua1=1.3256571e-017       ub1=-3.6935422e-018
+ lub1=3.622015e-025        wub1=1.3583415e-025       pub1=-1.3270909e-032
+ uc1=-6.421e-011           prt=0                     at=219297.93
+ lat=-0.054809887          wat=0.0037257901          pat=-1.6393476e-009
+ jss=9.00e-07              jsws=1.50e-12             jswgs=9.0e-12
+ njs=1                     ijthsfwd=0.01             ijthsrev=0.01
+ bvs=10                    xjbvs=1                   pbs=0.49
+ cjs=cjn_na                mjs=0.313                 pbsws=0.500
+ cjsws=cjswn_na            mjsws=0.01                pbswgs=0.479
+ cjswgs=cjswgn_na          mjswgs=0.414              tpb=2.6e-03
+ tcj=2.1e-03               tpbsw=5.0e-04             tcjsw=4.6e-04
+ tpbswg=2.4e-03            tcjswg=2.9e-03            xtis=3
+ dmcg=1.025e-007           dmci=1.025e-007           dmdg=0
+ dmcgt=0                   dwj=0                     xgw=0
+ xgl=0                     rshg=0.1                  gbmin=1e-012
+ rbpb=50                   rbpd=50                   rbps=50
+ rbdb=50                   rbsb=50                   ngcon=1
+ saref=6.3e-07             sbref=6.3e-07             kvsat=0.18
+ wlod=8.0e-07              tku0=0.01                 ku0=-7.16e-08
+ llodku0=1                 wlodku0=1                 lku0=3.057e-07
+ wku0=9.0e-07              pku0=-1.0e-13             kvth0=3.5e-09
+ stk2=1.35e-09             steta0=0                  lkvth0=-2.68e-11
+ wkvth0=2.5e-06            pkvth0=0                  llodvth=1
+ wlodvth=1                 lodk2=0.5                 lodeta0=1
+ fnoimod=1                 noia=4.446e+41            noib=1.15e+25
+ noic=0                    em=3.12e+07               ef=0.8
+ tnoimod=0                 wpemod=0                  ud=0
+ minr=1e-3

     14: type=n
+ lmin=3.0000e-07-dxl_na    lmax=5.0000e-07-dxl_na    wmin=5.0e-07
+ wmax=1.0000e-06-dxw_na    version=4.5               binunit=2
+ paramchk=1                mobmod=0                  capmod=2
+ igcmod=1                  igbmod=1                  geomod=0
+ diomod=1                  rdsmod=0                  rbodymod=0
+ rgatemod=0                permod=1                  acnqsmod=0
+ trnqsmod=0                tnom=25                   toxe=toxn_na
+ toxm=toxn_na              dtox=4e-010               epsrox=3.9
+ wint=6e-009               lint=2.5e-009             ll=0
+ wl=0                      lln=1                     wln=1
+ lw=0                      ww=0                      lwn=1
+ wwn=1                     lwl=0                     wwl=0
+ llc=0                     wlc=0                     lwc=0
+ wwc=0                     lwlc=0                    wwlc=0
+ dlc=1.43e-008             dwc=0                     xpart=1
+ toxref=3e-009             dlcig=1.2e-009            xl=-5.5e-08+dxl_na
+ xw=1.5e-8+dxw_na          vth0=-0.096765846+dvthn_na
+ lvth0=-9.2489354e-009+dlvthn_na                     wvth0=-6.7543563e-009+dwvthn_na
+ pvth0=3.4512582e-015+dpvthn_na                      k1=0.1847536
+ lk1=2.8083914e-009        wk1=2.4359259e-008        pk1=-9.8073254e-015
+ k2=-0.046740677           lk2=8.8537477e-010        wk2=-1.3900901e-008
+ pk2=5.9965611e-015        k3=-2.45                  k3b=1.2
+ w0=-5e-008                dvt0=0.1                  dvt1=0.1
+ dvt2=0                    dvt0w=0                   dvt1w=0
+ dvt2w=0                   dsub=0.3                  minv=0
+ voffl=0                   dvtp0=0.0001              dvtp1=2
+ lpe0=5.081e-007           lpeb=0                    xj=1.5e-007
+ ngate=2e020               ndep=2.3687e017           nsd=1e020
+ phin=0                    cdsc=0                    cdscb=0
+ cdscd=0                   cit=0                     voff=-0.10213351
+ lvoff=-8.8599212e-009     wvoff=2.3204482e-009      pvoff=2.0132339e-016
+ nfactor=1.2               eta0=0.0030505335         leta0=-1.2266935e-009
+ weta0=-8.6913314e-010     peta0=1.2303735e-015      etab=0
+ u0=0.050211351            lu0=-1.4255106e-009       wu0=4.7607318e-010
+ pu0=-9.6922834e-016       ua=-4.1177434e-010        lua=1.2459671e-016
+ wua=2.9329158e-016        pua=-1.290483e-022        ub=2.5741034e-018
+ lub=-2.7592549e-025       wub=-2.1374269e-025       pub=9.4046786e-032
+ uc=2.8632298e-011         luc=-3.1255163e-019       wuc=-1.3062054e-018
+ puc=3.1348929e-025        vsat=111700               a0=2.9104142
+ la0=-7.7806974e-007       wa0=-1.054769e-006        pa0=5.0819777e-013
+ ags=6.7582028             lags=-1.3053086e-006      wags=1.579321e-006
+ pags=-4.0609805e-013      a1=0                      a2=1
+ b0=0                      b1=0                      keta=0
+ dwg=0                     dwb=0                     pclm=3.0552231
+ lpclm=-3.9048037e-007     wpclm=-6.9450035e-007     ppclm=1.5386859e-013
+ pdiblc1=0.001             pdiblc2=0.0093530988      lpdiblc2=-1.7294201e-009
+ wpdiblc2=-5.5636287e-010  ppdiblc2=4.3342051e-016   pdiblcb=0
+ drout=0.56                pvag=1.5                  delta=0.0075
+ pscbe1=5.545e008          pscbe2=1e-020             fprout=1000
+ pdits=0                   pditsd=0                  pditsl=0
+ rsh=10.5                  rdsw=135                  prwg=0
+ prwb=0                    wr=1                      alpha0=0
+ agidl=9e-008              bgidl=2.3e009             cgidl=0.5
+ egidl=0.53                aigbacc=0.01157           bigbacc=0.002437
+ cigbacc=0.1416            nigbacc=4.05              aigbinv=0.35
+ bigbinv=0.03              cigbinv=0.006             eigbinv=1.1
+ nigbinv=1                 aigc=0.0109               bigc=0.001801
+ cigc=0                    aigsd=0.00744             bigsd=0.0002354
+ cigsd=0.001463            nigc=1                    poxedge=1
+ pigcd=2.3                 ntox=ntoxn_na             xrcrg1=12
+ xrcrg2=1                  cgso=cgon_na              cgdo=cgon_na
+ cgbo=0                    cgdl=cgln_na              cgsl=cgln_na
+ clc=1e-007                cle=0.6                   cf=cfn_na
+ ckappas=0.6               acde=1.2                  moin=12.6
+ noff=1.686                voffcv=-0.05472           kt1=-0.4534384
+ lkt1=-5.527104e-009       wkt1=-2.3792765e-008      pkt1=1.0468817e-014
+ kt1l=0                    kt2=-0.04464              ute=-2.6010348
+ lute=1.8715001e-007       wute=2.4195847e-007       pute=-6.643672e-014
+ ua1=8.174336e-010         lua1=-6.0074784e-017      wua1=-9.6020801e-017
+ pua1=4.2249152e-023       ub1=-3.4772985e-018       lub1=2.6705428e-025
+ wub1=3.1484016e-025       pub1=-9.2033552e-032      uc1=-6.421e-011
+ prt=0                     at=118003.58              lat=-0.010240373
+ wat=0.0082751759          pat=-3.6410774e-009       jss=9.00e-07
+ jsws=1.50e-12             jswgs=9.0e-12             njs=1
+ ijthsfwd=0.01             ijthsrev=0.01             bvs=10
+ xjbvs=1                   pbs=0.49                  cjs=cjn_na
+ mjs=0.313                 pbsws=0.500               cjsws=cjswn_na
+ mjsws=0.01                pbswgs=0.479              cjswgs=cjswgn_na
+ mjswgs=0.414              tpb=2.6e-03               tcj=2.1e-03
+ tpbsw=5.0e-04             tcjsw=4.6e-04             tpbswg=2.4e-03
+ tcjswg=2.9e-03            xtis=3                    dmcg=1.025e-007
+ dmci=1.025e-007           dmdg=0                    dmcgt=0
+ dwj=0                     xgw=0                     xgl=0
+ rshg=0.1                  gbmin=1e-012              rbpb=50
+ rbpd=50                   rbps=50                   rbdb=50
+ rbsb=50                   ngcon=1                   alpha1=0.03
+ beta0=8.7                 saref=6.3e-07             sbref=6.3e-07
+ kvsat=0.18                wlod=8.0e-07              tku0=0.01
+ ku0=-7.16e-08             llodku0=1                 wlodku0=1
+ lku0=3.057e-07            wku0=9.0e-07              pku0=-1.0e-13
+ kvth0=3.5e-09             stk2=1.35e-09             steta0=0
+ lkvth0=-2.68e-11          wkvth0=2.5e-06            pkvth0=0
+ llodvth=1                 wlodvth=1                 lodk2=0.5
+ lodeta0=1                 fnoimod=1                 noia=4.446e+41
+ noib=1.15e+25             noic=0                    em=3.12e+07
+ ef=0.8                    tnoimod=0                 wpemod=0
+ ud=0                      minr=1e-3

     15: type=n
+ lmin=2.0e-07              lmax=3.0000e-07-dxl_na    wmin=5.0e-07
+ wmax=1.0000e-06-dxw_na    version=4.5               binunit=2
+ paramchk=1                mobmod=0                  capmod=2
+ igcmod=1                  igbmod=1                  geomod=0
+ diomod=1                  rdsmod=0                  rbodymod=0
+ rgatemod=0                permod=1                  acnqsmod=0
+ trnqsmod=0                tnom=25                   toxe=toxn_na
+ toxm=toxn_na              dtox=4e-010               epsrox=3.9
+ wint=6e-009               lint=2.5e-009             ll=0
+ wl=0                      lln=1                     wln=1
+ lw=0                      ww=0                      lwn=1
+ wwn=1                     lwl=0                     wwl=0
+ llc=0                     wlc=0                     lwc=0
+ wwc=0                     lwlc=0                    wwlc=0
+ dlc=1.43e-008             dwc=0                     xpart=1
+ toxref=3e-009             dlcig=1.2e-009            xl=-5.5e-08+dxl_na
+ xw=1.5e-8+dxw_na          vth0=-0.15925794+dvthn_na lvth0=5.7491668e-009+dlvthn_na
+ wvth0=2.4631612e-008+dwvthn_na                      pvth0=-4.0813743e-015+dpvthn_na
+ k1=0.28070723             lk1=-2.022048e-008        wk1=-4.6245552e-008
+ pk1=7.1378294e-015        k2=-0.13070292            lk2=2.1036314e-008
+ wk2=2.919625e-008         pk2=-4.3467551e-015       k3=-2.45
+ k3b=1.2                   w0=-5e-008                dvt0=0.1
+ dvt1=0.1                  dvt2=0                    dvt0w=0
+ dvt1w=0                   dvt2w=0                   dsub=0.3
+ minv=0                    voffl=0                   dvtp0=0.0001
+ dvtp1=2                   lpe0=5.081e-007           lpeb=0
+ xj=1.5e-007               ngate=2e020               ndep=2.3687e017
+ nsd=1e020                 phin=0                    cdsc=0
+ cdscb=0                   cdscd=0                   cit=0
+ voff=-0.12959748          lvoff=-2.2685686e-009     wvoff=2.2441894e-009
+ pvoff=2.1962552e-016      nfactor=1.2               eta0=-0.021378639
+ leta0=4.6363079e-009      weta0=1.2658099e-008      peta0=-2.0161623e-015
+ etab=0                    u0=0.063816391            lu0=-4.6907202e-009
+ wu0=-7.1999259e-009       pu0=8.7301145e-016        ua=1.2711364e-009
+ lua=-2.7930186e-016       wua=-6.5521614e-016       pua=9.8593557e-023
+ ub=9.4342985e-019         lub=1.1543616e-025        wub=4.3587386e-025
+ pub=-6.1861188e-032       uc=2.733e-011             vsat=111700
+ a0=-4.1444862             la0=9.1510634e-007        wa0=2.4086906e-006
+ pa0=-3.2303254e-013       ags=2.1338529             lags=-1.9546464e-007
+ wags=-4.0025008e-007      pags=6.8999018e-014       a1=0
+ a2=1                      b0=0                      b1=0
+ keta=0                    dwg=0                     dwb=0
+ pclm=2.4786659            lpclm=-2.5210664e-007     wpclm=-3.2188865e-007
+ ppclm=6.4441788e-014      pdiblc1=0.001             pdiblc2=-0.0037404
+ lpdiblc2=1.4130196e-009   wpdiblc2=4.1778962e-009   ppdiblc2=-7.0280167e-016
+ pdiblcb=0                 drout=0.56                pvag=1.5
+ delta=0.0075              pscbe1=5.545e008          pscbe2=1e-020
+ fprout=1000               pdits=0                   pditsd=0
+ pditsl=0                  rsh=10.5                  rdsw=135
+ prwg=0                    prwb=0                    wr=1
+ alpha0=0                  agidl=9e-008              bgidl=2.3e009
+ cgidl=0.5                 egidl=0.53                aigbacc=0.01157
+ bigbacc=0.002437          cigbacc=0.1416            nigbacc=4.05
+ aigbinv=0.35              bigbinv=0.03              cigbinv=0.006
+ eigbinv=1.1               nigbinv=1                 aigc=0.0109
+ bigc=0.001801             cigc=0                    aigsd=0.00744
+ bigsd=0.0002354           cigsd=0.001463            nigc=1
+ poxedge=1                 pigcd=2.3                 ntox=ntoxn_na
+ xrcrg1=12                 xrcrg2=1                  cgso=cgon_na
+ cgdo=cgon_na              cgbo=0                    cgdl=cgln_na
+ cgsl=cgln_na              clc=1e-007                cle=0.6
+ cf=cfn_na                 ckappas=0.6               acde=1.2
+ moin=12.6                 noff=1.686                voffcv=-0.05472
+ kt1=-0.49159015           lkt1=3.6293169e-009       wkt1=2.5165424e-008
+ pkt1=-1.2811489e-015      kt1l=0                    kt2=-0.04464
+ ute=-1.8082812            lute=-3.1108431e-009      wute=-3.9436726e-008
+ pute=1.0981276e-015       ua1=1.2815358e-009        lua1=-1.714593e-016
+ wua1=-1.7217072e-016      pua1=6.0525133e-023       ub1=-4.581048e-018
+ lub1=5.3195417e-025       wub1=7.1378294e-025       pub1=-1.8777982e-031
+ uc1=-6.421e-011           prt=0                     at=121976.4
+ lat=-0.01119385           wat=-0.023360268          pat=3.9514292e-009
+ jss=9.00e-07              jsws=1.50e-12             jswgs=9.0e-12
+ njs=1                     ijthsfwd=0.01             ijthsrev=0.01
+ bvs=10                    xjbvs=1                   pbs=0.49
+ cjs=cjn_na                mjs=0.313                 pbsws=0.500
+ cjsws=cjswn_na            mjsws=0.01                pbswgs=0.479
+ cjswgs=cjswgn_na          mjswgs=0.414              tpb=2.6e-03
+ tcj=2.1e-03               tpbsw=5.0e-04             tcjsw=4.6e-04
+ tpbswg=2.4e-03            tcjswg=2.9e-03            xtis=3
+ dmcg=1.025e-007           dmci=1.025e-007           dmdg=0
+ dmcgt=0                   dwj=0                     xgw=0
+ xgl=0                     rshg=0.1                  gbmin=1e-012
+ rbpb=50                   rbpd=50                   rbps=50
+ rbdb=50                   rbsb=50                   ngcon=1
+ alpha1=0.03               beta0=8.7                 saref=6.3e-07
+ sbref=6.3e-07             kvsat=0.18                wlod=8.0e-07
+ tku0=0.01                 ku0=-7.16e-08             llodku0=1
+ wlodku0=1                 lku0=3.057e-07            wku0=9.0e-07
+ pku0=-1.0e-13             kvth0=3.5e-09             stk2=1.35e-09
+ steta0=0                  lkvth0=-2.68e-11          wkvth0=2.5e-06
+ pkvth0=0                  llodvth=1                 wlodvth=1
+ lodk2=0.5                 lodeta0=1                 fnoimod=1
+ noia=4.446e+41            noib=1.15e+25             noic=0
+ em=3.12e+07               ef=0.8                    tnoimod=0
+ wpemod=0                  ud=0                      minr=1e-3

     }
endsection mos_na
//
//
//
//
//  *************************************************************
//                                                              *
//                1.8V NATIVE NMOS DEVICE LIB                   *
//                                                              *
//  *************************************************************
//

section mos_na18
//
//  *****************************************************************************************
//
//             *
//                                1.8V NATIVE NMOS DEVICE MODELS
//             *
//
//             *
//  *****************************************************************************************

model nch_na18 bsim3v3  {
     1: type=n
+ lmin=1.0000e-05-dxl_na18  lmax=9.001e-04            wmin=1.0000e-05-dxw_na18
+ wmax=9.001e-04            tnom=25.0                 version=3.24
+ tox=toxn_na18             toxm=toxn_na18            xj=1.5000001e-07
+ nch=1.6999999e17          lln=1.0000000             lwn=1.0000000
+ wln=1.0000000             wwn=-1.0000000            lint=2.5000000e-08
+ ll=0.00                   lw=0.00                   lwl=0.00
+ wint=0.00                 wl=0.00                   ww=0.00
+ wwl=0.00                  mobmod=1                  binunit=2
+ xl=-4e-08+dxl_na18        xw=0+dxw_na18             dwg=0.00
+ dwb=0.00                  ldif=6.50e-08             hdif=1.25e-07
+ rsh=10.5                  rd=0                      rs=0
+ rsc=0                     rdc=0                     vth0=-2.2000000e-02+dvthn_na18
+ lvth0=0+dlvthn_na18       wvth0=0+dwvthn_na18       k1=9.7580000e-02
+ k2=-2.6264999e-02         k3=0.00                   dvt0=0.00
+ dvt1=0.00                 dvt2=0.00                 dvt0w=0.00
+ dvt1w=0.00                dvt2w=0.00                nlx=0.00
+ w0=0.00                   k3b=0.00                  ngate=4.0000000e20
+ vsat=1.0000000e05         ua=5.9700930e-10          ub=2.0248000e-18
+ uc=-1.3503200e-11         rdsw=2.2000000e02         prwb=0.00
+ prwg=0.00                 wr=1.0000000              u0=5.2283730e-02
+ a0=4.2506960              keta=1.7300000e-02        a1=0.00
+ a2=1.0000000              ags=1.1000000             b0=0.00
+ b1=0.00                   voff=-0.1050000           nfactor=1.7406400
+ cit=0.00                  cdsc=0.00                 cdscb=0.00
+ cdscd=0.00                eta0=6.7650000e-03        etab=4.0000000e-04
+ dsub=0.00                 pclm=1.3000000            pdiblc1=0.00
+ pdiblc2=8.0840000e-03     pdiblcb=0.00              drout=0.00
+ pscbe1=4.2400000e08       pscbe2=1.0000000e-05      pvag=0.00
+ delta=1.0000000e-02       alpha0=0.00               alpha1=0.001
+ beta0=7.97                kt1=-0.3575000            kt2=-1.0604001e-02
+ at=2.0000000e05           ute=-2.2500000            ua1=6.4843970e-10
+ ub1=-2.9700003e-18        uc1=-5.6000000e-11        kt1l=0.00
+ prt=0                     cj=cjn_na18               mj=0.29
+ pb=0.45                   cjsw=cjswn_na18           mjsw=0.01
+ pbsw=0.15                 cjswg=cjswgn_na18         mjswg=0.43
+ pbswg=0.55                tpb=2.5e-03               tpbsw=2.0e-04
+ tpbswg=2.4e-03            tcj=2.8e-03               tcjsw=3.0e-04
+ tcjswg=2.5e-03            js=1.0e-06                jsw=2.0e-12
+ n=1                       xti=3                     cgdo=cgon_na18
+ cgso=cgon_na18            cgbo=0                    capmod=3
+ nqsmod=0                  elm=5                     xpart=1
+ cgsl=cgln_na18            cgdl=cgln_na18            ckappa=0.6000000
+ cf=cfn_na18               clc=1.0000000e-07         cle=0.6000000
+ dlc=3.95e-8               dwc=0                     llc=0
+ lwc=0                     wlc=0                     wwc=-0.05084
+ lwlc=0                    wwlc=0                    acde=0.4
+ moin=15                   noff=2.7                  voffcv=-0.1018
+ tlev=1                    tlevc=1                   sa0=8.2e-07
+ sb0=8.2e-07               kvsat=-0.55               wlod=1.0e-07
+ tku0=0.1                  ku0=-6.0e-08              llodku0=1
+ wlodku0=1                 lku0=2.5e-07              wku0=2.0e-07
+ pku0=5.0e-14              kvth0=4.0e-09             stk2=0
+ steta0=0                  lkvth0=-4.68e-11          wkvth0=7.0e-07
+ pkvth0=0                  llodvth=1                 wlodvth=1
+ lodk2=1                   lodeta0=1                 noimod=2
+ noia=5.54e+20             noib=5.00e+02             noic=1.00e-13
+ em=5.20e+06               ef=0.85                   minr=1e-3
+ imax=0.01                 imelt=0.01

     2: type=n
+ lmin=1.2000e-06-dxl_na18  lmax=1.0000e-05-dxl_na18  wmin=1.0000e-05-dxw_na18
+ wmax=9.001e-04            tnom=25.0                 version=3.24
+ tox=toxn_na18             toxm=toxn_na18            xj=1.5000001e-07
+ nch=1.6999999e17          lln=1.0000000             lwn=1.0000000
+ wln=1.0000000             wwn=-1.0000000            lint=2.5000000e-08
+ ll=0.00                   lw=0.00                   lwl=0.00
+ wint=0.00                 wl=0.00                   ww=0.00
+ wwl=0.00                  mobmod=1                  binunit=2
+ xl=-4e-08+dxl_na18        xw=0+dxw_na18             dwg=0.00
+ dwb=0.00                  ldif=6.50e-08             hdif=1.25e-07
+ rsh=10.5                  rd=0                      rs=0
+ rsc=0                     rdc=0                     vth0=-3.1838640e-02+dvthn_na18
+ lvth0=9.7500890e-08+dlvthn_na18                     wvth0=0+dwvthn_na18
+ k1=9.7580000e-02          k2=-2.5938936e-02         lk2=-3.2312810e-09
+ k3=0.00                   dvt0=0.00                 dvt1=0.00
+ dvt2=0.00                 dvt0w=0.00                dvt1w=0.00
+ dvt2w=0.00                nlx=0.00                  w0=0.00
+ k3b=0.00                  ngate=4.0000000e20        vsat=9.1505980e04
+ lvsat=8.4175770e-02       ua=6.7105280e-10          lua=-7.3377070e-16
+ ub=1.9997745e-18          lub=2.4800236e-25         uc=-1.3469295e-11
+ luc=-3.3600270e-19        rdsw=2.2000000e02         prwb=0.00
+ prwg=0.00                 wr=1.0000000              u0=5.2865510e-02
+ lu0=-5.7654410e-09        a0=4.6981230              la0=-4.4340000e-06
+ keta=2.0234236e-02        lketa=-2.9078290e-08      a1=0.00
+ a2=1.0000000              ags=0.8598364             lags=2.3800217e-06
+ b0=0.00                   b1=0.00                   voff=-0.1063497
+ lvoff=1.3375115e-08       nfactor=1.7597295         lnfactor=-1.8917672e-07
+ cit=0.00                  cdsc=0.00                 cdscb=0.00
+ cdscd=0.00                eta0=7.4802560e-03        leta0=-7.0881900e-09
+ etab=3.6846590e-04        letab=3.1250286e-10       dsub=0.00
+ pclm=1.3000000            pdiblc1=0.00              pdiblc2=-5.1689940e-03
+ lpdiblc2=1.3133720e-07    pdiblcb=0.00              drout=0.00
+ pscbe1=4.2400000e08       pscbe2=1.0000000e-05      pvag=0.00
+ delta=1.0000000e-02       alpha0=0.00               alpha1=0.001
+ beta0=7.97                kt1=-0.3702398            lkt1=1.2625114e-07
+ kt2=-1.1107789e-02        lkt2=4.9925450e-09        at=2.1288547e05
+ lat=-0.1276949            ute=-2.3596795            lute=1.0869239e-06
+ ua1=2.6448457e-10         lua1=3.8049950e-15        ub1=-2.6481827e-18
+ lub1=-3.1892110e-24       uc1=-5.6000000e-11        kt1l=0.00
+ prt=0                     cj=cjn_na18               mj=0.29
+ pb=0.45                   cjsw=cjswn_na18           mjsw=0.01
+ pbsw=0.15                 cjswg=cjswgn_na18         mjswg=0.43
+ pbswg=0.55                tpb=2.5e-03               tpbsw=2.0e-04
+ tpbswg=2.4e-03            tcj=2.8e-03               tcjsw=3.0e-04
+ tcjswg=2.5e-03            js=1.0e-06                jsw=2.0e-12
+ n=1                       xti=3                     cgdo=cgon_na18
+ cgso=cgon_na18            cgbo=0                    capmod=3
+ nqsmod=0                  elm=5                     xpart=1
+ cgsl=cgln_na18            cgdl=cgln_na18            ckappa=0.6000000
+ cf=cfn_na18               clc=1.0000000e-07         cle=0.6000000
+ dlc=3.95e-8               dwc=0                     llc=0
+ lwc=0                     wlc=0                     wwc=-0.05084
+ lwlc=0                    wwlc=0                    acde=0.4
+ moin=15                   noff=2.7                  voffcv=-0.1018
+ tlev=1                    tlevc=1                   sa0=8.2e-07
+ sb0=8.2e-07               kvsat=-0.55               wlod=1.0e-07
+ tku0=0.1                  ku0=-6.0e-08              llodku0=1
+ wlodku0=1                 lku0=2.5e-07              wku0=2.0e-07
+ pku0=5.0e-14              kvth0=4.0e-09             stk2=0
+ steta0=0                  lkvth0=-4.68e-11          wkvth0=7.0e-07
+ pkvth0=0                  llodvth=1                 wlodvth=1
+ lodk2=1                   lodeta0=1                 noimod=2
+ noia=5.54e+20             noib=5.00e+02             noic=1.00e-13
+ em=5.20e+06               ef=0.85                   minr=1e-3
+ imax=0.01                 imelt=0.01

     3: type=n
+ lmin=8.0e-07              lmax=1.2000e-06-dxl_na18  wmin=1.0000e-05-dxw_na18
+ wmax=9.001e-04            tnom=25.0                 version=3.24
+ tox=toxn_na18             toxm=toxn_na18            xj=1.5000001e-07
+ nch=1.6999999e17          lln=1.0000000             lwn=1.0000000
+ wln=1.0000000             wwn=-1.0000000            lint=2.5000000e-08
+ ll=0.00                   lw=0.00                   lwl=0.00
+ wint=0.00                 wl=0.00                   ww=0.00
+ wwl=0.00                  mobmod=1                  binunit=2
+ xl=-4e-08+dxl_na18        xw=0+dxw_na18             dwg=0.00
+ dwb=0.00                  ldif=6.50e-08             hdif=1.25e-07
+ rsh=10.5                  rd=0                      rs=0
+ rsc=0                     rdc=0                     vth0=2.2138903e-02+dvthn_na18
+ lvth0=3.7585820e-08+dlvthn_na18                     wvth0=0+dwvthn_na18
+ k1=9.7580000e-02          k2=-3.2937000e-02         lk2=4.5365720e-09
+ k3=0.00                   dvt0=0.00                 dvt1=0.00
+ dvt2=0.00                 dvt0w=0.00                dvt1w=0.00
+ dvt2w=0.00                nlx=0.00                  w0=0.00
+ k3b=0.00                  ngate=4.0000000e20        vsat=2.2298275e05
+ lvsat=-6.1763460e-02      ua=2.0975719e-11          lua=-1.2185189e-17
+ ub=2.5147225e-18          lub=-3.2358990e-25        uc=-2.3395568e-11
+ luc=1.0682162e-17         rdsw=2.2000000e02         prwb=0.00
+ prwg=0.00                 wr=1.0000000              u0=4.8690970e-02
+ lu0=-1.1317002e-09        a0=0.7873757              la0=-9.3071180e-08
+ keta=-1.5418811e-02       lketa=1.0496594e-08       a1=0.00
+ a2=1.0000000              ags=5.4434150             lags=-2.7077501e-06
+ b0=0.00                   b1=0.00                   voff=-7.6366010e-02
+ lvoff=-1.9906736e-08      nfactor=1.4046652         lnfactor=2.0494464e-07
+ cit=0.00                  cdsc=0.00                 cdscb=0.00
+ cdscd=0.00                eta0=-1.4023520e-03       leta0=2.7715059e-09
+ etab=1.6200004e-04        letab=5.4168000e-10       dsub=0.00
+ pclm=1.9344000            lpclm=-7.0418400e-07      pdiblc1=0.00
+ pdiblc2=9.0704080e-02     lpdiblc2=2.4918087e-08    pdiblcb=0.00
+ drout=0.00                pscbe1=4.2400000e08       pscbe2=1.0000000e-05
+ pvag=0.00                 delta=1.0000000e-02       alpha0=0.00
+ alpha1=0.001              beta0=7.97                kt1=-0.2971870
+ lkt1=4.5162580e-08        kt2=-9.5014020e-03        lkt2=3.2094550e-09
+ at=2.1480031e05           lat=-0.1298204            ute=-1.3261406
+ lute=-6.0304190e-08       ua1=5.0505730e-09         lua1=-1.5075637e-15
+ ub1=-7.1465290e-18        lub1=1.8039539e-24        uc1=-5.6000000e-11
+ kt1l=0.00                 prt=0                     cj=cjn_na18
+ mj=0.29                   pb=0.45                   cjsw=cjswn_na18
+ mjsw=0.01                 pbsw=0.15                 cjswg=cjswgn_na18
+ mjswg=0.43                pbswg=0.55                tpb=2.5e-03
+ tpbsw=2.0e-04             tpbswg=2.4e-03            tcj=2.8e-03
+ tcjsw=3.0e-04             tcjswg=2.5e-03            js=1.0e-06
+ jsw=2.0e-12               n=1                       xti=3
+ cgdo=cgon_na18            cgso=cgon_na18            cgbo=0
+ capmod=3                  nqsmod=0                  elm=5
+ xpart=1                   cgsl=cgln_na18            cgdl=cgln_na18
+ ckappa=0.6000000          cf=cfn_na18               clc=1.0000000e-07
+ cle=0.6000000             dlc=3.95e-8               dwc=0
+ llc=0                     lwc=0                     wlc=0
+ wwc=-0.05084              lwlc=0                    wwlc=0
+ acde=0.4                  moin=15                   noff=2.7
+ voffcv=-0.1018            tlev=1                    tlevc=1
+ sa0=8.2e-07               sb0=8.2e-07               kvsat=-0.55
+ wlod=1.0e-07              tku0=0.1                  ku0=-6.0e-08
+ llodku0=1                 wlodku0=1                 lku0=2.5e-07
+ wku0=2.0e-07              pku0=5.0e-14              kvth0=4.0e-09
+ stk2=0                    steta0=0                  lkvth0=-4.68e-11
+ wkvth0=7.0e-07            pkvth0=0                  llodvth=1
+ wlodvth=1                 lodk2=1                   lodeta0=1
+ noimod=2                  noia=5.54e+20             noib=5.00e+02
+ noic=1.00e-13             em=5.20e+06               ef=0.85
+ minr=1e-3                 imax=0.01                 imelt=0.01

     4: type=n
+ lmin=1.0000e-05-dxl_na18  lmax=9.001e-04            wmin=1.0000e-06-dxw_na18
+ wmax=1.0000e-05-dxw_na18  tnom=25.0                 version=3.24
+ tox=toxn_na18             toxm=toxn_na18            xj=1.5000001e-07
+ nch=1.6999999e17          lln=1.0000000             lwn=1.0000000
+ wln=1.0000000             wwn=-1.0000000            lint=2.5000000e-08
+ ll=0.00                   lw=0.00                   lwl=0.00
+ wint=0.00                 wl=0.00                   ww=0.00
+ wwl=0.00                  mobmod=1                  binunit=2
+ xl=-4e-08+dxl_na18        xw=0+dxw_na18             dwg=0.00
+ dwb=0.00                  ldif=6.50e-08             hdif=1.25e-07
+ rsh=10.5                  rd=0                      rs=0
+ rsc=0                     rdc=0                     vth0=-2.1777777e-02+dvthn_na18
+ wvth0=-2.2222224e-09+dwvthn_na18                    lvth0=0+dlvthn_na18
+ k1=9.7580000e-02          k2=-2.7165111e-02         wk2=9.0011110e-09
+ k3=0.00                   dvt0=0.00                 dvt1=0.00
+ dvt2=0.00                 dvt0w=0.00                dvt1w=0.00
+ dvt2w=0.00                nlx=0.00                  w0=0.00
+ k3b=0.00                  ngate=4.0000000e20        vsat=1.0000000e05
+ ua=5.4881260e-10          wua=4.8196650e-16         ub=2.1164446e-18
+ wub=-9.1644450e-25        uc=-1.3503223e-11         rdsw=2.2000000e02
+ prwb=0.00                 prwg=0.00                 wr=1.0000000
+ u0=5.2710150e-02          wu0=-4.2642280e-09        a0=4.2007470
+ wa0=4.9949330e-07         keta=1.7379444e-02        wketa=-7.9444510e-10
+ a1=0.00                   a2=1.0000000              ags=1.1229820
+ wags=-2.2982002e-07       b0=0.00                   b1=0.00
+ voff=-0.1070328           wvoff=2.0327775e-08       nfactor=1.7490489
+ wnfactor=-8.4088910e-08   cit=0.00                  cdsc=0.00
+ cdscb=0.00                cdscd=0.00                eta0=6.9138500e-03
+ weta0=-1.4884957e-09      etab=3.6088890e-04        wetab=3.9111110e-10
+ dsub=0.00                 pclm=1.3000000            pdiblc1=0.00
+ pdiblc2=8.0840000e-03     pdiblcb=0.00              drout=0.00
+ pscbe1=4.2400000e08       pscbe2=1.0000000e-05      pvag=0.00
+ delta=1.0000000e-02       alpha0=0.00               alpha1=0.001
+ beta0=7.97                kt1=-0.3605555            wkt1=3.0555526e-08
+ kt2=-9.0044460e-03        wkt2=-1.5995555e-08       at=2.0000000e05
+ ute=-2.2750001            wute=2.5000014e-07        ua1=5.8922510e-10
+ wua1=5.9214600e-16        ub1=-2.8687670e-18        wub1=-1.0123330e-24
+ uc1=-5.6000000e-11        kt1l=0.00                 prt=0
+ cj=cjn_na18               mj=0.29                   pb=0.45
+ cjsw=cjswn_na18           mjsw=0.01                 pbsw=0.15
+ cjswg=cjswgn_na18         mjswg=0.43                pbswg=0.55
+ tpb=2.5e-03               tpbsw=2.0e-04             tpbswg=2.4e-03
+ tcj=2.8e-03               tcjsw=3.0e-04             tcjswg=2.5e-03
+ js=1.0e-06                jsw=2.0e-12               n=1
+ xti=3                     cgdo=cgon_na18            cgso=cgon_na18
+ cgbo=0                    capmod=3                  nqsmod=0
+ elm=5                     xpart=1                   cgsl=cgln_na18
+ cgdl=cgln_na18            ckappa=0.6000000          cf=cfn_na18
+ clc=1.0000000e-07         cle=0.6000000             dlc=3.95e-8
+ dwc=0                     llc=0                     lwc=0
+ wlc=0                     wwc=-0.05084              lwlc=0
+ wwlc=0                    acde=0.4                  moin=15
+ noff=2.7                  voffcv=-0.1018            tlev=1
+ tlevc=1                   sa0=8.2e-07               sb0=8.2e-07
+ kvsat=-0.55               wlod=1.0e-07              tku0=0.1
+ ku0=-6.0e-08              llodku0=1                 wlodku0=1
+ lku0=2.5e-07              wku0=2.0e-07              pku0=5.0e-14
+ kvth0=4.0e-09             stk2=0                    steta0=0
+ lkvth0=-4.68e-11          wkvth0=7.0e-07            pkvth0=0
+ llodvth=1                 wlodvth=1                 lodk2=1
+ lodeta0=1                 noimod=2                  noia=5.54e+20
+ noib=5.00e+02             noic=1.00e-13             em=5.20e+06
+ ef=0.85                   minr=1e-3                 imax=0.01
+ imelt=0.01

     5: type=n
+ lmin=1.2000e-06-dxl_na18  lmax=1.0000e-05-dxl_na18  wmin=1.0000e-06-dxw_na18
+ wmax=1.0000e-05-dxw_na18  tnom=25.0                 version=3.24
+ tox=toxn_na18             toxm=toxn_na18            xj=1.5000001e-07
+ nch=1.6999999e17          lln=1.0000000             lwn=1.0000000
+ wln=1.0000000             wwn=-1.0000000            lint=2.5000000e-08
+ ll=0.00                   lw=0.00                   lwl=0.00
+ wint=0.00                 wl=0.00                   ww=0.00
+ wwl=0.00                  mobmod=1                  binunit=2
+ xl=-4e-08+dxl_na18        xw=0+dxw_na18             dwg=0.00
+ dwb=0.00                  ldif=6.50e-08             hdif=1.25e-07
+ rsh=10.5                  rd=0                      rs=0
+ rsc=0                     rdc=0                     vth0=-3.1518307e-02+dvthn_na18
+ lvth0=9.6528660e-08+dlvthn_na18                     wvth0=-3.2032780e-09+dwvthn_na18
+ pvth0=9.7223030e-15       k1=9.7580000e-02          k2=-2.6816377e-02
+ lk2=-3.4559360e-09        wk2=8.7744160e-09         pk2=2.2465495e-15
+ k3=0.00                   dvt0=0.00                 dvt1=0.00
+ dvt2=0.00                 dvt0w=0.00                dvt1w=0.00
+ dvt2w=0.00                nlx=0.00                  w0=0.00
+ k3b=0.00                  ngate=4.0000000e20        vsat=9.0562200e04
+ lvsat=9.3528620e-02       wvsat=9.4378040e-03       pvsat=-9.3528630e-08
+ ua=6.2003150e-10          lua=-7.0577900e-16        wua=5.1021240e-16
+ pua=-2.7991625e-22        ub=2.0970474e-18          lub=1.9222419e-25
+ wub=-9.7272920e-25        pub=5.5778260e-31         uc=-1.3465550e-11
+ luc=-3.7333630e-19        wuc=-3.7450060e-20        puc=3.7333630e-25
+ rdsw=2.2000000e02         prwb=0.00                 prwg=0.00
+ wr=1.0000000              u0=5.3308270e-02          lu0=-5.9274400e-09
+ wu0=-4.4276990e-09        pu0=1.6200019e-15         a0=4.6502050
+ la0=-4.4541300e-06        wa0=4.7918160e-07         pa0=2.0129105e-13
+ keta=2.0051282e-02        lketa=-2.6477908e-08      wketa=1.8295501e-09
+ pketa=-2.6003815e-14      a1=0.00                   a2=1.0000000
+ ags=0.8772523             lags=2.4351832e-06        wags=-1.7415722e-07
+ pags=-5.5161870e-13       b0=0.00                   b1=0.00
+ voff=-0.1087187           lvoff=1.6707782e-08       wvoff=2.3690710e-08
+ pvoff=-3.3326680e-14      nfactor=1.7734414         lnfactor=-2.4172996e-07
+ wnfactor=-1.3711941e-07   pnfactor=5.2553260e-13    cit=0.00
+ cdsc=0.00                 cdscb=0.00                cdscd=0.00
+ eta0=7.7026170e-03        leta0=-7.8166880e-09      weta0=-2.2236102e-09
+ peta0=7.2849910e-15       etab=3.3353140e-04        letab=2.7111349e-10
+ wetab=3.4934590e-10       petab=4.1389270e-16       dsub=0.00
+ pclm=1.3000000            pdiblc1=0.00              pdiblc2=-4.3637780e-03
+ lpdiblc2=1.2335748e-07    wpdiblc2=-8.0521900e-09   ppdiblc2=7.9797250e-14
+ pdiblcb=0.00              drout=0.00                pscbe1=4.2400000e08
+ pscbe2=1.0000000e-05      pvag=0.00                 delta=1.0000000e-02
+ alpha0=0.00               alpha1=0.001              beta0=7.97
+ kt1=-0.3742203            lkt1=1.3541785e-07        wkt1=3.9805520e-08
+ pkt1=-9.1667430e-14       kt2=-9.2359750e-03        lkt2=2.2944657e-09
+ wkt2=-1.8718138e-08       pkt2=2.6980801e-14        at=2.1315392e05
+ lat=-0.1303554            wat=-2.6846007e-03        pat=2.6604408e-08
+ ute=-2.3910890            lute=1.1504427e-06        wute=3.1409587e-07
+ pute=-6.3518830e-13       ua1=1.7625405e-10         lua1=4.0925450e-15
+ wua1=8.8230710e-16        pua1=-2.8754973e-21       ub1=-2.5243470e-18
+ lub1=-3.4132050e-24       wub1=-1.2383615e-24       pub1=2.2399444e-30
+ uc1=-5.6000000e-11        kt1l=0.00                 prt=0
+ cj=cjn_na18               mj=0.29                   pb=0.45
+ cjsw=cjswn_na18           mjsw=0.01                 pbsw=0.15
+ cjswg=cjswgn_na18         mjswg=0.43                pbswg=0.55
+ tpb=2.5e-03               tpbsw=2.0e-04             tpbswg=2.4e-03
+ tcj=2.8e-03               tcjsw=3.0e-04             tcjswg=2.5e-03
+ js=1.0e-06                jsw=2.0e-12               n=1
+ xti=3                     cgdo=cgon_na18            cgso=cgon_na18
+ cgbo=0                    capmod=3                  nqsmod=0
+ elm=5                     xpart=1                   cgsl=cgln_na18
+ cgdl=cgln_na18            ckappa=0.6000000          cf=cfn_na18
+ clc=1.0000000e-07         cle=0.6000000             dlc=3.95e-8
+ dwc=0                     llc=0                     lwc=0
+ wlc=0                     wwc=-0.05084              lwlc=0
+ wwlc=0                    acde=0.4                  moin=15
+ noff=2.7                  voffcv=-0.1018            tlev=1
+ tlevc=1                   sa0=8.2e-07               sb0=8.2e-07
+ kvsat=-0.55               wlod=1.0e-07              tku0=0.1
+ ku0=-6.0e-08              llodku0=1                 wlodku0=1
+ lku0=2.5e-07              wku0=2.0e-07              pku0=5.0e-14
+ kvth0=4.0e-09             stk2=0                    steta0=0
+ lkvth0=-4.68e-11          wkvth0=7.0e-07            pkvth0=0
+ llodvth=1                 wlodvth=1                 lodk2=1
+ lodeta0=1                 noimod=2                  noia=5.54e+20
+ noib=5.00e+02             noic=1.00e-13             em=5.20e+06
+ ef=0.85                   minr=1e-3                 imax=0.01
+ imelt=0.01

     6: type=n
+ lmin=8.0e-07              lmax=1.2000e-06-dxl_na18  wmin=1.0000e-06-dxw_na18
+ wmax=1.0000e-05-dxw_na18  tnom=25.0                 version=3.24
+ tox=toxn_na18             toxm=toxn_na18            xj=1.5000001e-07
+ nch=1.6999999e17          lln=1.0000000             lwn=1.0000000
+ wln=1.0000000             wwn=-1.0000000            lint=2.5000000e-08
+ ll=0.00                   lw=0.00                   lwl=0.00
+ wint=0.00                 wl=0.00                   ww=0.00
+ wwl=0.00                  mobmod=1                  binunit=2
+ xl=-4e-08+dxl_na18        xw=0+dxw_na18             dwg=0.00
+ dwb=0.00                  ldif=6.50e-08             hdif=1.25e-07
+ rsh=10.5                  rd=0                      rs=0
+ rsc=0                     rdc=0                     vth0=2.1616552e-02+dvthn_na18
+ lvth0=3.7548960e-08+dlvthn_na18                     wvth0=5.2234430e-09+dwvthn_na18
+ pvth0=3.6864520e-16       k1=9.7580000e-02          k2=-3.4838170e-02
+ lk2=5.4482520e-09         wk2=1.9011649e-08         pk2=-9.1167780e-15
+ k3=0.00                   dvt0=0.00                 dvt1=0.00
+ dvt2=0.00                 dvt0w=0.00                dvt1w=0.00
+ dvt2w=0.00                nlx=0.00                  w0=0.00
+ k3b=0.00                  ngate=4.0000000e20        vsat=2.3664753e05
+ lvsat=-6.8626080e-02      wvsat=-0.1366475          pvsat=6.8626080e-08
+ ua=9.1639250e-12          lua=-2.7716053e-17        wua=1.1811775e-16
+ pua=1.5530874e-22         ub=2.5534695e-18          lub=-3.1440436e-25
+ wub=-3.8746950e-25        pub=-9.1855660e-32        uc=-2.4429805e-11
+ luc=1.1796985e-17         wuc=1.0342333e-17         puc=-1.1148222e-23
+ rdsw=2.2000000e02         prwb=0.00                 prwg=0.00
+ wr=1.0000000              u0=4.9101070e-02          lu0=-1.2574447e-09
+ wu0=-4.1010710e-09        pu0=1.2574448e-15         a0=0.7580220
+ la0=-1.3380674e-07        wa0=2.9353797e-07         pa0=4.0735520e-13
+ keta=-1.0862604e-02       lketa=7.8365120e-09       wketa=-4.5562000e-08
+ pketa=2.6600794e-14       a1=0.00                   a2=1.0000000
+ ags=5.6595720             lags=-2.8731915e-06       wags=-2.1615715e-06
+ pags=1.6544112e-12        b0=0.00                   b1=0.00
+ voff=-7.3063980e-02       lvoff=-2.2868978e-08      wvoff=-3.3020160e-08
+ pvoff=2.9622375e-14       nfactor=1.3505168         lnfactor=2.2771631e-07
+ wnfactor=5.4148330e-07    pnfactor=-2.2771631e-13   cit=0.00
+ cdsc=0.00                 cdscb=0.00                cdscd=0.00
+ eta0=-1.9959002e-03       leta0=2.9486658e-09       weta0=5.9354760e-09
+ peta0=-1.7715947e-15      etab=-8.6445280e-05       letab=7.3728710e-10
+ wetab=2.4844453e-09       petab=-1.9560669e-15      dsub=0.00
+ pclm=2.0930007            lpclm=-8.8023030e-07      wpclm=-1.5860007e-06
+ ppclm=1.7604605e-12       pdiblc1=0.00              pdiblc2=7.8666180e-02
+ lpdiblc2=3.1194194e-08    wpdiblc2=1.2037869e-07    ppdiblc2=-6.2761010e-14
+ pdiblcb=0.00              drout=0.00                pscbe1=4.2400000e08
+ pscbe2=1.0000000e-05      pvag=0.00                 delta=1.0000000e-02
+ alpha0=0.00               alpha1=0.001              beta0=7.97
+ kt1=-0.2927940            lkt1=4.5034690e-08        wkt1=-4.3929950e-08
+ pkt1=1.2789325e-15        kt2=-1.0967162e-02        lkt2=4.2160790e-09
+ wkt2=1.4657562e-08        pkt2=-1.0066224e-14       at=2.1116256e05
+ lat=-0.1281450            wat=3.6377440e-02         pat=-1.6754466e-08
+ ute=-1.2948588            lute=-6.6372710e-08       wute=-3.1281715e-07
+ pute=6.0685090e-14        ua1=5.0801960e-09         lua1=-1.3508313e-15
+ wua1=-2.9622751e-16       pua1=-1.5673238e-21       ub1=-6.7517270e-18
+ lub1=1.2791876e-24        wub1=-3.9480130e-24       pub1=5.2476570e-30
+ uc1=-5.6000000e-11        kt1l=0.00                 prt=0
+ cj=cjn_na18               mj=0.29                   pb=0.45
+ cjsw=cjswn_na18           mjsw=0.01                 pbsw=0.15
+ cjswg=cjswgn_na18         mjswg=0.43                pbswg=0.55
+ tpb=2.5e-03               tpbsw=2.0e-04             tpbswg=2.4e-03
+ tcj=2.8e-03               tcjsw=3.0e-04             tcjswg=2.5e-03
+ js=1.0e-06                jsw=2.0e-12               n=1
+ xti=3                     cgdo=cgon_na18            cgso=cgon_na18
+ cgbo=0                    capmod=3                  nqsmod=0
+ elm=5                     xpart=1                   cgsl=cgln_na18
+ cgdl=cgln_na18            ckappa=0.6000000          cf=cfn_na18
+ clc=1.0000000e-07         cle=0.6000000             dlc=3.95e-8
+ dwc=0                     llc=0                     lwc=0
+ wlc=0                     wwc=-0.05084              lwlc=0
+ wwlc=0                    acde=0.4                  moin=15
+ noff=2.7                  voffcv=-0.1018            tlev=1
+ tlevc=1                   sa0=8.2e-07               sb0=8.2e-07
+ kvsat=-0.55               wlod=1.0e-07              tku0=0.1
+ ku0=-6.0e-08              llodku0=1                 wlodku0=1
+ lku0=2.5e-07              wku0=2.0e-07              pku0=5.0e-14
+ kvth0=4.0e-09             stk2=0                    steta0=0
+ lkvth0=-4.68e-11          wkvth0=7.0e-07            pkvth0=0
+ llodvth=1                 wlodvth=1                 lodk2=1
+ lodeta0=1                 noimod=2                  noia=5.54e+20
+ noib=5.00e+02             noic=1.00e-13             em=5.20e+06
+ ef=0.85                   minr=1e-3                 imax=0.01
+ imelt=0.01

     7: type=n
+ lmin=1.0000e-05-dxl_na18  lmax=9.001e-04            wmin=5.0e-07
+ wmax=1.0000e-06-dxw_na18  tnom=25.0                 version=3.24
+ tox=toxn_na18             toxm=toxn_na18            xj=1.5000001e-07
+ nch=1.6999999e17          lln=1.0000000             lwn=1.0000000
+ wln=1.0000000             wwn=-1.0000000            lint=2.5000000e-08
+ ll=0.00                   lw=0.00                   lwl=0.00
+ wint=0.00                 wl=0.00                   ww=0.00
+ wwl=0.00                  mobmod=1                  binunit=2
+ xl=-4e-08+dxl_na18        xw=0+dxw_na18             dwg=0.00
+ dwb=0.00                  ldif=6.50e-08             hdif=1.25e-07
+ rsh=10.5                  rd=0                      rs=0
+ rsc=0                     rdc=0                     vth0=-2.3333333e-02+dvthn_na18
+ wvth0=-6.6666680e-10+dwvthn_na18                    lvth0=0+dlvthn_na18
+ k1=9.7580000e-02          k2=-2.2422666e-02         wk2=4.2586660e-09
+ k3=0.00                   dvt0=0.00                 dvt1=0.00
+ dvt2=0.00                 dvt0w=0.00                dvt1w=0.00
+ dvt2w=0.00                nlx=0.00                  w0=0.00
+ k3b=0.00                  ngate=4.0000000e20        vsat=-1.6666663e05
+ wvsat=0.2666667           ua=5.3966200e-10          wua=4.9111720e-16
+ ub=1.9433335e-18          wub=-7.4333340e-25        uc=-2.5056693e-12
+ wuc=-1.0997332e-17        rdsw=2.2000000e02         prwb=0.00
+ prwg=0.00                 wr=1.0000000              u0=4.5409870e-02
+ wu0=3.0360514e-09         a0=6.5004000              wa0=-1.8001600e-06
+ keta=2.7621668e-02        wketa=-1.1036668e-08      a1=0.00
+ a2=1.0000000              ags=1.0219367             wags=-1.2877469e-07
+ b0=0.00                   b1=0.00                   voff=-8.5641670e-02
+ wvoff=-1.0633320e-09      nfactor=1.6277333         wnfactor=3.7226680e-08
+ cit=0.00                  cdsc=0.00                 cdscb=0.00
+ cdscd=0.00                eta0=4.6508430e-03        weta0=7.7451050e-10
+ etab=5.4233040e-04        wetab=2.0966966e-10       dsub=0.00
+ pclm=1.3000000            pdiblc1=0.00              pdiblc2=1.3473318e-02
+ wpdiblc2=-5.3893180e-09   pdiblcb=0.00              drout=0.00
+ pscbe1=4.2400000e08       pscbe2=1.0000000e-05      pvag=0.00
+ delta=1.0000000e-02       alpha0=0.00               alpha1=0.001
+ beta0=7.97                kt1=-0.3269200            wkt1=-3.0799907e-09
+ kt2=-2.3706665e-02        wkt2=-1.2933351e-09       at=3.2288400e05
+ wat=-0.1228840            ute=-1.8947691            wute=-1.3023075e-07
+ ua1=1.9683484e-09         wua1=-7.8697730e-16       ub1=-4.7860340e-18
+ wub1=9.0493340e-25        uc1=-9.3146660e-11        wuc1=3.7146660e-17
+ kt1l=0.00                 prt=0                     cj=cjn_na18
+ mj=0.29                   pb=0.45                   cjsw=cjswn_na18
+ mjsw=0.01                 pbsw=0.15                 cjswg=cjswgn_na18
+ mjswg=0.43                pbswg=0.55                tpb=2.5e-03
+ tpbsw=2.0e-04             tpbswg=2.4e-03            tcj=2.8e-03
+ tcjsw=3.0e-04             tcjswg=2.5e-03            js=1.0e-06
+ jsw=2.0e-12               n=1                       xti=3
+ cgdo=cgon_na18            cgso=cgon_na18            cgbo=0
+ capmod=3                  nqsmod=0                  elm=5
+ xpart=1                   cgsl=cgln_na18            cgdl=cgln_na18
+ ckappa=0.6000000          cf=cfn_na18               clc=1.0000000e-07
+ cle=0.6000000             dlc=3.95e-8               dwc=0
+ llc=0                     lwc=0                     wlc=0
+ wwc=-0.05084              lwlc=0                    wwlc=0
+ acde=0.4                  moin=15                   noff=2.7
+ voffcv=-0.1018            tlev=1                    tlevc=1
+ sa0=8.2e-07               sb0=8.2e-07               kvsat=-0.55
+ wlod=1.0e-07              tku0=0.1                  ku0=-6.0e-08
+ llodku0=1                 wlodku0=1                 lku0=2.5e-07
+ wku0=2.0e-07              pku0=5.0e-14              kvth0=4.0e-09
+ stk2=0                    steta0=0                  lkvth0=-4.68e-11
+ wkvth0=7.0e-07            pkvth0=0                  llodvth=1
+ wlodvth=1                 lodk2=1                   lodeta0=1
+ noimod=2                  noia=5.54e+20             noib=5.00e+02
+ noic=1.00e-13             em=5.20e+06               ef=0.85
+ minr=1e-3                 imax=0.01                 imelt=0.01

     8: type=n
+ lmin=1.2000e-06-dxl_na18  lmax=1.0000e-05-dxl_na18  wmin=5.0e-07
+ wmax=1.0000e-06-dxw_na18  tnom=25.0                 version=3.24
+ tox=toxn_na18             toxm=toxn_na18            xj=1.5000001e-07
+ nch=1.6999999e17          lln=1.0000000             lwn=1.0000000
+ wln=1.0000000             wwn=-1.0000000            lint=2.5000000e-08
+ ll=0.00                   lw=0.00                   lwl=0.00
+ wint=0.00                 wl=0.00                   ww=0.00
+ wwl=0.00                  mobmod=1                  binunit=2
+ xl=-4e-08+dxl_na18        xw=0+dxw_na18             dwg=0.00
+ dwb=0.00                  ldif=6.50e-08             hdif=1.25e-07
+ rsh=10.5                  rd=0                      rs=0
+ rsc=0                     rdc=0                     vth0=-3.4223120e-02+dvthn_na18
+ lvth0=1.0791766e-07+dlvthn_na18                     wvth0=-4.9847860e-10+dwvthn_na18
+ pvth0=-1.6666885e-15      k1=9.7580000e-02          k2=-2.2717426e-02
+ lk2=2.9210674e-09         wk2=4.6754630e-09         pk2=-4.1304540e-15
+ k3=0.00                   dvt0=0.00                 dvt1=0.00
+ dvt2=0.00                 dvt0w=0.00                dvt1w=0.00
+ dvt2w=0.00                nlx=0.00                  w0=0.00
+ k3b=0.00                  ngate=4.0000000e20        vsat=-2.0030309e05
+ lvsat=0.3333364           wvsat=0.3003031           pvsat=-3.3333640e-07
+ ua=6.3649250e-10          lua=-9.5959030e-16        wua=4.9375140e-16
+ pua=-2.6105099e-23        ub=1.8689131e-18          lub=7.3750680e-25
+ wub=-7.4459480e-25        pub=1.2500063e-32         uc=-4.3844580e-12
+ luc=1.8618795e-17         wuc=-9.1185440e-18        puc=-1.8618796e-23
+ rdsw=2.2000000e02         prwb=0.00                 prwg=0.00
+ wr=1.0000000              u0=4.5461570e-02          lu0=-5.1233920e-10
+ wu0=3.4190080e-09         pu0=-3.7950990e-15        a0=7.2156440
+ la0=-7.0880660e-06        wa0=-2.0862576e-06        pa0=2.8352262e-12
+ keta=3.4763730e-02        lketa=-7.0777730e-08      wketa=-1.2882887e-08
+ pketa=1.8296000e-14       a1=0.00                   a2=1.0000000
+ ags=0.7472039             lags=2.7226042e-06        wags=-4.4108870e-08
+ pags=-8.3903940e-13       b0=0.00                   b1=0.00
+ voff=-8.2445160e-02       lvoff=-3.1677380e-08      wvoff=-2.5828544e-09
+ pvoff=1.5058470e-14       nfactor=1.5625796         lnfactor=6.4567270e-07
+ wnfactor=7.3742350e-08    pnfactor=-3.6187010e-13   cit=0.00
+ cdsc=0.00                 cdscb=0.00                cdscd=0.00
+ eta0=5.3104990e-03        leta0=-6.5371840e-09      weta0=1.6850792e-10
+ peta0=6.0054860e-15       etab=4.2153340e-04        letab=1.1970981e-09
+ wetab=2.6134386e-10       petab=-5.1209170e-16      dsub=0.00
+ pclm=1.3169863            lpclm=-1.6833492e-07      wpclm=-1.6986370e-08
+ ppclm=1.6833490e-13       pdiblc1=0.00              pdiblc2=-1.9852392e-02
+ lpdiblc2=3.3025790e-07    wpdiblc2=7.4364150e-09    ppdiblc2=-1.2710311e-13
+ pdiblcb=0.00              drout=0.00                pscbe1=4.2400000e08
+ pscbe2=1.0000000e-05      pvag=0.00                 delta=1.0000000e-02
+ alpha0=0.00               alpha1=0.001              beta0=7.97
+ kt1=-0.3301306            lkt1=3.1817000e-08        wkt1=-4.2841720e-09
+ pkt1=1.1933432e-14        kt2=-2.7230073e-02        lkt2=3.4916990e-08
+ wkt2=-7.2404000e-10       pkt2=-5.6417180e-15       at=3.4321930e05
+ lat=-0.2015235            wat=-0.1327501            pat=9.7772560e-08
+ ute=-1.9207240            lute=2.5721360e-07        wute=-1.5626919e-07
+ pute=2.5804090e-13        ua1=1.9225337e-09         lua1=4.5402600e-16
+ wua1=-8.6397250e-16       pua1=7.6302110e-22        ub1=-4.6478230e-18
+ lub1=-1.3696628e-24       wub1=8.8511480e-25        pub1=1.9640189e-31
+ uc1=-9.5477670e-11        luc1=2.3100215e-17        wuc1=3.9477670e-17
+ puc1=-2.3100212e-23       kt1l=0.00                 prt=0
+ cj=cjn_na18               mj=0.29                   pb=0.45
+ cjsw=cjswn_na18           mjsw=0.01                 pbsw=0.15
+ cjswg=cjswgn_na18         mjswg=0.43                pbswg=0.55
+ tpb=2.5e-03               tpbsw=2.0e-04             tpbswg=2.4e-03
+ tcj=2.8e-03               tcjsw=3.0e-04             tcjswg=2.5e-03
+ js=1.0e-06                jsw=2.0e-12               n=1
+ xti=3                     cgdo=cgon_na18            cgso=cgon_na18
+ cgbo=0                    capmod=3                  nqsmod=0
+ elm=5                     xpart=1                   cgsl=cgln_na18
+ cgdl=cgln_na18            ckappa=0.6000000          cf=cfn_na18
+ clc=1.0000000e-07         cle=0.6000000             dlc=3.95e-8
+ dwc=0                     llc=0                     lwc=0
+ wlc=0                     wwc=-0.05084              lwlc=0
+ wwlc=0                    acde=0.4                  moin=15
+ noff=2.7                  voffcv=-0.1018            tlev=1
+ tlevc=1                   sa0=8.2e-07               sb0=8.2e-07
+ kvsat=-0.55               wlod=1.0e-07              tku0=0.1
+ ku0=-6.0e-08              llodku0=1                 wlodku0=1
+ lku0=2.5e-07              wku0=2.0e-07              pku0=5.0e-14
+ kvth0=4.0e-09             stk2=0                    steta0=0
+ lkvth0=-4.68e-11          wkvth0=7.0e-07            pkvth0=0
+ llodvth=1                 wlodvth=1                 lodk2=1
+ lodeta0=1                 noimod=2                  noia=5.54e+20
+ noib=5.00e+02             noic=1.00e-13             em=5.20e+06
+ ef=0.85                   minr=1e-3                 imax=0.01
+ imelt=0.01

     9: type=n
+ lmin=8.0e-07              lmax=1.2000e-06-dxl_na18  wmin=5.0e-07
+ wmax=1.0000e-06-dxw_na18  tnom=25.0                 version=3.24
+ tox=toxn_na18             toxm=toxn_na18            xj=1.5000001e-07
+ nch=1.6999999e17          lln=1.0000000             lwn=1.0000000
+ wln=1.0000000             wwn=-1.0000000            lint=2.5000000e-08
+ ll=0.00                   lw=0.00                   lwl=0.00
+ wint=0.00                 wl=0.00                   ww=0.00
+ wwl=0.00                  mobmod=1                  binunit=2
+ xl=-4e-08+dxl_na18        xw=0+dxw_na18             dwg=0.00
+ dwb=0.00                  ldif=6.50e-08             hdif=1.25e-07
+ rsh=10.5                  rd=0                      rs=0
+ rsc=0                     rdc=0                     vth0=2.8026666e-02+dvthn_na18
+ lvth0=3.8820400e-08+dlvthn_na18                     wvth0=-1.1866689e-09+dwvthn_na18
+ pvth0=-9.0279850e-16      k1=9.7596270e-02          lk1=-1.8053619e-11
+ wk1=-1.6264521e-11        pk1=1.8053617e-17         k2=-1.4821533e-02
+ lk2=-5.8433730e-09        wk2=-1.0049868e-09        pk2=2.1748454e-15
+ k3=0.00                   dvt0=0.00                 dvt1=0.00
+ dvt2=0.00                 dvt0w=0.00                dvt1w=0.00
+ dvt2w=0.00                nlx=0.00                  w0=0.00
+ k3b=0.00                  ngate=4.0000000e20        vsat=1.0000000e05
+ ua=-7.0800520e-10         lua=5.3280190e-16         wua=8.3528670e-16
+ pua=-4.0520910e-22        ub=3.5151600e-18          lub=-1.0898277e-24
+ wub=-1.3491601e-24        pub=6.8356770e-31         uc=4.2544120e-11
+ luc=-3.3471920e-17        wuc=-5.6631580e-17        puc=3.4120680e-23
+ rdsw=2.2000000e02         prwb=0.00                 prwg=0.00
+ wr=1.0000000              u0=4.5000000e-02          a0=0.4192664
+ la0=4.5591410e-07         wa0=6.3229340e-07         pa0=-1.8236564e-13
+ keta=-6.4432870e-02       lketa=3.9330480e-08       wketa=8.0082610e-09
+ pketa=-4.8931720e-15      a1=0.00                   a2=1.0000000
+ ags=4.8266670             lags=-1.8056002e-06       wags=-1.3286667e-06
+ pags=5.8682000e-13        b0=0.00                   b1=0.00
+ voff=-0.1304566           lvoff=2.1615293e-08       wvoff=2.4372424e-08
+ pvoff=-1.4861893e-14      nfactor=2.3288937         lnfactor=-2.0493562e-07
+ wnfactor=-4.3689340e-07   pnfactor=2.0493561e-13    cit=0.00
+ cdsc=0.00                 cdscb=0.00                cdscd=0.00
+ eta0=-4.1098160e-03       leta0=3.9193660e-09       weta0=8.0493910e-09
+ peta0=-2.7422944e-15      etab=2.8972174e-03        letab=-1.5509111e-09
+ wetab=-4.9921720e-10      petab=3.3213100e-16       dsub=0.00
+ pclm=0.2487063            lpclm=1.0174559e-06       wpclm=2.5829340e-07
+ ppclm=-1.3722567e-13      pdiblc1=0.00              pdiblc2=0.3169414
+ lpdiblc2=-4.3583360e-08   wpdiblc2=-1.1789658e-07   ppdiblc2=1.2016543e-14
+ pdiblcb=0.00              drout=0.00                pscbe1=4.2400000e08
+ pscbe2=1.0000000e-05      pvag=0.00                 delta=1.0000000e-02
+ alpha0=0.00               alpha1=0.001              beta0=7.97
+ kt1=-0.3690140            lkt1=7.4977510e-08        wkt1=3.2290000e-08
+ pkt1=-2.8663896e-14       kt2=1.5198542e-02         lkt2=-1.2178776e-08
+ wkt2=-1.1508138e-08       pkt2=6.3286310e-15        at=3.6542710e05
+ lat=-0.2261740            wat=-0.1178871            pat=8.1274630e-08
+ ute=-1.8960800            lute=2.2985867e-07        wute=2.8840395e-07
+ pute=-2.3554626e-13       ua1=5.1767330e-09         lua1=-3.1581346e-15
+ wua1=-3.9276400e-16       pua1=2.3997957e-22        ub1=-1.4692812e-17
+ lub1=9.7802740e-24        wub1=3.9930700e-24        pub1=-3.2534290e-30
+ uc1=-9.7440010e-11        luc1=2.5278406e-17        wuc1=4.1440000e-17
+ puc1=-2.5278402e-23       kt1l=0.00                 prt=0
+ cj=cjn_na18               mj=0.29                   pb=0.45
+ cjsw=cjswn_na18           mjsw=0.01                 pbsw=0.15
+ cjswg=cjswgn_na18         mjswg=0.43                pbswg=0.55
+ tpb=2.5e-03               tpbsw=2.0e-04             tpbswg=2.4e-03
+ tcj=2.8e-03               tcjsw=3.0e-04             tcjswg=2.5e-03
+ js=1.0e-06                jsw=2.0e-12               n=1
+ xti=3                     cgdo=cgon_na18            cgso=cgon_na18
+ cgbo=0                    capmod=3                  nqsmod=0
+ elm=5                     xpart=1                   cgsl=cgln_na18
+ cgdl=cgln_na18            ckappa=0.6000000          cf=cfn_na18
+ clc=1.0000000e-07         cle=0.6000000             dlc=3.95e-8
+ dwc=0                     llc=0                     lwc=0
+ wlc=0                     wwc=-0.05084              lwlc=0
+ wwlc=0                    acde=0.4                  moin=15
+ noff=2.7                  voffcv=-0.1018            tlev=1
+ tlevc=1                   sa0=8.2e-07               sb0=8.2e-07
+ kvsat=-0.55               wlod=1.0e-07              tku0=0.1
+ ku0=-6.0e-08              llodku0=1                 wlodku0=1
+ lku0=2.5e-07              wku0=2.0e-07              pku0=5.0e-14
+ kvth0=4.0e-09             stk2=0                    steta0=0
+ lkvth0=-4.68e-11          wkvth0=7.0e-07            pkvth0=0
+ llodvth=1                 wlodvth=1                 lodk2=1
+ lodeta0=1                 noimod=2                  noia=5.54e+20
+ noib=5.00e+02             noic=1.00e-13             em=5.20e+06
+ ef=0.85                   minr=1e-3                 imax=0.01
+ imelt=0.01

     }
endsection mos_na18
//
//
//
//
//  *************************************************************
//                                                              *
//                3.3V NATIVE NMOS DEVICE LIB                   *
//                                                              *
//  *************************************************************
//

section mos_na33
//
//  *****************************************************************************************
//
//             *
//                                3.3V NATIVE NMOS DEVICE MODELS
//             *
//
//             *
//  *****************************************************************************************

model nch_na33 bsim3v3  {
     1: type=n
+ lmin=1.0000e-05-dxl_na33  lmax=9.001e-04            wmin=1.0000e-05-dxw_na33
+ wmax=9.001e-04            tnom=25.0                 version=3.24
+ tox=toxn_na33             toxm=toxn_na33            xj=1.5000001e-07
+ nch=6.1500000e15          lln=1.0000000             lwn=1.0000000
+ wln=1.0000000             wwn=-1                    lint=2.9650000e-08
+ ll=0.00                   lw=0.00                   lwl=0.00
+ wint=3.9850000e-08        wl=0.00                   ww=0.00
+ wwl=0.00                  mobmod=1                  binunit=2
+ xl=-0.045e-06+dxl_na33    xw=0+dxw_na33             dwg=0.00
+ dwb=0.00                  ldif=6.50e-08             hdif=hdifn_na33
+ rsh=rshn_na33             rd=0                      rs=0
+ rsc=0                     rdc=0                     vth0=-0.1400000+dvthn_na33
+ lvth0=0+dlvthn_na33       k1=8.0000000e-02          k2=-6.1818000e-03
+ k3=7.7100000              dvt0=0.2160000            dvt1=0.1790000
+ dvt2=0.1040000            dvt0w=0.00                dvt1w=0.00
+ dvt2w=0.00                nlx=0.00                  w0=1.8240000e-06
+ k3b=-16.6000000           ngate=2.0000000e20        vsat=1.0000000e05
+ ua=6.6173800e-10          ub=1.3833000e-18          uc=2.0000000e-12
+ rdsw=2.5000000e02         prwb=0.00                 prwg=0.00
+ wr=1.0000000              u0=5.1500000e-02+du0n_na33
+ a0=0.8000000              keta=-1.1600000e-02       a1=0.00
+ a2=0.9900000              ags=1.6200000             b0=0.00
+ b1=0.00                   voff=-0.1150000           nfactor=1.0000000
+ cit=0.00                  cdsc=0.00                 cdscb=0.00
+ cdscd=0.00                eta0=1.0000000e-04        etab=1.3125000e-03
+ dsub=0.00                 pclm=1.0000000            pdiblc1=3.0000000e-03
+ pdiblc2=1.0000000e-04     pdiblcb=1.0000000e-02     drout=0.00
+ pscbe1=4.0000000e08       pscbe2=1.0000000e-06      pvag=0.00
+ delta=2.5000130e-03       alpha0=0.00               alpha1=0.0048
+ beta0=9.5                 kt1=-0.2876400            kt2=-1.8618530e-02
+ at=5.0000000e04           ute=-1.4732350            ua1=3.0072000e-09
+ ub1=-5.0406560e-18        uc1=-1.4399940e-12        kt1l=0.00
+ prt=0                     cj=cjn_na33               mj=0.315
+ pb=0.4                    cjsw=cjswn_na33           mjsw=0.02
+ pbsw=0.125                cjswg=cjswgn_na33         mjswg=0.414
+ pbswg=0.479               tpb=2.3e-03               tpbsw=2.0e-04
+ tpbswg=2.4e-03            tcj=3.0e-03               tcjsw=2.0e-04
+ tcjswg=3.5e-03            js=9.00e-07               jsw=1.50e-12
+ n=1                       xti=3                     cgdo=cgon_na33
+ cgso=cgon_na33            cgbo=0                    capmod=3
+ nqsmod=0                  elm=5                     xpart=1
+ cgsl=cgln_na33            cgdl=cgln_na33            ckappa=0.6000000
+ cf=cfn_na33               clc=1.0000000e-07         cle=0.6000000
+ dlc=2.746e-08             dwc=6.0835e-09            llc=-1.776e-16
+ lwc=-2.58e-16             wlc=0                     wwc=-0.0238
+ lwlc=0                    wwlc=0                    acde=0.4
+ moin=18                   noff=2.5                  voffcv=-0.28
+ tlev=1                    tlevc=1                   sa0=8.2e-07
+ sb0=8.2e-07               kvsat=0.28                wlod=1.5e-07
+ tku0=0.1                  ku0=-9.0e-08              llodku0=1
+ wlodku0=1                 lku0=9.0e-07              wku0=7.0e-07
+ pku0=5.0e-14              kvth0=0                   stk2=0
+ steta0=0                  lkvth0=0                  wkvth0=0
+ pkvth0=0                  llodvth=1                 wlodvth=1
+ lodk2=1                   lodeta0=1                 noia=1.55e+19
+ noib=2.96e+04             noic=2.50e-12             em=4.02e+07
+ ef=0.85                   noimod=2                  minr=1e-3
+ imax=0.01                 imelt=0.01

     2: type=n
+ lmin=1.2e-06              lmax=1.0000e-05-dxl_na33  wmin=1.0000e-05-dxw_na33
+ wmax=9.001e-04            tnom=25.0                 version=3.24
+ tox=toxn_na33             toxm=toxn_na33            xj=1.5000001e-07
+ nch=6.1500000e15          lln=1.0000000             lwn=1.0000000
+ wln=1.0000000             wwn=-1                    lint=2.9650000e-08
+ ll=0.00                   lw=0.00                   lwl=0.00
+ wint=3.9850000e-08        wl=0.00                   ww=0.00
+ wwl=0.00                  mobmod=1                  binunit=2
+ xl=-0.045e-06+dxl_na33    xw=0+dxw_na33             dwg=0.00
+ dwb=0.00                  ldif=6.50e-08             hdif=hdifn_na33
+ rsh=rshn_na33             rd=0                      rs=0
+ rsc=0                     rdc=0                     vth0=-0.1400000+dvthn_na33
+ lvth0=0+dlvthn_na33       k1=8.0000000e-02          k2=-5.5564130e-03
+ lk2=-6.1886420e-09        k3=7.7100000              dvt0=0.2160000
+ dvt1=0.1790000            dvt2=0.1040000            dvt0w=0.00
+ dvt1w=0.00                dvt2w=0.00                nlx=0.00
+ w0=1.8244981e-06          lw0=-4.9285970e-15        k3b=-16.6000000
+ ngate=2.0000000e20        vsat=1.0074707e05         lvsat=-7.3927630e-03
+ ua=6.6502440e-10          lua=-3.2521720e-17        ub=1.2551579e-18
+ lub=1.2680557e-24         uc=2.0000000e-12          rdsw=2.5000000e02
+ prwb=0.00                 prwg=0.00                 wr=1.0000000
+ u0=5.1313230e-02+du0n_na33                          lu0=1.8481907e-09
+ a0=0.8622557              la0=-6.1606360e-07        keta=-1.1626997e-02
+ lketa=2.6715591e-10       a1=0.00                   a2=0.9900000
+ ags=1.7843549             lags=-1.6264078e-06       b0=0.00
+ b1=0.00                   voff=-0.1159961           lvoff=9.8570190e-09
+ nfactor=0.8754886         lnfactor=1.2321271e-06    cit=0.00
+ cdsc=0.00                 cdscb=0.00                cdscd=0.00
+ eta0=-1.1073535e-03       leta0=1.1947605e-08       etab=1.3835640e-03
+ letab=-7.0322720e-10      dsub=0.00                 pclm=1.0000000
+ pdiblc1=2.8754885e-03     lpdiblc1=1.2321274e-09    pdiblc2=1.0000000e-04
+ pdiblcb=1.0000000e-02     drout=0.00                pscbe1=4.0000000e08
+ pscbe2=1.0000000e-06      pvag=0.00                 delta=2.5000146e-03
+ alpha0=0.00               alpha1=0.0048             beta0=9.5
+ kt1=-0.2840591            lkt1=-3.5435960e-08       kt2=-1.9630471e-02
+ lkt2=1.0013879e-08        at=5.0000000e04           ute=-1.4367626
+ lute=-3.6092080e-07       ua1=3.3241270e-09         lua1=-3.1362136e-15
+ ub1=-5.1175560e-18        lub1=7.6097750e-25        uc1=7.1935010e-12
+ luc1=-8.5434470e-17       kt1l=0.00                 prt=0
+ cj=cjn_na33               mj=0.315                  pb=0.4
+ cjsw=cjswn_na33           mjsw=0.02                 pbsw=0.125
+ cjswg=cjswgn_na33         mjswg=0.414               pbswg=0.479
+ tpb=2.3e-03               tpbsw=2.0e-04             tpbswg=2.4e-03
+ tcj=3.0e-03               tcjsw=2.0e-04             tcjswg=3.5e-03
+ js=9.00e-07               jsw=1.50e-12              n=1
+ xti=3                     cgdo=cgon_na33            cgso=cgon_na33
+ cgbo=0                    capmod=3                  nqsmod=0
+ elm=5                     xpart=1                   cgsl=cgln_na33
+ cgdl=cgln_na33            ckappa=0.6000000          cf=cfn_na33
+ clc=1.0000000e-07         cle=0.6000000             dlc=2.746e-08
+ dwc=6.0835e-09            llc=-1.776e-16            lwc=-2.58e-16
+ wlc=0                     wwc=-0.0238               lwlc=0
+ wwlc=0                    acde=0.4                  moin=18
+ noff=2.5                  voffcv=-0.28              tlev=1
+ tlevc=1                   sa0=8.2e-07               sb0=8.2e-07
+ kvsat=0.28                wlod=1.5e-07              tku0=0.1
+ ku0=-9.0e-08              llodku0=1                 wlodku0=1
+ lku0=9.0e-07              wku0=7.0e-07              pku0=5.0e-14
+ kvth0=0                   stk2=0                    steta0=0
+ lkvth0=0                  wkvth0=0                  pkvth0=0
+ llodvth=1                 wlodvth=1                 lodk2=1
+ lodeta0=1                 noia=1.55e+19             noib=2.96e+04
+ noic=2.50e-12             em=4.02e+07               ef=0.85
+ noimod=2                  minr=1e-3                 imax=0.01
+ imelt=0.01

     3: type=n
+ lmin=1.0000e-05-dxl_na33  lmax=9.001e-04            wmin=1.0000e-06-dxw_na33
+ wmax=1.0000e-05-dxw_na33  tnom=25.0                 version=3.24
+ tox=toxn_na33             toxm=toxn_na33            xj=1.5000001e-07
+ nch=6.1500000e15          lln=1.0000000             lwn=1.0000000
+ wln=1.0000000             wwn=-1                    lint=2.9650000e-08
+ ll=0.00                   lw=0.00                   lwl=0.00
+ wint=3.9850000e-08        wl=0.00                   ww=0.00
+ wwl=0.00                  mobmod=1                  binunit=2
+ xl=-0.045e-06+dxl_na33    xw=0+dxw_na33             dwg=0.00
+ dwb=0.00                  ldif=6.50e-08             hdif=hdifn_na33
+ rsh=rshn_na33             rd=0                      rs=0
+ rsc=0                     rdc=0                     vth0=-0.1400000+dvthn_na33
+ lvth0=0+dlvthn_na33       k1=8.0000000e-02          k2=-6.4741790e-03
+ wk2=2.9004901e-09         k3=7.7100000              dvt0=0.2160000
+ dvt1=0.1790000            dvt2=0.1040000            dvt0w=0.00
+ dvt1w=0.00                dvt2w=0.00                nlx=0.00
+ w0=1.8240000e-06          k3b=-16.6000000           ngate=2.0000000e20
+ vsat=1.0000000e05         ua=6.3517950e-10          wua=2.6346859e-16
+ ub=1.4566300e-18          wub=-7.2745520e-25        uc=2.0000000e-12
+ rdsw=2.5000000e02         prwb=0.00                 prwg=0.00
+ wr=1.0000000              u0=5.1551130e-02+du0n_na33
+ wu0=-5.0720290e-10        a0=0.8000000              keta=-1.0480302e-02
+ wketa=-1.1107743e-08      a1=0.00                   a2=0.9900000
+ ags=1.6709232             wags=-5.0517410e-07       b0=0.00
+ b1=0.00                   voff=-0.1146569           wvoff=-3.4033280e-09
+ nfactor=0.8977445         wnfactor=1.0144057e-06    cit=0.00
+ cdsc=0.00                 cdscb=0.00                cdscd=0.00
+ eta0=1.0000000e-04        etab=1.3393420e-03        wetab=-2.6628150e-10
+ dsub=0.00                 pclm=1.0000000            pdiblc1=3.0000000e-03
+ pdiblc2=1.0000000e-04     pdiblcb=1.0000000e-02     drout=0.00
+ pscbe1=4.0000000e08       pscbe2=1.0000000e-06      pvag=0.00
+ delta=2.5000144e-03       alpha0=0.00               alpha1=0.0048
+ beta0=9.5                 kt1=-0.2908751            wkt1=3.2092760e-08
+ kt2=-1.8618530e-02        at=5.0000000e04           ute=-1.5081142
+ wute=3.4601280e-07        ua1=2.9503120e-09         wua1=5.6434620e-16
+ ub1=-5.0375900e-18        wub1=-3.0410126e-26       uc1=-1.4667114e-12
+ wuc1=2.6504495e-19        kt1l=0.00                 prt=0
+ cj=cjn_na33               mj=0.315                  pb=0.4
+ cjsw=cjswn_na33           mjsw=0.02                 pbsw=0.125
+ cjswg=cjswgn_na33         mjswg=0.414               pbswg=0.479
+ tpb=2.3e-03               tpbsw=2.0e-04             tpbswg=2.4e-03
+ tcj=3.0e-03               tcjsw=2.0e-04             tcjswg=3.5e-03
+ js=9.00e-07               jsw=1.50e-12              n=1
+ xti=3                     cgdo=cgon_na33            cgso=cgon_na33
+ cgbo=0                    capmod=3                  nqsmod=0
+ elm=5                     xpart=1                   cgsl=cgln_na33
+ cgdl=cgln_na33            ckappa=0.6000000          cf=cfn_na33
+ clc=1.0000000e-07         cle=0.6000000             dlc=2.746e-08
+ dwc=6.0835e-09            llc=-1.776e-16            lwc=-2.58e-16
+ wlc=0                     wwc=-0.0238               lwlc=0
+ wwlc=0                    acde=0.4                  moin=18
+ noff=2.5                  voffcv=-0.28              tlev=1
+ tlevc=1                   sa0=8.2e-07               sb0=8.2e-07
+ kvsat=0.28                wlod=1.5e-07              tku0=0.1
+ ku0=-9.0e-08              llodku0=1                 wlodku0=1
+ lku0=9.0e-07              wku0=7.0e-07              pku0=5.0e-14
+ kvth0=0                   stk2=0                    steta0=0
+ lkvth0=0                  wkvth0=0                  pkvth0=0
+ llodvth=1                 wlodvth=1                 lodk2=1
+ lodeta0=1                 noia=1.55e+19             noib=2.96e+04
+ noic=2.50e-12             em=4.02e+07               ef=0.85
+ noimod=2                  minr=1e-3                 imax=0.01
+ imelt=0.01

     4: type=n
+ lmin=1.2e-06              lmax=1.0000e-05-dxl_na33  wmin=1.0000e-06-dxw_na33
+ wmax=1.0000e-05-dxw_na33  tnom=25.0                 version=3.24
+ tox=toxn_na33             toxm=toxn_na33            xj=1.5000001e-07
+ nch=6.1500000e15          lln=1.0000000             lwn=1.0000000
+ wln=1.0000000             wwn=-1                    lint=2.9650000e-08
+ ll=0.00                   lw=0.00                   lwl=0.00
+ wint=3.9850000e-08        wl=0.00                   ww=0.00
+ wwl=0.00                  mobmod=1                  binunit=2
+ xl=-0.045e-06+dxl_na33    xw=0+dxw_na33             dwg=0.00
+ dwb=0.00                  ldif=6.50e-08             hdif=hdifn_na33
+ rsh=rshn_na33             rd=0                      rs=0
+ rsc=0                     rdc=0                     vth0=-0.1400000+dvthn_na33
+ lvth0=0+dlvthn_na33       k1=8.0000000e-02          k2=-5.8841640e-03
+ lk2=-5.8386140e-09        wk2=3.2513890e-09         pk2=-3.4723820e-15
+ k3=7.7100000              dvt0=0.2160000            dvt1=0.1790000
+ dvt2=0.1040000            dvt0w=0.00                dvt1w=0.00
+ dvt2w=0.00                nlx=0.00                  w0=1.8244981e-06
+ lw0=-4.9285960e-15        k3b=-16.6000000           ngate=2.0000000e20
+ vsat=1.0082346e05         lvsat=-8.1487140e-03      wvsat=-7.5783050e-04
+ pvsat=7.4992620e-09       ua=6.3716510e-10          lua=-1.9649113e-17
+ wua=2.7637319e-16         pua=-1.2770018e-22        ub=1.3226874e-18
+ lub=1.3254558e-24         wub=-6.6991240e-25        pub=-5.6942620e-31
+ uc=1.9745360e-12          luc=2.5198382e-19         wuc=2.5261013e-19
+ puc=-2.4997539e-24        rdsw=2.5000000e02         prwb=0.00
+ prwg=0.00                 wr=1.0000000              u0=5.1351630e-02+du0n_na33
+ lu0=1.9741826e-09         wu0=-3.8089780e-10        pu0=-1.2498769e-15
+ a0=0.8686217              la0=-6.7905960e-07        wa0=-6.3152520e-08
+ pa0=6.2493850e-13         keta=-1.0498130e-02       lketa=1.7642146e-10
+ wketa=-1.1198704e-08      pketa=9.0012000e-16       a1=0.00
+ a2=0.9900000              ags=1.8553057             lags=-1.8245930e-06
+ wags=-7.0385200e-07       pags=1.9660564e-12        b0=0.00
+ b1=0.00                   voff=-0.1153776           lvoff=7.1311830e-09
+ wvoff=-6.1359370e-09      pvoff=2.7041083e-14       nfactor=0.7668670
+ lnfactor=1.2951230e-06    wnfactor=1.0775584e-06    pnfactor=-6.2493840e-13
+ cit=0.00                  cdsc=0.00                 cdscb=0.00
+ cdscd=0.00                eta0=-1.2092410e-03       leta0=1.2955858e-08
+ weta0=1.0107593e-09       peta0=-1.0002172e-14      etab=1.4073461e-03
+ letab=-6.7294830e-10      wetab=-2.3592747e-10      petab=-3.0037429e-16
+ dsub=0.00                 pclm=1.0000000            pdiblc1=2.9136848e-03
+ lpdiblc1=8.5415150e-10    wpdiblc1=-3.7891520e-10   ppdiblc1=3.7496310e-15
+ pdiblc2=1.0000000e-04     pdiblcb=9.8726800e-03     lpdiblcb=1.2599189e-09
+ wpdiblcb=1.2630504e-09    ppdiblcb=-1.2498769e-14   drout=0.00
+ pscbe1=4.0000000e08       pscbe2=1.0000000e-06      pvag=0.00
+ delta=2.5000160e-03       pdelta=1.6296539e-20      alpha0=0.00
+ alpha1=0.0048             beta0=9.5                 kt1=-0.2873308
+ lkt1=-3.5073480e-08       wkt1=3.2456150e-08        pkt1=-3.5959270e-15
+ kt2=-1.9733949e-02        lkt2=1.1037853e-08        wkt2=1.0265203e-09
+ pkt2=-1.0158137e-14       at=5.0000000e04           ute=-1.4720837
+ lute=-3.5654760e-07       wute=3.5039680e-07        pute=-4.3383120e-14
+ ua1=3.2624120e-09         lua1=-3.0884448e-15       wua1=6.1223300e-16
+ pua1=-4.7387430e-22       ub1=-5.0897460e-18        lub1=5.1611850e-25
+ wub1=-2.7587753e-25       pub1=2.4290714e-30        uc1=8.0027350e-12
+ luc1=-9.3706810e-17       wuc1=-8.0278560e-18       puc1=8.2064070e-23
+ kt1l=0.00                 prt=0                     cj=cjn_na33
+ mj=0.315                  pb=0.4                    cjsw=cjswn_na33
+ mjsw=0.02                 pbsw=0.125                cjswg=cjswgn_na33
+ mjswg=0.414               pbswg=0.479               tpb=2.3e-03
+ tpbsw=2.0e-04             tpbswg=2.4e-03            tcj=3.0e-03
+ tcjsw=2.0e-04             tcjswg=3.5e-03            js=9.00e-07
+ jsw=1.50e-12              n=1                       xti=3
+ cgdo=cgon_na33            cgso=cgon_na33            cgbo=0
+ capmod=3                  nqsmod=0                  elm=5
+ xpart=1                   cgsl=cgln_na33            cgdl=cgln_na33
+ ckappa=0.6000000          cf=cfn_na33               clc=1.0000000e-07
+ cle=0.6000000             dlc=2.746e-08             dwc=6.0835e-09
+ llc=-1.776e-16            lwc=-2.58e-16             wlc=0
+ wwc=-0.0238               lwlc=0                    wwlc=0
+ acde=0.4                  moin=18                   noff=2.5
+ voffcv=-0.28              tlev=1                    tlevc=1
+ sa0=8.2e-07               sb0=8.2e-07               kvsat=0.28
+ wlod=1.5e-07              tku0=0.1                  ku0=-9.0e-08
+ llodku0=1                 wlodku0=1                 lku0=9.0e-07
+ wku0=7.0e-07              pku0=5.0e-14              kvth0=0
+ stk2=0                    steta0=0                  lkvth0=0
+ wkvth0=0                  pkvth0=0                  llodvth=1
+ wlodvth=1                 lodk2=1                   lodeta0=1
+ noia=1.55e+19             noib=2.96e+04             noic=2.50e-12
+ em=4.02e+07               ef=0.85                   noimod=2
+ minr=1e-3                 imax=0.01                 imelt=0.01

     5: type=n
+ lmin=1.0000e-05-dxl_na33  lmax=9.001e-04            wmin=0.5e-06
+ wmax=1.0000e-06-dxw_na33  tnom=25.0                 version=3.24
+ tox=toxn_na33             toxm=toxn_na33            xj=1.5000001e-07
+ nch=6.1500000e15          lln=1.0000000             lwn=1.0000000
+ wln=1.0000000             wwn=-1                    lint=2.9650000e-08
+ ll=0.00                   lw=0.00                   lwl=0.00
+ wint=3.9850000e-08        wl=0.00                   ww=0.00
+ wwl=0.00                  mobmod=1                  binunit=2
+ xl=-0.045e-06+dxl_na33    xw=0+dxw_na33             dwg=0.00
+ dwb=0.00                  ldif=6.50e-08             hdif=hdifn_na33
+ rsh=rshn_na33             rd=0                      rs=0
+ rsc=0                     rdc=0                     vth0=-0.1400000+dvthn_na33
+ lvth0=0+dlvthn_na33       k1=8.0000000e-02          k2=-5.5900180e-03
+ wk2=2.0867972e-09         k3=7.7100000              dvt0=0.2160000
+ dvt1=0.1790000            dvt2=0.1040000            dvt0w=0.00
+ dvt1w=0.00                dvt2w=0.00                nlx=0.00
+ w0=1.8240000e-06          k3b=-16.6000000           ngate=2.0000000e20
+ vsat=1.0000000e05         ua=1.1888641e-09          wua=-2.4608740e-16
+ ub=2.9163204e-19          wub=3.4469230e-25         uc=2.0000000e-12
+ rdsw=2.5000000e02         prwb=0.00                 prwg=0.00
+ wr=1.0000000              u0=4.9318800e-02+du0n_na33
+ wu0=1.5472086e-09         a0=0.6318800              wa0=1.5472084e-07
+ keta=-2.7087558e-02       wketa=4.1759150e-09       a1=0.00
+ a2=0.9900000              ags=1.3086132             wags=-1.7174014e-07
+ b0=0.00                   b1=0.00                   voff=-0.1001602
+ wvoff=-1.6744666e-08      nfactor=2.0000000         cit=0.00
+ cdsc=0.00                 cdscb=0.00                cdscd=0.00
+ eta0=1.0000000e-04        etab=1.4545387e-03        wetab=-3.7229700e-10
+ dsub=0.00                 pclm=1.0000000            pdiblc1=3.0000000e-03
+ pdiblc2=1.0000000e-04     pdiblcb=1.0000000e-02     drout=0.00
+ pscbe1=4.0000000e08       pscbe2=1.0000000e-06      pvag=0.00
+ delta=2.4999999e-03       alpha0=0.00               alpha1=0.0048
+ beta0=9.5                 kt1=-0.2318189            wkt1=-2.2256595e-08
+ kt2=-1.1754166e-02        wkt2=-6.3172740e-09       at=5.0000000e04
+ ute=-1.2348036            wute=9.4484920e-08        ua1=2.9602643e-09
+ wua1=5.5518720e-16        ub1=-4.1636520e-18        wub1=-8.3469570e-25
+ uc1=-1.0666521e-12        wuc1=-1.0312962e-19       kt1l=0.00
+ prt=0                     cj=cjn_na33               mj=0.315
+ pb=0.4                    cjsw=cjswn_na33           mjsw=0.02
+ pbsw=0.125                cjswg=cjswgn_na33         mjswg=0.414
+ pbswg=0.479               tpb=2.3e-03               tpbsw=2.0e-04
+ tpbswg=2.4e-03            tcj=3.0e-03               tcjsw=2.0e-04
+ tcjswg=3.5e-03            js=9.00e-07               jsw=1.50e-12
+ n=1                       xti=3                     cgdo=cgon_na33
+ cgso=cgon_na33            cgbo=0                    capmod=3
+ nqsmod=0                  elm=5                     xpart=1
+ cgsl=cgln_na33            cgdl=cgln_na33            ckappa=0.6000000
+ cf=cfn_na33               clc=1.0000000e-07         cle=0.6000000
+ dlc=2.746e-08             dwc=6.0835e-09            llc=-1.776e-16
+ lwc=-2.58e-16             wlc=0                     wwc=-0.0238
+ lwlc=0                    wwlc=0                    acde=0.4
+ moin=18                   noff=2.5                  voffcv=-0.28
+ tlev=1                    tlevc=1                   sa0=8.2e-07
+ sb0=8.2e-07               kvsat=0.28                wlod=1.5e-07
+ tku0=0.1                  ku0=-9.0e-08              llodku0=1
+ wlodku0=1                 lku0=9.0e-07              wku0=7.0e-07
+ pku0=5.0e-14              kvth0=0                   stk2=0
+ steta0=0                  lkvth0=0                  wkvth0=0
+ pkvth0=0                  llodvth=1                 wlodvth=1
+ lodk2=1                   lodeta0=1                 noia=1.55e+19
+ noib=2.96e+04             noic=2.50e-12             em=4.02e+07
+ ef=0.85                   noimod=2                  minr=1e-3
+ imax=0.01                 imelt=0.01

     6: type=n
+ lmin=1.2e-06              lmax=1.0000e-05-dxl_na33  wmin=0.5e-06
+ wmax=1.0000e-06-dxw_na33  tnom=25.0                 version=3.24
+ tox=toxn_na33             toxm=toxn_na33            xj=1.5000001e-07
+ nch=6.1500000e15          lln=1.0000000             lwn=1.0000000
+ wln=1.0000000             wwn=-1                    lint=2.9650000e-08
+ ll=0.00                   lw=0.00                   lwl=0.00
+ wint=3.9850000e-08        wl=0.00                   ww=0.00
+ wwl=0.00                  mobmod=1                  binunit=2
+ xl=-0.045e-06+dxl_na33    xw=0+dxw_na33             dwg=0.00
+ dwb=0.00                  ldif=6.50e-08             hdif=hdifn_na33
+ rsh=rshn_na33             rd=0                      rs=0
+ rsc=0                     rdc=0                     vth0=-0.1400000+dvthn_na33
+ lvth0=0+dlvthn_na33       k1=8.0000000e-02          k2=-4.0803440e-03
+ lk2=-1.4939287e-08        wk2=1.5913326e-09         pk2=4.9029690e-15
+ k3=7.7100000              dvt0=0.2160000            dvt1=0.1790000
+ dvt2=0.1040000            dvt0w=0.00                dvt1w=0.00
+ dvt2w=0.00                nlx=0.00                  w0=1.8244981e-06
+ lw0=-4.9285960e-15        k3b=-16.6000000           ngate=2.0000000e20
+ vsat=1.0000000e05         ua=1.1923492e-09          lua=-3.4488080e-17
+ wua=-2.3456280e-16        pua=-1.1404385e-22        ub=1.8279197e-19
+ lub=1.0770505e-24         wub=3.7913340e-25         pub=-3.4081890e-31
+ uc=2.4583514e-12          luc=-4.5357060e-18        wuc=-1.9264525e-19
+ puc=1.9063575e-24         rdsw=2.5000000e02         prwb=0.00
+ prwg=0.00                 wr=1.0000000              u0=4.9047220e-02+du0n_na33
+ lu0=2.6875155e-09         wu0=1.7398534e-09         pu0=-1.9063573e-15
+ a0=0.6109472              la0=2.0714518e-07         wa0=1.7398531e-07
+ pa0=-1.9063573e-13        keta=-2.8648755e-02       lketa=1.5449155e-08
+ wketa=5.5053180e-09       pketa=-1.3155376e-14      a1=0.00
+ a2=0.9900000              ags=1.3219583             lags=-1.3205980e-07
+ wags=-2.1301238e-07       pags=4.0841810e-13        b0=0.00
+ b1=0.00                   voff=-0.1011953           lvoff=1.0242889e-08
+ wvoff=-1.9187885e-08      pvoff=2.4177380e-14       nfactor=1.8854122
+ lnfactor=1.1339266e-06    wnfactor=4.8161250e-08    pnfactor=-4.7658940e-13
+ cit=0.00                  cdsc=0.00                 cdscb=0.00
+ cdscd=0.00                eta0=-1.1219898e-04       leta0=2.0998558e-09
+ weta0=1.1514991e-12       peta0=-1.1394291e-17      etab=1.6368751e-03
+ letab=-1.8043491e-09      wetab=-4.4716310e-10      petab=7.4085380e-16
+ dsub=0.00                 pclm=1.0000000            pdiblc1=2.5019550e-03
+ lpdiblc1=4.9285080e-09    pdiblc2=1.0000000e-04     pdiblcb=1.1245113e-02
+ lpdiblcb=-1.2321270e-08   drout=0.00                pscbe1=4.0000000e08
+ pscbe2=1.0000000e-06      pvag=0.00                 delta=2.4999999e-03
+ alpha0=0.00               alpha1=0.0048             beta0=9.5
+ kt1=-0.2158361            lkt1=-1.5816182e-07       wkt1=-3.3340420e-08
+ pkt1=1.0968228e-13        kt2=-1.0899475e-02        lkt2=-8.4577690e-09
+ wkt2=-7.1038460e-09       pkt2=7.7836850e-15        at=5.0000000e04
+ ute=-1.1052155            lute=-1.2823637e-06       wute=1.2768062e-08
+ pute=8.0864530e-13        ua1=3.6509040e-09         lua1=-6.8343620e-15
+ wua1=2.5470397e-16        pua1=2.9734932e-21        ub1=-4.6183890e-18
+ lub1=4.4999390e-24        wub1=-7.0966760e-25       pub1=-1.2372386e-30
+ uc1=-3.2835620e-13        luc1=-7.3059580e-18       wuc1=-3.6075290e-19
+ puc1=2.5493638e-24        kt1l=0.00                 prt=0
+ cj=cjn_na33               mj=0.315                  pb=0.4
+ cjsw=cjswn_na33           mjsw=0.02                 pbsw=0.125
+ cjswg=cjswgn_na33         mjswg=0.414               pbswg=0.479
+ tpb=2.3e-03               tpbsw=2.0e-04             tpbswg=2.4e-03
+ tcj=3.0e-03               tcjsw=2.0e-04             tcjswg=3.5e-03
+ js=9.00e-07               jsw=1.50e-12              n=1
+ xti=3                     cgdo=cgon_na33            cgso=cgon_na33
+ cgbo=0                    capmod=3                  nqsmod=0
+ elm=5                     xpart=1                   cgsl=cgln_na33
+ cgdl=cgln_na33            ckappa=0.6000000          cf=cfn_na33
+ clc=1.0000000e-07         cle=0.6000000             dlc=2.746e-08
+ dwc=6.0835e-09            llc=-1.776e-16            lwc=-2.58e-16
+ wlc=0                     wwc=-0.0238               lwlc=0
+ wwlc=0                    acde=0.4                  moin=18
+ noff=2.5                  voffcv=-0.28              tlev=1
+ tlevc=1                   sa0=8.2e-07               sb0=8.2e-07
+ kvsat=0.28                wlod=1.5e-07              tku0=0.1
+ ku0=-9.0e-08              llodku0=1                 wlodku0=1
+ lku0=9.0e-07              wku0=7.0e-07              pku0=5.0e-14
+ kvth0=0                   stk2=0                    steta0=0
+ lkvth0=0                  wkvth0=0                  pkvth0=0
+ llodvth=1                 wlodvth=1                 lodk2=1
+ lodeta0=1                 noia=1.55e+19             noib=2.96e+04
+ noic=2.50e-12             em=4.02e+07               ef=0.85
+ noimod=2                  minr=1e-3                 imax=0.01
+ imelt=0.01

     }
endsection mos_na33

//
//
//
//
//  *************************************************************
//                                                              *
//   Vertical BIPOLAR MODELS for 1.0V device process            *
//                                                              *
//  *************************************************************
//
//  ****************************    LIBRARY OF TYPICAL CASE    ******************************

section tt_bip
parameters bfa=1
parameters isa=1
parameters nfa=1
parameters rba=1
parameters rea=1
parameters rca=1
parameters rbma=1
parameters cjea=1
parameters cjca=1
include "cln90g_lk.scs" section=bip
endsection tt_bip

//  ****************************  LIBRARY OF SS CORNER CASE  ******************************

section ss_bip
parameters bfa=0.85
parameters isa=0.7
parameters nfa=1.0025
parameters rba=1.2
parameters rea=1.2
parameters rca=1.2
parameters rbma=1.2
parameters cjea=1.07
parameters cjca=1.07
include "cln90g_lk.scs" section=bip
endsection ss_bip

//  ****************************  LIBRARY OF FF CORNER CASE  ******************************

section ff_bip
parameters bfa=1.15
parameters isa=1.3
parameters nfa=0.9975
parameters rba=0.8
parameters rea=0.8
parameters rca=0.8
parameters rbma=0.8
parameters cjea=0.93
parameters cjca=0.93
include "cln90g_lk.scs" section=bip
endsection ff_bip

//  *****************************************************************************************
//
//             *
//                    MODELS OF VERTICAL P+/NW/SUB PNP BIPOLAR
//             *
//
//             *
//  *****************************************************************************************

section bip
//
//  *************************************************************
//                                                              *
//         MODEL OF P+/NW/PSUB VERTICAL PNP10X10 BIPOLAR        *
//                                                              *
//  *************************************************************
//
model pnp10 bjt type=pnp
+ is=6.47e-18*isa           bf=1.39*bfa               nf=1.005*nfa
+ vaf=881.302               ikf=1.465e-03             ise=6.47e-18*isa
+ ne=1.13                   br=5.4226e-03             nr=1.004
+ var=71.7836               ikr=1.63e-03              isc=6.47e-18*isa
+ nc=1.13                   rb=60.135*rba             irb=1.00e-03
+ rbm=0.1*rbma              re=3.8322*rea             rc=5.95*rca
+ nkf=0.3793                tnom=25.0                 xtb=0.00
+ xti=3.0                   eg=1.18                   tlev=0
+ tlevc=1                   tbf1=4.5753e-03           tbf2=2.20e-06
+ tbr1=-5.50e-03            tbr2=3.50e-05             tikf1=-9.2736e-03
+ tikf2=4.00e-05            tnf1=1.00e-04             trb1=1e-03
+ trc1=2.19e-03             cje=1.164e-13*cjea        vje=0.8
+ mje=0.36                  cjc=9.043e-14*cjca        vjc=0.8
+ mjc=0.45                  fc=0.00                   ctc=2.03e-03
+ cte=8.54e-04              tvjc=3.00e-03             tvje=1.90e-03
+ rbmod=spice               minr=1e-3
//
//  *************************************************************
//                                                              *
//        MODEL OF P+/NW/PSUB VERTICAL PNP5X5 BIPOLAR           *
//                                                              *
//  *************************************************************
//
model pnp5 bjt type=pnp
+ is=1.7861e-18*isa         bf=1.63*bfa               nf=1.0077*nfa
+ vaf=1.09e03               ikf=0.80e-03              ise=1.7861e-18*isa
+ ne=1.1                    br=2.28e-03               nr=1.005
+ var=71.7756               ikr=1.63e-03              isc=1.7861e-18*isa
+ nc=1.3                    rb=73.142*rba             irb=1.00e-03
+ rbm=0.1*rbma              re=8.0*rea                rc=7.3*rca
+ nkf=0.39                  tnom=25.0                 xtb=0.00
+ xti=3.0                   eg=1.18                   tlev=0
+ tlevc=1                   tbf1=4.5655e-03           tbf2=2.20e-06
+ tbr2=3.50e-05             tikf1=-9.90e-03           tikf2=6.00e-05
+ tne1=3.03e-04             tnf1=1.50e-04             trb1=1e-03
+ trc1=1.00e-03             trc2=-1.00e-05            cje=2.970e-14*cjea
+ vje=0.8                   mje=0.36                  cjc=5.475e-14*cjca
+ vjc=0.8                   mjc=0.45                  fc=0.75
+ ctc=2.03e-03              cte=8.54e-04              tvjc=3.00e-03
+ tvje=1.90e-03             tbr1=-5.5e-3              rbmod=spice
+ minr=1e-3
//
//  *************************************************************
//                                                              *
//        MODEL OF P+/NW/PSUB VERTICAL PNP2X2 BIPOLAR           *
//                                                              *
//  *************************************************************
//
model pnp2 bjt type=pnp
+ is=4.00e-19*isa           bf=2.25*bfa               nf=1.0077*nfa
+ vaf=1.09e03               ikf=2.80e-04              ise=4.00e-19*isa
+ ne=1.1                    br=0.75e-03               nr=1.005
+ var=71.776                ikr=1.63e-03              isc=4.00e-19*isa
+ nc=1.3                    rb=93.332*rba             irb=1.00e-03
+ rbm=0.1*rbma              re=16.8*rea               rc=8.6*rca
+ nkf=0.383                 tnom=25.0                 xtb=0.00
+ xti=3.0                   eg=1.18                   tlev=0
+ tlevc=1                   tbf1=5e-03                tbf2=2.2e-06
+ tbr1=-5.0e-03             tbr2=3.00e-05             tikf1=-9.88e-03
+ tikf2=8.96e-05            tne1=3.03e-04             tnf1=1.50e-04
+ trb1=1e-03                trc1=8.15e-04             trc2=-1.00e-05
+ tre1=5.20e-04             cje=5.040e-15*cjea        vje=0.8
+ mje=0.36                  cjc=3.658e-14*cjca        vjc=0.8
+ mjc=0.45                  fc=0.75                   ctc=2.03e-03
+ cte=8.54e-04              tvjc=3.00e-03             tvje=1.90e-03
+ rbmod=spice               minr=1e-3
//
//
endsection bip

//  *************************************************************
//                                                              *
//   Vertical NPN BIPOLAR MODELS for 1.0V device process        *
//                                                              *
//  *************************************************************
//
//  ****************************    LIBRARY OF TYPICAL CASE    ******************************

section tt_bip_npn
parameters bfb=1
parameters isb=1
parameters nfb=1
parameters rbb=1
parameters reb=1
parameters rcb=1
parameters rbmb=1
parameters cjeb=1
parameters cjcb=1
include "cln90g_lk.scs" section=bip_npn
endsection tt_bip_npn

//  ****************************  LIBRARY OF SS CORNER CASE  ******************************

section ss_bip_npn
parameters bfb=0.85
parameters isb=0.7
parameters nfb=1.0025
parameters rbb=1.2
parameters reb=1.2
parameters rcb=1.2
parameters rbmb=1.2
parameters cjeb=1.07
parameters cjcb=1.07
include "cln90g_lk.scs" section=bip_npn
endsection ss_bip_npn

//  ****************************  LIBRARY OF FF CORNER CASE  ******************************

section ff_bip_npn
parameters bfb=1.15
parameters isb=1.3
parameters nfb=0.9975
parameters rbb=0.8
parameters reb=0.8
parameters rcb=0.8
parameters rbmb=0.8
parameters cjeb=0.93
parameters cjcb=0.93
include "cln90g_lk.scs" section=bip_npn
endsection ff_bip_npn

//  *****************************************************************************************
//
//             *
//                    MODELS OF VERTICAL N+/PW/DNW NPN BIPOLAR
//             *
//
//             *
//  *****************************************************************************************

section bip_npn
//
//  *************************************************************
//                                                              *
//          MODEL OF N+/PW/DNW VERTICAL NPN10X10 BIPOLAR        *
//                                                              *
//  *************************************************************
//
model npn10 bjt type=npn
+ is=1.33e-17*isb           bf=4.7223*bfb             nf=1.005*nfb
+ vaf=71.8                  ikf=0.1421                ise=1.33e-17*isb
+ ne=1.13                   br=0.425                  nr=1.0
+ var=78.236                ikr=0.1                   isc=1.33e-17*isb
+ nc=1.13                   rb=103.22*rbb             irb=1.00e-03
+ rbm=0.1*rbmb              re=4.258*reb              rc=5.95*rcb
+ nkf=0.69                  tnom=25.0                 xtb=0.00
+ xti=3.0                   eg=1.18                   tlev=0
+ tlevc=1                   tbf1=2.48e-03             tbf2=1.70e-05
+ tbr1=1.0434e-03           tikf1=-5.84e-03           tne1=5.00e-04
+ trb1=5.1775e-03           trc1=7.05e-04             tre1=5.40e-04
+ cje=9.960e-14*cjeb        vje=0.5                   mje=0.25
+ cjc=2.682e-13*cjcb        vjc=0.6997                mjc=0.3519
+ fc=0.00                   ctc=9.88e-04              cte=7.32e-04
+ tvjc=1.75e-03             tvje=1.00e-03             rbmod=spice
+ minr=1e-3
//
//  *************************************************************
//                                                              *
//           MODEL OF N+/PW/DNW VERTICAL NPN5X5 BIPOLAR         *
//                                                              *
//  *************************************************************
//
model npn5 bjt type=npn
+ is=3.85e-18*isb           bf=5.4278*bfb             nf=1.005*nfb
+ vaf=94.058                ikf=0.0468                ise=3.85e-18*isb
+ ne=1.13                   br=0.225                  nr=1.0
+ var=71.776                ikr=1.00e-02              isc=3.85e-18*isb
+ nc=1.13                   rb=157.08*rbb             irb=1.00e-03
+ rbm=0.1*rbmb              re=5.792*reb              rc=6.6831*rcb
+ nkf=0.69                  tnom=25.0                 xtb=0.00
+ xti=3.0                   eg=1.18                   tlev=0
+ tlevc=1                   tbf1=2.58e-03             tbf2=1.504e-05
+ tbr1=8.75e-04             tikf1=-4.23e-03           tne1=5.00e-04
+ trb1=5.1775e-03           trc1=7.05e-04             tre1=5.40e-04
+ cje=2.530e-14*cjeb        vje=0.5                   mje=0.25
+ cjc=1.365e-13*cjcb        vjc=0.6997                mjc=0.3519
+ fc=0.00                   ctc=9.88e-04              cte=7.32e-04
+ tvjc=1.75e-03             tvje=1.00e-03             rbmod=spice
+ minr=1e-3
//
//  *************************************************************
//                                                              *
//           MODEL OF N+/PW/DNW VERTICAL NPN2X2 BIPOLAR         *
//                                                              *
//  *************************************************************
//
model npn2 bjt type=npn
+ is=7.85e-19*isb           bf=8.02*bfb               nf=1.005*nfb
+ vaf=113.6                 ikf=0.012                 ise=7.85e-19*isb
+ ne=1.13                   br=0.081                  nr=1.0
+ var=56.703                ikr=1.00e-02              isc=7.85e-19*isb
+ nc=1.13                   rb=288.2*rbb              irb=1.00e-03
+ rbm=0.1*rbmb              re=13.452*reb             rc=14.224*rcb
+ nkf=0.69                  tnom=25.0                 xtb=0.00
+ xti=3.0                   eg=1.18                   tlev=0
+ tlevc=1                   tbf1=1.4e-03              tbf2=2e-05
+ tbr1=1e-03                tikf1=-3.14e-03           tne1=5.00e-04
+ trb1=2.6285e-03           trc1=7.05e-04             tre1=5.40e-04
+ cje=4.240e-15*cjeb        vje=0.5                   mje=0.25
+ cjc=7.840e-14*cjcb        vjc=0.6997                mjc=0.3519
+ fc=0.00                   ctc=9.88e-04              cte=7.32e-04
+ tvjc=1.75e-03             tvje=1.00e-03             rbmod=spice
+ minr=1e-3
//
//
endsection bip_npn
//
//
//
//
//  *************************************************************
//                                                              *
//              1.0V Standard Vt Junction DIODE MODELS          *
//                                                              *
//  *************************************************************
//  *************** CORNER_LIB OF TYPICAL MODEL ****************************

section tt_dio
parameters is_d=1
parameters jsw_d=1
parameters n_d=1
parameters rs_d=1
parameters cj_d=1
parameters cjsw_d=1
include "cln90g_lk.scs" section=dio
endsection tt_dio
//  ***************** CORNER_LIB OF SLOW MODEL *****************************
section ss_dio
parameters is_d=0.7
parameters jsw_d=0.5
parameters n_d=1.0025
parameters rs_d=1.2
parameters cj_d=1.07
parameters cjsw_d=1.07
include "cln90g_lk.scs" section=dio
endsection ss_dio
//  ***************** CORNER_LIB OF FAST MODEL *****************************
section ff_dio
parameters is_d=1.3
parameters jsw_d=2
parameters n_d=0.9975
parameters rs_d=0.8
parameters cj_d=0.93
parameters cjsw_d=0.93
include "cln90g_lk.scs" section=dio
endsection ff_dio
//  ************************************************************************
//
//
//  *************************************************************
//                                                              *
//              1.0V Standard Vt Junction DIODE MODELS          *
//                                                              *
//  *************************************************************
//
section dio
//
//  *************************************************************
//                       MODEL OF N+/PW DIODE                   *
//                                                              *
//  *************************************************************

model ndio diode
+ level=1                   is=1.77e-07*is_d          rs=1.0e-10*rs_d
+ n=1.02*n_d                bv=10.1                   ibv=0.03
+ isw=4.23e-13*jsw_d        cj=9.80e-04*cj_d          pj=8.4e-4
+ mj=0.25                   fc=0                      cjsw=4.00e-11*cjsw_d
+ area=3.92e-8              mjsw=0.01                 tlevc=1
+ cta=7.32e-04              ctp=3.57e-04              trs=2.5e-3
+ tbv1=-1*-1.00e-03         tlev=1                    xti=3
+ eg=1.17                   vjsw=0.8                  vj=0.5
+ pta=1.00e-03              tnom=25                   ptp=1.90e-03
+ ns=1.02*n_d               nz=1.02*n_d               imax=1e40
+ minr=1e-10                allow_scaling=1

//  *************************************************************
//                       MODEL OF P+/NW DIODE                   *
//                                                              *
//  *************************************************************

model pdio diode
+ level=1                   is=1.245e-07*is_d         rs=1.0e-10*rs_d
+ n=1.02*n_d                bv=9.3                    ibv=0.03
+ isw=3.77e-13*jsw_d        cj=1.14e-03*cj_d          pj=8.4e-4
+ mj=0.36                   fc=0                      cjsw=6.00e-11*cjsw_d
+ area=3.92e-8              mjsw=0.01                 tlevc=1
+ cta=8.54e-04              ctp=3.57e-04              trs=2.5e-3
+ tbv1=-1*-1.00e-03         tlev=1                    xti=3
+ eg=1.17                   vjsw=0.8                  vj=0.8
+ pta=1.90e-03              tnom=25                   ptp=1.90e-03
+ ns=1.02*n_d               nz=1.02*n_d               imax=1e40
+ minr=1e-10                allow_scaling=1

//  *************************************************************
//                       MODEL OF NW/PSUB DIODE                 *
//                                                              *
//  *************************************************************

model nwdio diode
+ level=1                   is=8.90e-07*is_d          rs=4.8e-10*rs_d
+ n=1.02*n_d                bv=11.7                   ibv=0.03
+ isw=8.40e-13*jsw_d        cj=1.35e-04*cj_d          pj=8.4e-4
+ mj=0.45                   fc=0                      cjsw=8.73e-10*cjsw_d
+ area=3.92e-8              mjsw=0.35                 tlevc=1
+ cta=2.03e-03              ctp=8.70e-04              trs=2.5e-3
+ tbv1=-1*-8.00e-04         tlev=1                    xti=3
+ eg=1.17                   vjsw=0.8                  vj=0.8
+ pta=3.00e-03              tnom=25                   ptp=1.90e-03
+ ns=1.02*n_d               nz=1.02*n_d               imax=1e40
+ minr=1e-10                allow_scaling=1

endsection dio
//
//
//
//
//  *************************************************************
//                                                              *
//               1.0V High Vt Junction DIODE MODELS             *
//                                                              *
//  *************************************************************
//  ***************************    LIBRARY OF TYPICAL CASE    ******************************
section tt_dio_hvt
parameters is_d_hvt=1
parameters jsw_d_hvt=1
parameters n_d_hvt=1
parameters rs_d_hvt=1
parameters cj_d_hvt=1
parameters cjsw_d_hvt=1
include "cln90g_lk.scs" section=dio_hvt
endsection tt_dio_hvt
//  ****************************    LIBRARY OF SLOW CASE    ******************************
section ss_dio_hvt
parameters is_d_hvt=0.7
parameters jsw_d_hvt=0.5
parameters n_d_hvt=1.0025
parameters rs_d_hvt=1.2
parameters cj_d_hvt=1.07
parameters cjsw_d_hvt=1.07
include "cln90g_lk.scs" section=dio_hvt
endsection ss_dio_hvt
//  ****************************    LIBRARY OF FAST CASE    ******************************
section ff_dio_hvt
parameters is_d_hvt=1.3
parameters jsw_d_hvt=2
parameters n_d_hvt=0.9975
parameters rs_d_hvt=0.8
parameters cj_d_hvt=0.93
parameters cjsw_d_hvt=0.93
include "cln90g_lk.scs" section=dio_hvt
endsection ff_dio_hvt
//  ************************************************************************
//
//
//  *************************************************************
//                                                              *
//               1.0V High Vt Junction DIODE MODELS             *
//                                                              *
//  *************************************************************
//
section dio_hvt
//
//  *************************************************************
//                       MODEL OF N+/PW DIODE                   *
//                                                              *
//  *************************************************************

model ndio_hvt diode
+ level=1                   is=2.00e-07*is_d_hvt      rs=1.0e-10*rs_d_hvt
+ n=1.02*n_d_hvt            bv=10.2                   ibv=0.03
+ isw=6.71e-13*jsw_d_hvt    cj=1.09e-03*cj_d_hvt      pj=8.4e-4
+ mj=0.336                  fc=0                      cjsw=2.0e-11*cjsw_d_hvt
+ area=3.92e-8              mjsw=0.01                 tlevc=1
+ cta=8.34e-04              ctp=3.57e-04              trs=2.5e-3
+ tbv1=-1*-8.00e-04         tlev=1                    xti=3
+ eg=1.17                   vjsw=0.8                  vj=0.496
+ pta=1.00e-03              tnom=25                   ptp=1.00e-03
+ ns=1.02*n_d_hvt           nz=1.02*n_d_hvt           imax=1e40
+ minr=1e-10                allow_scaling=1

//  *************************************************************
//                       MODEL OF P+/NW DIODE                   *
//                                                              *
//  *************************************************************

model pdio_hvt diode
+ level=1                   is=1.50e-07*is_d_hvt      rs=1.0e-10*rs_d_hvt
+ n=1.02*n_d_hvt            bv=9.4                    ibv=0.03
+ isw=5.60e-13*jsw_d_hvt    cj=1.17e-03*cj_d_hvt      pj=8.4e-4
+ mj=0.351                  fc=0                      cjsw=6.0e-11*cjsw_d_hvt
+ area=3.92e-8              mjsw=0.01                 tlevc=1
+ cta=8.59e-04              ctp=1.86e-04              trs=2.5e-3
+ tbv1=-1*-8.00e-04         tlev=1                    xti=3
+ eg=1.17                   vjsw=0.8                  vj=0.751
+ pta=1.56e-03              tnom=25                   ptp=1.56e-03
+ ns=1.02*n_d_hvt           nz=1.02*n_d_hvt           imax=1e40
+ minr=1e-10                allow_scaling=1

endsection dio_hvt
//
//
//
//
//  *************************************************************
//                                                              *
//                1.0V Low Vt Junction DIODE MODELS             *
//                                                              *
//  *************************************************************
//  ***************************    LIBRARY OF TYPICAL CASE    ******************************
section tt_dio_lvt
parameters is_d_lvt=1
parameters jsw_d_lvt=1
parameters n_d_lvt=1
parameters rs_d_lvt=1
parameters cj_d_lvt=1
parameters cjsw_d_lvt=1
include "cln90g_lk.scs" section=dio_lvt
endsection tt_dio_lvt
//  ****************************    LIBRARY OF SLOW CASE    ******************************
section ss_dio_lvt
parameters is_d_lvt=0.7
parameters jsw_d_lvt=0.5
parameters n_d_lvt=1.0025
parameters rs_d_lvt=1.2
parameters cj_d_lvt=1.07
parameters cjsw_d_lvt=1.07
include "cln90g_lk.scs" section=dio_lvt
endsection ss_dio_lvt
//  ****************************    LIBRARY OF FAST CASE    ******************************
section ff_dio_lvt
parameters is_d_lvt=1.3
parameters jsw_d_lvt=2
parameters n_d_lvt=0.9975
parameters rs_d_lvt=0.8
parameters cj_d_lvt=0.93
parameters cjsw_d_lvt=0.93
include "cln90g_lk.scs" section=dio_lvt
endsection ff_dio_lvt
//  ************************************************************************
//
//
//  *************************************************************
//                                                              *
//                1.0V Low Vt Junction DIODE MODELS             *
//                                                              *
//  *************************************************************
//
section dio_lvt
//
//  *************************************************************
//                       MODEL OF N+/PW DIODE                   *
//                                                              *
//  *************************************************************

model ndio_lvt diode
+ level=1                   is=1.93e-07*is_d_lvt      rs=1.0e-10*rs_d_lvt
+ n=1.02*n_d_lvt            bv=10.1                   ibv=0.03
+ isw=3.4e-13*jsw_d_lvt     cj=9.87e-04*cj_d_lvt      pj=8.4e-4
+ mj=0.25                   fc=0                      cjsw=3.50e-11*cjsw_d_lvt
+ area=3.92e-8              mjsw=0.01                 tlevc=1
+ cta=7.60e-04              ctp=3.70e-04              trs=2.5e-3
+ tbv1=-1*-8.00e-04         tlev=1                    xti=3
+ eg=1.17                   vjsw=0.8                  vj=0.5
+ pta=1.20e-03              tnom=25                   ptp=1.90e-03
+ ns=1.02*n_d_lvt           nz=1.02*n_d_lvt           imax=1e40
+ minr=1e-10                allow_scaling=1

//  *************************************************************
//                       MODEL OF P+/NW DIODE                   *
//                                                              *
//  *************************************************************

model pdio_lvt diode
+ level=1                   is=1.56e-07*is_d_lvt      rs=1.0e-10*rs_d_lvt
+ n=1.02*n_d_lvt            bv=9.3                    ibv=0.03
+ isw=3.47e-13*jsw_d_lvt    cj=1.129e-03*cj_d_lvt     pj=8.4e-4
+ mj=0.36                   fc=0                      cjsw=5.80e-11*cjsw_d_lvt
+ area=3.92e-8              mjsw=0.01                 tlevc=1
+ cta=8.55e-04              ctp=1.90e-04              trs=2.5e-3
+ tbv1=-1*-1.00e-03         tlev=1                    xti=3
+ eg=1.17                   vjsw=0.8                  vj=0.8
+ pta=1.90e-03              tnom=25                   ptp=1.90e-03
+ ns=1.02*n_d_lvt           nz=1.02*n_d_lvt           imax=1e40
+ minr=1e-10                allow_scaling=1

endsection dio_lvt
//
//
//
//
//  *************************************************************
//                                                              *
//                   1.8V Junction DIODE MODELS                 *
//                                                              *
//  *************************************************************
//  ***************************    LIBRARY OF TYPICAL CASE    ******************************
section tt_dio_18
parameters is_d_18=1
parameters jsw_d_18=1
parameters n_d_18=1
parameters rs_d_18=1
parameters cj_d_18=1
parameters cjsw_d_18=1
include "cln90g_lk.scs" section=dio_18
endsection tt_dio_18
//  ***************************    LIBRARY OF SLOW CASE    ******************************
section ss_dio_18
parameters is_d_18=0.7
parameters jsw_d_18=0.5
parameters n_d_18=1.0025
parameters rs_d_18=1.2
parameters cj_d_18=1.07
parameters cjsw_d_18=1.07
include "cln90g_lk.scs" section=dio_18
endsection ss_dio_18
//  ***************************    LIBRARY OF FAST CASE    ******************************
section ff_dio_18
parameters is_d_18=1.3
parameters jsw_d_18=2
parameters n_d_18=0.9975
parameters rs_d_18=0.8
parameters cj_d_18=0.93
parameters cjsw_d_18=0.93
include "cln90g_lk.scs" section=dio_18
endsection ff_dio_18
//
//
//  *************************************************************
//                                                              *
//                 1.8V IO Junction DIODE MODELS                *
//                                                              *
//  *************************************************************
//
section dio_18
//
//  *************************************************************
//                       MODEL OF N+/PW DIODE                   *
//                                                              *
//  *************************************************************

model ndio_18 diode
+ level=1                   is=2.85e-07*is_d_18       rs=1.0e-10*rs_d_18
+ n=1.01*n_d_18             bv=10.5                   ibv=0.03
+ isw=6.9e-13*jsw_d_18      tlev=1                    tlevc=1
+ eg=1.17                   xti=3                     tbv1=-1*-9.0e-04
+ trs=2.5e-3                cj=9.66e-04*cj_d_18       cjsw=5.42e-11*cjsw_d_18
+ mj=0.279                  mjsw=0.01                 vj=0.613
+ pta=1.33e-03              vjsw=0.613                ptp=0.00133
+ tnom=25                   cta=0.000766              ctp=1.0e-04
+ fc=0                      area=3.92e-08             pj=0.00084
+ ns=1.01*n_d_18            nz=1.01*n_d_18            imax=1e40
+ minr=1e-10                allow_scaling=1

//  *************************************************************
//                       MODEL OF P+/NW DIODE                   *
//                                                              *
//  *************************************************************

model pdio_18 diode
+ level=1                   is=1.9e-07*is_d_18        rs=1.0e-10*rs_d_18
+ n=1.01*n_d_18             bv=9.8                    ibv=0.03
+ isw=1.0e-12*jsw_d_18      tlev=1                    tlevc=1
+ eg=1.17                   xti=3                     tbv1=-1*-8.0e-04
+ trs=2.5e-3                cj=1.08e-03*cj_d_18       cjsw=7.0e-11*cjsw_d_18
+ mj=0.335                  mjsw=0.01                 vj=0.752
+ pta=0.00174               vjsw=0.752                ptp=1.37e-03
+ tnom=25                   cta=0.000859              ctp=1.0e-04
+ fc=0                      area=3.92e-08             pj=0.00084
+ ns=1.01*n_d_18            nz=1.01*n_d_18            imax=1e40
+ minr=1e-10                allow_scaling=1

endsection dio_18
//
//
//
//
//  *************************************************************
//                                                              *
//                 3.3V IO Junction DIODE MODELS                *
//                                                              *
//  *************************************************************
//  ***************************    LIBRARY OF TYPICAL CASE    ******************************
section tt_dio_33
parameters is_d_33=1.0
parameters jsw_d_33=1.0
parameters n_d_33=1.000
parameters rs_d_33=1.0
parameters cj_d_33=1.00
parameters cjsw_d_33=1.00
include "cln90g_lk.scs" section=dio_33
endsection tt_dio_33
//  ****************************    LIBRARY OF SLOW CASE    ******************************
section ss_dio_33
parameters is_d_33=0.7
parameters jsw_d_33=0.5
parameters n_d_33=1.0025
parameters rs_d_33=1.2
parameters cj_d_33=1.07
parameters cjsw_d_33=1.07
include "cln90g_lk.scs" section=dio_33
endsection ss_dio_33
//  ****************************    LIBRARY OF FAST CASE    ******************************
section ff_dio_33
parameters is_d_33=1.3
parameters jsw_d_33=2.0
parameters n_d_33=0.9975
parameters rs_d_33=0.8
parameters cj_d_33=0.93
parameters cjsw_d_33=0.93
include "cln90g_lk.scs" section=dio_33
endsection ff_dio_33
//
//
//  *************************************************************
//                                                              *
//                 3.3V IO Junction DIODE MODELS                *
//                                                              *
//  *************************************************************
//
section dio_33
//
//  *************************************************************
//                       MODEL OF N+/PW DIODE                   *
//                                                              *
//  *************************************************************

model ndio_33 diode
+ level=1                   is=4.10e-07*is_d_33       rs=1.0e-10*rs_d_33
+ n=1.02*n_d_33             bv=10.65                  ibv=0.03
+ isw=1.55e-12*jsw_d_33     cj=9.62e-04*cj_d_33       pj=8.4e-4
+ mj=0.3234                 fc=0                      cjsw=1.38e-10*cjsw_d_33
+ area=3.92e-8              mjsw=0.1391               tlevc=1
+ cta=8.91e-04              ctp=4.45e-04              trs=2.5e-3
+ tbv1=-1*-9.00e-04         tlev=1                    xti=3
+ eg=1.17                   vjsw=0.5345               vj=0.7126
+ pta=1.50e-03              tnom=25                   ptp=1.39e-03
+ ns=1.02*n_d_33            nz=1.02*n_d_33            imax=1e40
+ minr=1e-10                allow_scaling=1

//  *************************************************************
//                       MODEL OF P+/NW DIODE                   *
//                                                              *
//  *************************************************************

model pdio_33 diode
+ level=1                   is=3.60e-07*is_d_33       rs=1.0e-10*rs_d_33
+ n=1.02*n_d_33             bv=9.80                   ibv=0.03
+ isw=1.60e-12*jsw_d_33     cj=1.04e-03*cj_d_33       pj=8.4e-4
+ mj=0.3261                 fc=0                      cjsw=7.00e-11*cjsw_d_33
+ area=3.92e-8              mjsw=0.0496               tlevc=1
+ cta=8.66e-04              ctp=3.20e-04              trs=2.5e-3
+ tbv1=-1*-8.50e-04         tlev=1                    xti=3
+ eg=1.17                   vjsw=0.3954               vj=0.7556
+ pta=1.50e-03              tnom=25                   ptp=1.90e-03
+ ns=1.02*n_d_33            nz=1.02*n_d_33            imax=1e40
+ minr=1e-10                allow_scaling=1

endsection dio_33
//
//
//
//
//  *************************************************************
//                                                              *
//              1.0V Native Core Junction DIODE MODELS          *
//                                                              *
//  *************************************************************
//  ***************************    LIBRARY OF TYPICAL CASE    ******************************
section tt_dio_na
parameters is_d_na=1.0
parameters jsw_d_na=1.0
parameters n_d_na=1.000
parameters rs_d_na=1.0
parameters cj_d_na=1.00
parameters cjsw_d_na=1.00
include "cln90g_lk.scs" section=dio_na
endsection tt_dio_na
//  ****************************    LIBRARY OF SLOW CASE    ******************************
section ss_dio_na
parameters is_d_na=0.7
parameters jsw_d_na=0.5
parameters n_d_na=1.0025
parameters rs_d_na=1.2
parameters cj_d_na=1.07
parameters cjsw_d_na=1.07
include "cln90g_lk.scs" section=dio_na
endsection ss_dio_na
//  ****************************    LIBRARY OF FAST CASE    ******************************
section ff_dio_na
parameters is_d_na=1.3
parameters jsw_d_na=2.0
parameters n_d_na=0.9975
parameters rs_d_na=0.8
parameters cj_d_na=0.93
parameters cjsw_d_na=0.93
include "cln90g_lk.scs" section=dio_na
endsection ff_dio_na
//
//
//  *************************************************************
//                                                              *
//              1.0V Native Core Junction DIODE MODELS          *
//                                                              *
//  *************************************************************
//
section dio_na
//
//  *************************************************************
//                      MODEL OF N+/Psub DIODE                  *
//                                                              *
//  *************************************************************

model ndio_na diode
+ is=9.00e-7*is_d_na        isw=1.50e-12*jsw_d_na     rs=1.0e-10*rs_d_na
+ n=1.02*n_d_na             cj=1.44e-04*cj_d_na       cjsw=1.6e-10*cjsw_d_na
+ bv=23.0                   area=3.92e-8              pj=8.4e-4
+ mj=0.313                  mjsw=0.01                 vj=0.49
+ vjsw=0.500                trs=2.5e-3                tbv1=-1*-9.0e-7
+ cta=2.10e-03              ctp=4.6e-04               pta=2.60e-03
+ ptp=5.0e-04               ibv=0.03                  tnom=25
+ fc=0                      tlev=1                    tlevc=1
+ xti=3                     eg=1.17                   level=1
+ ns=1.02*n_d_na            nz=1.02*n_d_na            imax=1e40
+ minr=1e-10                allow_scaling=1

endsection dio_na
//
//
//
//
//  *************************************************************
//                                                              *
//               1.8V Native Junction DIODE MODELS              *
//                                                              *
//  *************************************************************
//  ***************************    LIBRARY OF TYPICAL CASE    ******************************
section tt_dio_na18
parameters is_d_na18=1
parameters jsw_d_na18=1
parameters n_d_na18=1
parameters rs_d_na18=1
parameters cj_d_na18=1
parameters cjsw_d_na18=1
include "cln90g_lk.scs" section=dio_na18
endsection tt_dio_na18
//  ****************************    LIBRARY OF SLOW CASE    ******************************
section ss_dio_na18
parameters is_d_na18=0.7
parameters jsw_d_na18=0.5
parameters n_d_na18=1.0025
parameters rs_d_na18=1.2
parameters cj_d_na18=1.07
parameters cjsw_d_na18=1.07
include "cln90g_lk.scs" section=dio_na18
endsection ss_dio_na18
//  ****************************    LIBRARY OF FAST CASE    ******************************
section ff_dio_na18
parameters is_d_na18=1.3
parameters jsw_d_na18=2
parameters n_d_na18=0.9975
parameters rs_d_na18=0.8
parameters cj_d_na18=0.93
parameters cjsw_d_na18=0.93
include "cln90g_lk.scs" section=dio_na18
endsection ff_dio_na18
//  ******************************************************************************************
//
//
//  *************************************************************
//                                                              *
//               1.8V Native Junction DIODE MODELS              *
//                                                              *
//  *************************************************************
//
section dio_na18
//
//  *************************************************************
//                       MODEL OF N+/PSUB DIODE                 *
//                                                              *
//  *************************************************************

model ndio_na18 diode
+ level=1                   is=1.0e-06*is_d_na18      rs=1.0e-10*rs_d_na18
+ n=1.02*n_d_na18           bv=21.0                   ibv=0.03
+ isw=2.0e-12*jsw_d_na18    cj=1.42e-04*cj_d_na18     pj=8.4e-4
+ mj=2.90e-01               fc=0                      cjsw=2.54e-10*cjsw_d_na18
+ area=3.92e-8              mjsw=0.01                 tlevc=1
+ cta=2.80e-03              ctp=3.0e-04               trs=2.5e-3
+ tbv1=-1*-8.0e-04          tlev=1                    xti=3
+ eg=1.17                   vjsw=0.15                 vj=0.45
+ pta=2.50e-03              tnom=25                   ptp=2.0e-04
+ ns=1.02*n_d_na18          nz=1.02*n_d_na18          imax=1e40
+ minr=1e-10                allow_scaling=1

endsection dio_na18
//
//
//
//
//  *************************************************************
//                                                              *
//               3.3V Native Junction DIODE MODELS              *
//                                                              *
//  *************************************************************
//  ***************************    LIBRARY OF TYPICAL CASE    ******************************
section tt_dio_na33
parameters is_d_na33=1
parameters jsw_d_na33=1
parameters n_d_na33=1
parameters rs_d_na33=1
parameters cj_d_na33=1
parameters cjsw_d_na33=1
include "cln90g_lk.scs" section=dio_na33
endsection tt_dio_na33
//  ****************************    LIBRARY OF SLOW CASE    ******************************
section ss_dio_na33
parameters is_d_na33=0.7
parameters jsw_d_na33=0.5
parameters n_d_na33=1.0025
parameters rs_d_na33=1.2
parameters cj_d_na33=1.07
parameters cjsw_d_na33=1.07
include "cln90g_lk.scs" section=dio_na33
endsection ss_dio_na33
//  ****************************    LIBRARY OF FAST CASE    ******************************
section ff_dio_na33
parameters is_d_na33=1.3
parameters jsw_d_na33=2
parameters n_d_na33=0.9975
parameters rs_d_na33=0.8
parameters cj_d_na33=0.93
parameters cjsw_d_na33=0.93
include "cln90g_lk.scs" section=dio_na33
endsection ff_dio_na33
//  ******************************************************************************************
//
//
//  *************************************************************
//                                                              *
//               3.3V Native Junction DIODE MODELS              *
//                                                              *
//  *************************************************************
//
section dio_na33
//
//  *************************************************************
//                       MODEL OF N+/PSUB DIODE                 *
//                                                              *
//  *************************************************************

model ndio_na33 diode
+ level=1                   is=9.0e-07*is_d_na33      rs=1.0e-10*rs_d_na33
+ n=1.02*n_d_na33           bv=20.7                   ibv=0.03
+ isw=1.5e-12*jsw_d_na33    cj=1.39e-04*cj_d_na33     pj=8.4e-4
+ mj=3.15e-01               fc=0                      cjsw=1.97e-10*cjsw_d_na33
+ area=3.92e-8              mjsw=0.02                 tlevc=1
+ cta=3.00e-03              ctp=2.0e-04               trs=2.5e-3
+ tbv1=-1*-8.0e-04          tlev=1                    xti=3
+ eg=1.17                   vjsw=0.125                vj=0.4
+ pta=2.30e-03              tnom=25                   ptp=2.0e-04
+ ns=1.02*n_d_na33          nz=1.02*n_d_na33          imax=1e40
+ minr=1e-10                allow_scaling=1

endsection dio_na33
//
//
//
//
//  *************************************************************
//                                                              *
//                    DNW Junction DIODE MODELS                 *
//                                                              *
//  *************************************************************
//  *************** CORNER_LIB OF TYPICAL MODEL ****************************
section tt_dio_dnw
parameters is_d_dnw=1
parameters jsw_d_dnw=1
parameters n_d_dnw=1
parameters rs_d_dnw=1
parameters cj_d_dnw=1
parameters cjsw_d_dnw=1
include "cln90g_lk.scs" section=dio_dnw
endsection tt_dio_dnw
//  ***************** CORNER_LIB OF SLOW MODEL *****************************
section ss_dio_dnw
parameters is_d_dnw=0.7
parameters jsw_d_dnw=0.5
parameters n_d_dnw=1.0025
parameters rs_d_dnw=1.2
parameters cj_d_dnw=1.07
parameters cjsw_d_dnw=1.07
include "cln90g_lk.scs" section=dio_dnw
endsection ss_dio_dnw
//  ***************** CORNER_LIB OF FAST MODEL *****************************
section ff_dio_dnw
parameters is_d_dnw=1.3
parameters jsw_d_dnw=2
parameters n_d_dnw=0.9975
parameters rs_d_dnw=0.8
parameters cj_d_dnw=0.93
parameters cjsw_d_dnw=0.93
include "cln90g_lk.scs" section=dio_dnw
endsection ff_dio_dnw
//  ************************************************************************
//
//
//  *************************************************************
//                                                              *
//                    DNW Junction DIODE MODELS                 *
//                                                              *
//  *************************************************************
//
section dio_dnw
//
//  *************************************************************
//                      MODEL OF PW/DNW DIODE                   *
//                                                              *
//  *************************************************************

model pwdnw diode
+ level=1                   is=7.40e-07*is_d_dnw      rs=2.0e-10*rs_d_dnw
+ n=1.02*n_d_dnw            bv=10.4                   ibv=0.03
+ isw=8.70e-13*jsw_d_dnw    cj=8.7e-04*cj_d_dnw       pj=8.4e-4
+ mj=0.3519                 fc=0                      cjsw=7.1e-10*cjsw_d_dnw
+ area=3.92e-8              mjsw=0.4454               tlevc=1
+ cta=9.88e-04              ctp=1.03e-03              trs=2.5e-3
+ tbv1=-1*-8.00e-04         tlev=1                    xti=3
+ eg=1.17                   vjsw=0.818                vj=0.6997
+ pta=1.75e-03              tnom=25                   ptp=1.77e-03
+ ns=1.02*n_d_dnw           nz=1.02*n_d_dnw           imax=1e40
+ minr=1e-10                allow_scaling=1

//  *************************************************************
//                      MODEL OF DNW/PSUB DIODE                 *
//                                                              *
//  *************************************************************

model dnwpsub diode
+ level=1                   is=1.00e-06*is_d_dnw      rs=4.8e-10*rs_d_dnw
+ n=1.02*n_d_dnw            bv=11.6                   ibv=0.03
+ isw=8.70e-13*jsw_d_dnw    cj=1.37e-04*cj_d_dnw      pj=8.4e-4
+ mj=0.33                   fc=0                      cjsw=1.10e-09*cjsw_d_dnw
+ area=3.92e-8              mjsw=0.33                 tlevc=1
+ cta=2.03e-03              ctp=2.03e-03              trs=2.5e-3
+ tbv1=-1*-8.00e-04         tlev=1                    xti=3
+ eg=1.17                   vjsw=0.51                 vj=0.51
+ pta=2.40e-03              tnom=25                   ptp=2.40e-03
+ ns=1.02*n_d_dnw           nz=1.02*n_d_dnw           imax=1e40
+ minr=1e-10                allow_scaling=1

endsection dio_dnw
//
//
//
//
//  *************************************************************
//                                                              *
//                    ESD Junction DIODE MODELS                 *
//                                                              *
//  *************************************************************
//  *************** CORNER_LIB OF TYPICAL MODEL ****************************
section tt_dio_esd
parameters is_d_esd=1
parameters jsw_d_esd=1
parameters n_d_esd=1
parameters rs_d_esd=1
parameters cj_d_esd=1
parameters cjsw_d_esd=1
include "cln90g_lk.scs" section=dio_esd
endsection tt_dio_esd
//  ***************** CORNER_LIB OF SLOW MODEL *****************************
section ss_dio_esd
parameters is_d_esd=0.7
parameters jsw_d_esd=0.5
parameters n_d_esd=1.0025
parameters rs_d_esd=1.2
parameters cj_d_esd=1.07
parameters cjsw_d_esd=1.07
include "cln90g_lk.scs" section=dio_esd
endsection ss_dio_esd
//  ***************** CORNER_LIB OF FAST MODEL *****************************
section ff_dio_esd
parameters is_d_esd=1.3
parameters jsw_d_esd=2
parameters n_d_esd=0.9975
parameters rs_d_esd=0.8
parameters cj_d_esd=0.93
parameters cjsw_d_esd=0.93
include "cln90g_lk.scs" section=dio_esd
endsection ff_dio_esd
//  ************************************************************************
//
//
//  *************************************************************
//                                                              *
//                    ESD Junction DIODE MODELS                 *
//                                                              *
//  *************************************************************
//
section dio_esd
//
//  *************************************************************
//                       MODEL OF ESD DIODE                     *
//                                                              *
//  *************************************************************

model ndio_esd diode
+ level=1                   is=1.00e-07*is_d_esd      rs=1.0e-10*rs_d_esd
+ n=1.02*n_d_esd            bv=5.9                    ibv=0.03
+ isw=1.00e-13*jsw_d_esd    cj=2.09e-03*cj_d_esd      pj=8.4e-4
+ mj=0.345                  fc=0                      cjsw=1.32e-10*cjsw_d_esd
+ area=3.92e-8              mjsw=0.11                 tlevc=1
+ cta=4.73e-04              ctp=5.50e-03              trs=2.5e-3
+ tbv1=-1*-7.00e-04         tlev=1                    xti=3
+ eg=1.17                   vjsw=0.451                vj=0.818
+ pta=1.00e-03              tnom=25                   ptp=2.50e-03
+ ns=1.02*n_d_esd           nz=1.02*n_d_esd           imax=1e40
+ minr=1e-10                allow_scaling=1

endsection dio_esd
//
//
//
//
//  **********************************************************************************************************
//
//    1.0V Standard-Vt NMOS in N-Well varactor MODEL
//
//    Note that the corners are defined such that the capacitance decreases and
// increases in SS and FF
//    corners, respectively.  This is to align the effects of Tox change to that
// of the direction of Tox
//    skew in MOSFET corners.
//
//  **********************************************************************************************************

section tt_mos_cap
parameters toxm_var=23.3
parameters ndep0_var=1.105
parameters pndep_var=5.0e-13
parameters fac_var=1.0
parameters rs0_var=42.0
parameters dxl_var=0
parameters dxw_var=0
include "cln90g_lk.scs" section=mos_cap
endsection tt_mos_cap
//  *********************************************************************************************************
section ss_mos_cap
parameters toxm_var=24.2
parameters ndep0_var=0.95
parameters pndep_var=4.0e-13
parameters fac_var=0.32
parameters rs0_var=340
parameters dxl_var=5.0e-9
parameters dxw_var=-8e-9
include "cln90g_lk.scs" section=mos_cap
endsection ss_mos_cap
//  *********************************************************************************************************
section ff_mos_cap
parameters toxm_var=22.4
parameters ndep0_var=1.25
parameters pndep_var=6.0e-13
parameters fac_var=4.2
parameters rs0_var=1.0
parameters dxl_var=-5.0e-9
parameters dxw_var=8e-9
include "cln90g_lk.scs" section=mos_cap
endsection ff_mos_cap
//  *********************************************************************************************************
section mos_cap
ahdl_include "mosCap_ahdl.va"

subckt nmoscap ( ng nds )
parameters lr=50e-6 wr=50e-6 toxa=toxm_var * 0.88 + 0.5 weff=wr - 3.5e-8 + dxw_var
+ leff=lr - 1.05e-7 + 4.0e-14 / wr + dxl_var rvalue=rs0_var * (1.0 + 1.5e-7 / wr + 2.0e-7 / lr)
+ eff=wr * lr * (1.0 + 1.6e-3 * (temp - 25)) * 9393.931 / toxa / toxa / toxa * fac_var
+ phit=(temp + 273.0) / 11606.0
+ as=sqrt(ndep0_var * (1.0 + 2.3e-7 / lr + 1.55e-6 / wr + pndep_var / wr / lr) * 3.8850499 / (temp + 273.0)) * toxa / 3.399936
+ as2=as * as a0=1.0 / (1.0 + 0.707106781186547 * as) vfb=(0.116 - 2.3e-8 / wr + 8.0e-9 / lr - 1.5e-14 / lr / wr) * (1.0 + (temp - 25.0) * 4.5e-3)

cg ( ng n1 ) mosCap toxa=toxa weff=weff leff=leff as=as as2=as2 phit=phit a0=a0 vfb=vfb
gdf1 ( ng n1 ) bsource i =eff * (2.3e4 * (pow(0.5 * (sqrt(v(ng,n1) * v(ng,n1) +
+ 1.0e-4) + v(ng,n1)),4.7) - pow(5.0e-3,4.7)) - 150.0 * (pow(0.5 * (sqrt(v(ng,n1)
+ * v(ng,n1) + 1.0e-4) - v(ng,n1)),1.16) - pow(5.0e-3,1.16)) + 200.0 * v(ng,n1))
rs ( n1 nds ) resistor r=rvalue
ends nmoscap
endsection mos_cap
//  ************************************************************************
//                                                                         *
//                  1.8V IO NMOS in N-Well varactor MODEL                  *
//                                                                         *
//   Note that the corners are defined such that the capacitance decreases *
//   and increases in SS and FF corners, respectively.  This is to align   *
//   the effects of Tox change to that of the direction of Tox skew in     *
//   MOSFET corners.                                                       *
//                                                                         *
//  ************************************************************************
//  *************** CORNER_LIB OF TYPICAL MODEL ****************************
section tt_mos_cap_18
parameters cgmin_var18=1
parameters dcg_var18=1
parameters dxl_var18=0
parameters dxw_var18=0
include "cln90g_lk.scs" section=mos_cap_18
endsection tt_mos_cap_18
//  ***************** CORNER_LIB OF SLOW MODEL *****************************
section ss_mos_cap_18
parameters cgmin_var18=0.90
parameters dcg_var18=0.942
parameters dxl_var18=8e-09
parameters dxw_var18=-1.2e-08
include "cln90g_lk.scs" section=mos_cap_18
endsection ss_mos_cap_18
//  ***************** CORNER_LIB OF FAST MODEL *****************************
section ff_mos_cap_18
parameters cgmin_var18=1.10
parameters dcg_var18=1.058
parameters dxl_var18=-8e-09
parameters dxw_var18=1.2e-08
include "cln90g_lk.scs" section=mos_cap_18
endsection ff_mos_cap_18
//  ************************************************************************
//
//
//  ************************************************************************
//                                                                         *
//                  1.8V IO NMOS in N-Well varactor MODEL                  *
//                                                                         *
//  ************************************************************************
//
section mos_cap_18
//
subckt nmoscap_18 ( ng nds )
parameters factor=1.0 lr=1e-6 wr=1e-6 xl=5.5e-08 xw=0e-09 area=(lr - xl + dxl_var18) * (wr
+ - xw + dxw_var18) pj=2 * (lr - xl + dxl_var18 + wr - xw + dxw_var18) cgmin=1.12e-10
+ * cgmin_var18 * pj + 3.08e-10 * cgmin_var18 * (lr - xl + dxl_var18) + 1.348e-03
+ * cgmin_var18 * area dcg= - 5.2e-11 * dcg_var18 * pj - 2.6e-11 * dcg_var18 * (lr
+ - xl + dxl_var18) + 4.26e-03 * dcg_var18 * area dvgs= - 0.1 - 4.0e-04 * (temp
+ - 25) vgnorm=0.37 + 9.0e-04 * (temp - 25)

cg ( ng nds ) bsource q=(cgmin+dcg)*v(ng,nds)+vgnorm*dcg*ln(cosh((v(ng,nds)-dvgs)/vgnorm))

ends nmoscap_18

endsection mos_cap_18
//
//  ************************************************************************
//                                                                         *
//                  3.3V IO NMOS in N-Well varactor MODEL                  *
//                                                                         *
//   Note that the corners are defined such that the capacitance decreases *
//   and increases in SS and FF corners, respectively.  This is to align   *
//   the effects of Tox change to that of the direction of Tox skew in     *
//   MOSFET corners.                                                       *
//                                                                         *
//  ************************************************************************
//  *************** CORNER_LIB OF TYPICAL MODEL ****************************
section tt_mos_cap_33
parameters cgmin_var33=1
parameters dcg_var33=1
parameters dxl_var33=0
parameters dxw_var33=0
include "cln90g_lk.scs" section=mos_cap_33
endsection tt_mos_cap_33
//  ***************** CORNER_LIB OF SLOW MODEL *****************************
section ss_mos_cap_33
parameters cgmin_var33=0.9
parameters dcg_var33=0.9583
parameters dxl_var33=1.2e-08
parameters dxw_var33=-1.2e-08
include "cln90g_lk.scs" section=mos_cap_33
endsection ss_mos_cap_33
//  ***************** CORNER_LIB OF FAST MODEL *****************************
section ff_mos_cap_33
parameters cgmin_var33=1.1
parameters dcg_var33=1.0417
parameters dxl_var33=-1.2e-08
parameters dxw_var33=1.2e-08
include "cln90g_lk.scs" section=mos_cap_33
endsection ff_mos_cap_33
//  ************************************************************************
//  ************************************************************************
//                                                                         *
//                  3.3V IO NMOS in N-Well varactor MODEL                  *
//                                                                         *
//  ************************************************************************
//
section mos_cap_33
//
subckt nmoscap_33 ( ng nds )
parameters factor=1.0 lr=1e-6 wr=1e-6 xl=1.5e-08 xw=7.5e-09 area=(lr - xl + dxl_var33) * (wr
+ - xw + dxw_var33) pj=2 * (lr - xl + dxl_var33 + wr - xw + dxw_var33) cgmin=2.36e-10
+ * cgmin_var33 * pj + 2.94e-10 * cgmin_var33 * (lr - xl + dxl_var33) + 7.523e-04
+ * cgmin_var33 * area dcg= - 1.0e-10 * dcg_var33 * pj + 4.0e-11 * dcg_var33 * (lr
+ - xl + dxl_var33) + 2.008e-03 * dcg_var33 * area dvgs= - 0.25 - 5.0e-04 * (temp
+ - 25) vgnorm=0.6 + 1.0e-03 * (temp - 25)

cg ( ng nds ) bsource q=(cgmin+dcg)*v(ng,nds)+vgnorm*dcg*ln(cosh((v(ng,nds)-dvgs)/vgnorm))

ends nmoscap_33

endsection mos_cap_33
//
//
//
//  ************************************************************************
//
//    RESISTANCE MODEL
//
//  ************************************************************************

section tt_res
parameters r_rnodwo=92.99
parameters rend_rnodwo=8.46u
parameters dxl_rnodwo=0
parameters dxw_rnodwo=0
parameters r_rpodwo=152.56
parameters rend_rpodwo=29.5u
parameters dxl_rpodwo=0
parameters dxw_rpodwo=0
parameters r_rnpolywo=89.62
parameters rend_rnpolywo=14.4u
parameters dxl_rnpolywo=0
parameters dxw_rnpolywo=0
parameters r_rppolywo=402.1
parameters rend_rppolywo=86.7u
parameters dxl_rppolywo=0
parameters dxw_rppolywo=0
parameters r_rnods=10.5
parameters dxw_rnods=0
parameters r_rnodl=10.5
parameters r_rpods=9.68
parameters dxw_rpods=0
parameters r_rpodl=9.68
parameters r_rnpolys=10.41
parameters dxw_rnpolys=0
parameters r_rnpolyl=10.41
parameters r_rppolys=10.77
parameters dxw_rppolys=0
parameters r_rppolyl=10.77
parameters r_rnwod=330
parameters r_rnwsti=550
parameters r_rm1l=0.0736
parameters r_rm1s=0.1
parameters r_rm1w=0.0894
parameters r_rm2l=0.0604
parameters r_rm2s=0.072
parameters r_rm2w=0.069
parameters r_rm3l=0.0604
parameters r_rm3s=0.072
parameters r_rm3w=0.069
parameters r_rm4l=0.0604
parameters r_rm4s=0.072
parameters r_rm4w=0.069
parameters r_rm5l=0.0604
parameters r_rm5s=0.072
parameters r_rm5w=0.069
parameters r_rm6l=0.0604
parameters r_rm6s=0.072
parameters r_rm6w=0.069
parameters r_rm7l=0.0604
parameters r_rm7s=0.072
parameters r_rm7w=0.069
parameters r_rm8l=0.0214
parameters r_rm8s=0.0221
parameters r_rm8w=0.0204
parameters r_rm9l=0.0214
parameters r_rm9s=0.0221
parameters r_rm9w=0.0204
parameters r_rm10l=0.021
parameters r_rm10s=0.021
parameters r_rm10w=0.021
parameters r_rm2_7l=0.0604
parameters r_rm2_7s=0.072
parameters r_rm2_7w=0.069
parameters r_rm8_9l=0.0214
parameters r_rm8_9s=0.0221
parameters r_rm8_9w=0.0204
include "cln90g_lk.scs" section=res
endsection tt_res

section ss_res
parameters r_rnodwo=92.99 * 1.15
parameters rend_rnodwo=8.46u * 1.90
parameters dxl_rnodwo=0 + 0.0u
parameters dxw_rnodwo=0 + 0.040u
parameters r_rpodwo=152.56 * 1.25
parameters rend_rpodwo=29.5u * 1.60
parameters dxl_rpodwo=0 + 0.0u
parameters dxw_rpodwo=0 + 0.022u
parameters r_rnpolywo=89.62 * 1.15
parameters rend_rnpolywo=14.4u * 1.90
parameters dxl_rnpolywo=0 + 0.0u
parameters dxw_rnpolywo=0 + 0.032u
parameters r_rppolywo=402.1 * 1.15
parameters rend_rppolywo=86.7u * 1.60
parameters dxl_rppolywo=0 + 0.0u
parameters dxw_rppolywo=0 + 0.035u
parameters r_rnods=10.5 + 2.21
parameters dxw_rnods=0 + 0.015u
parameters r_rnodl=10.5 + 1.58
parameters r_rpods=9.68 + 2.03
parameters dxw_rpods=0 + 0.015u
parameters r_rpodl=9.68 + 1.45
parameters r_rnpolys=10.41 + 2.19
parameters dxw_rnpolys=0 + 0.009u
parameters r_rnpolyl=10.41 + 2.08
parameters r_rppolys=10.77 + 2.26
parameters dxw_rppolys=0 + 0.012u
parameters r_rppolyl=10.77 + 2.15
parameters r_rnwod=330 * 1.20
parameters r_rnwsti=550 * 1.20
parameters r_rm1l=0.0736 * 1.20
parameters r_rm1s=0.1 * 1.20
parameters r_rm1w=0.0894 * 1.20
parameters r_rm2l=0.0604 * 1.20
parameters r_rm2s=0.072 * 1.20
parameters r_rm2w=0.069 * 1.20
parameters r_rm3l=0.0604 * 1.20
parameters r_rm3s=0.072 * 1.20
parameters r_rm3w=0.069 * 1.20
parameters r_rm4l=0.0604 * 1.20
parameters r_rm4s=0.072 * 1.20
parameters r_rm4w=0.069 * 1.20
parameters r_rm5l=0.0604 * 1.20
parameters r_rm5s=0.072 * 1.20
parameters r_rm5w=0.069 * 1.20
parameters r_rm6l=0.0604 * 1.20
parameters r_rm6s=0.072 * 1.20
parameters r_rm6w=0.069 * 1.20
parameters r_rm7l=0.0604 * 1.20
parameters r_rm7s=0.072 * 1.20
parameters r_rm7w=0.069 * 1.20
parameters r_rm8l=0.0214 * 1.20
parameters r_rm8s=0.0221 * 1.20
parameters r_rm8w=0.0204 * 1.20
parameters r_rm9l=0.0214 * 1.20
parameters r_rm9s=0.0221 * 1.20
parameters r_rm9w=0.0204 * 1.20
parameters r_rm10l=0.021 * 1.20
parameters r_rm10s=0.021 * 1.20
parameters r_rm10w=0.021 * 1.20
parameters r_rm2_7l=0.0604 * 1.20
parameters r_rm2_7s=0.072 * 1.20
parameters r_rm2_7w=0.069 * 1.20
parameters r_rm8_9l=0.0214 * 1.20
parameters r_rm8_9s=0.0221 * 1.20
parameters r_rm8_9w=0.0204 * 1.20
include "cln90g_lk.scs" section=res
endsection ss_res

section ff_res
parameters r_rnodwo=92.99 * 0.85
parameters rend_rnodwo=8.46u * 0.10
parameters dxl_rnodwo=0 + 0.0u
parameters dxw_rnodwo=0 - 0.040u
parameters r_rpodwo=152.56 * 0.75
parameters rend_rpodwo=29.5u * 0.40
parameters dxl_rpodwo=0 + 0.0u
parameters dxw_rpodwo=0 - 0.022u
parameters r_rnpolywo=89.62 * 0.85
parameters rend_rnpolywo=14.4u * 0.10
parameters dxl_rnpolywo=0 + 0.0u
parameters dxw_rnpolywo=0 - 0.032u
parameters r_rppolywo=402.1 * 0.85
parameters rend_rppolywo=86.7u * 0.40
parameters dxl_rppolywo=0 + 0.0u
parameters dxw_rppolywo=0 - 0.035u
parameters r_rnods=10.5 - 2.21
parameters dxw_rnods=0 - 0.03u
parameters r_rnodl=10.5 - 1.58
parameters r_rpods=9.68 - 2.03
parameters dxw_rpods=0 - 0.03u
parameters r_rpodl=9.68 - 1.45
parameters r_rnpolys=10.41 - 2.19
parameters dxw_rnpolys=0 - 0.025u
parameters r_rnpolyl=10.41 - 2.08
parameters r_rppolys=10.77 - 2.26
parameters dxw_rppolys=0 - 0.03u
parameters r_rppolyl=10.77 - 2.15
parameters r_rnwod=330 * 0.80
parameters r_rnwsti=550 * 0.80
parameters r_rm1l=0.0736 * 0.80
parameters r_rm1s=0.1 * 0.80
parameters r_rm1w=0.0894 * 0.80
parameters r_rm2l=0.0604 * 0.80
parameters r_rm2s=0.072 * 0.80
parameters r_rm2w=0.069 * 0.80
parameters r_rm3l=0.0604 * 0.80
parameters r_rm3s=0.072 * 0.80
parameters r_rm3w=0.069 * 0.80
parameters r_rm4l=0.0604 * 0.80
parameters r_rm4s=0.072 * 0.80
parameters r_rm4w=0.069 * 0.80
parameters r_rm5l=0.0604 * 0.80
parameters r_rm5s=0.072 * 0.80
parameters r_rm5w=0.069 * 0.80
parameters r_rm6l=0.0604 * 0.80
parameters r_rm6s=0.072 * 0.80
parameters r_rm6w=0.069 * 0.80
parameters r_rm7l=0.0604 * 0.80
parameters r_rm7s=0.072 * 0.80
parameters r_rm7w=0.069 * 0.80
parameters r_rm8l=0.0214 * 0.80
parameters r_rm8s=0.0221 * 0.80
parameters r_rm8w=0.0204 * 0.80
parameters r_rm9l=0.0214 * 0.80
parameters r_rm9s=0.0221 * 0.80
parameters r_rm9w=0.0204 * 0.80
parameters r_rm10l=0.021 * 0.80
parameters r_rm10s=0.021 * 0.80
parameters r_rm10w=0.021 * 0.80
parameters r_rm2_7l=0.0604 * 0.80
parameters r_rm2_7s=0.072 * 0.80
parameters r_rm2_7w=0.069 * 0.80
parameters r_rm8_9l=0.0214 * 0.80
parameters r_rm8_9s=0.0221 * 0.80
parameters r_rm8_9w=0.0204 * 0.80
include "cln90g_lk.scs" section=res
endsection ff_res

section res

//  *********************************     N+OD w/o silicide resistor     ***********************************
subckt rnodwo ( n1 n2 )
parameters l=1u w=1u factor=1 pt=temp rsh=r_rnodwo rend0=rend_rnodwo dw=0.027u + dxw_rnodwo
+ dl=0 + dxl_rnodwo pvcp1=-2.96e-01 pvcp2=-8.04e-06 pvcp3=-2.449 ptcp1=1.51e-03
+ ptcp2=1.10e-06 pvce1=-6.89e-02 pvce2=1.12e+03 pvce3=-1.82e-01 ptce1=1.25e-03 ptce2=2.50e-06
+ tface=1.0 + ptce1 * (pt - 25.0) + ptce2 * (pt - 25.0) * (pt - 25.0)
+ tfacp=1.0 + ptcp1 * (pt - 25.0) + ptcp2 * (pt - 25.0) * (pt - 25.0)
rend1 ( n1 3 ) bsource r=rend0 / w / factor * tface * (1 + pvce1 * (tanh(pvce2
+ * abs(v(n1,3)) + pvce3) - tanh(pvce3)))
rp ( 3 4 ) bsource r=rsh * (l * factor - dl) / (w * factor - dw) * tfacp *
+ (1 + pvcp1 * (tanh(pvcp2 * abs(v(3,4) / (l * factor - dl)) + pvcp3) - tanh(pvcp3)))
rend2 ( 4 n2 ) bsource r=rend0 / w / factor * tface * (1 + pvce1 * (tanh(pvce2
+ * abs(v(4,n2)) + pvce3) - tanh(pvce3)))
ends rnodwo

//  *********************************     P+OD w/o silicide resistor     ***********************************
subckt rpodwo ( n1 n2 )
parameters l=1u w=1u factor=1 pt=temp rsh=r_rpodwo rend0=rend_rpodwo dw=0.0307u + dxw_rpodwo
+ dl=0 + dxl_rpodwo pvcp1=-3.89e-01 pvcp2=-1.73e-06 pvcp3=-2.098 ptcp1=1.11e-03
+ ptcp2=4.14e-06 pvce1=3.50e-02 pvce2=2.59e+02 pvce3=-9.92e-02 ptce1=-1.00e-03 ptce2=2.00e-06
+ tface=1.0 + ptce1 * (pt - 25.0) + ptce2 * (pt - 25.0) * (pt - 25.0)
+ tfacp=1.0 + ptcp1 * (pt - 25.0) + ptcp2 * (pt - 25.0) * (pt - 25.0)
rend1 ( n1 3 ) bsource r=rend0 / w / factor * tface * (1 + pvce1 * (tanh(pvce2
+ * abs(v(n1,3)) + pvce3) - tanh(pvce3)))
rp ( 3 4 ) bsource r=rsh * (l * factor - dl) / (w * factor - dw) * tfacp *
+ (1 + pvcp1 * (tanh(pvcp2 * abs(v(3,4) / (l * factor - dl)) + pvcp3) - tanh(pvcp3)))
rend2 ( 4 n2 ) bsource r=rend0 / w / factor * tface * (1 + pvce1 * (tanh(pvce2
+ * abs(v(4,n2)) + pvce3) - tanh(pvce3)))
ends rpodwo

//  *********************************     N+POLY w/o silicide resistor     ***********************************
subckt rnpolywo ( n1 n2 )
parameters l=1u w=1u factor=1 pt=temp rsh=r_rnpolywo rend0=rend_rnpolywo dw=0.106u
+ + dxw_rnpolywo dl=0 + dxl_rnpolywo pvcp1=-7.88e-01 pvcp2=-9.80e-05 pvcp3=-2.453
+ ptcp1=1.79e-04 ptcp2=-5.44e-07 pvce1=-2.27e-02 pvce2=-6.54e+02 pvce3=7.66e-01
+ ptce1=3.00e-03 ptce2=8.00e-06 tface=1.0 + ptce1 * (pt - 25.0) + ptce2
+ * (pt - 25.0) * (pt - 25.0) tfacp=1.0 + ptcp1 * (pt - 25.0) + ptcp2 * (pt - 25.0)
+ * (pt - 25.0)
rend1 ( n1 3 ) bsource r=rend0 / w / factor * tface * (1 + pvce1 * (tanh(pvce2
+ * abs(v(n1,3)) + pvce3) - tanh(pvce3)))
rp ( 3 4 ) bsource r=rsh * (l * factor - dl) / (w * factor - dw) * tfacp *
+ (1 + pvcp1 * (tanh(pvcp2 * abs(v(3,4) / (l * factor - dl)) + pvcp3) - tanh(pvcp3)))
rend2 ( 4 n2 ) bsource r=rend0 / w / factor * tface * (1 + pvce1 * (tanh(pvce2
+ * abs(v(4,n2)) + pvce3) - tanh(pvce3)))
ends rnpolywo

//  *********************************     P+POLY w/o silicide resistor     ***********************************
subckt rppolywo ( n1 n2 )
parameters l=1u w=1u factor=1 pt=temp rsh=r_rppolywo rend0=rend_rppolywo dw=0.0809u
+ + dxw_rppolywo dl=0 + dxl_rppolywo pvcp1=1.10e-03 pvcp2=-2.69e-05 pvcp3=2.957
+ ptcp1=-1.94e-04 ptcp2=1.01e-06 pvce1=1.04e-02 pvce2=-7.216 pvce3=1.72e-01 ptce1=-8.00e-04
+ ptce2=-5.00e-06 tface=1.0 + ptce1 * (pt - 25.0) + ptce2 * (pt - 25.0)
+ * (pt - 25.0) tfacp=1.0 + ptcp1 * (pt - 25.0) + ptcp2 * (pt - 25.0) * (pt - 25.0)
rend1 ( n1 3 ) bsource r=rend0 / w / factor * tface * (1 + pvce1 * (tanh(pvce2
+ * abs(v(n1,3)) + pvce3) - tanh(pvce3)))
rp ( 3 4 ) bsource r=rsh * (l * factor - dl) / (w * factor - dw) * tfacp *
+ (1 + pvcp1 * (tanh(pvcp2 * abs(v(3,4) / (l * factor - dl)) + pvcp3) - tanh(pvcp3)))
rend2 ( 4 n2 ) bsource r=rend0 / w / factor * tface * (1 + pvce1 * (tanh(pvce2
+ * abs(v(4,n2)) + pvce3) - tanh(pvce3)))
ends rppolywo

//  *********************************     N+OD silicide resistor (W<2um)     ***********************************
subckt rnods ( n1 n2 )
parameters l=1u w=1u factor=1 pt=temp rsh=r_rnods dw=0.0032u + dxw_rnods pvc1=4.77e-07
+ pvc2=7.63e-13 ptc1=3.10e-03 ptc2=3.96e-07 tfac=1.0 + ptc1 * (pt - 25.0)
+ + ptc2 * (pt - 25.0) * (pt - 25.0)
r1 ( n1 n2 ) bsource r=rsh * l * factor / (w * factor - dw) * (1 + pvc1 * (abs(v(n2,n1))
+ / l / factor) + pvc2 * (v(n2,n1) / l / factor) * (v(n2,n1) / l / factor)) * tfac
ends rnods

//  *********************************     N+OD silicide resistor (W>=2um)     ***********************************
subckt rnodl ( n1 n2 )
parameters l=1u w=1u factor=1 pt=temp rsh=r_rnodl dw=0.0032u pvc1=4.91e-07 pvc2=1.99e-12
+ ptc1=2.85e-03 ptc2=-2.29e-06 tfac=1.0 + ptc1 * (pt - 25.0) + ptc2 *
+ (pt - 25.0) * (pt - 25.0)
// .param pvc1 = 4.77E-07   pvc2 = 7.63E-13   ptc1 = 3.10E-03   ptc2 = 3.96E-07
//
r1 ( n1 n2 ) bsource r=rsh * l * factor / (w * factor - dw) * (1 + pvc1 * (abs(v(n2,n1))
+ / l / factor) + pvc2 * (v(n2,n1) / l / factor) * (v(n2,n1) / l / factor)) * tfac
ends rnodl

//  *********************************     P+OD silicide resistor (W<2.0um)     ***********************************
subckt rpods ( n1 n2 )
parameters l=1u w=1u factor=1 pt=temp rsh=r_rpods dw=0.0066u + dxw_rpods pvc1=6.04e-07
+ pvc2=7.82e-13 ptc1=3.25e-03 ptc2=-4.18e-07 tfac=1.0 + ptc1 * (pt - 25.0)
+ + ptc2 * (pt - 25.0) * (pt - 25.0)
r1 ( n1 n2 ) bsource r=rsh * l * factor / (w * factor - dw) * (1 + pvc1 * (abs(v(n2,n1))
+ / l / factor) + pvc2 * (v(n2,n1) / l / factor) * (v(n2,n1) / l / factor)) * tfac
ends rpods

//  *********************************     P+OD silicide resistor (W>=2.0um)
// ***********************************
subckt rpodl ( n1 n2 )
parameters l=1u w=1u factor=1 pt=temp rsh=r_rpodl dw=0.0066u pvc1=4.53e-07 pvc2=2.22e-12
+ ptc1=2.63e-03 ptc2=-9.56e-07 tfac=1.0 + ptc1 * (pt - 25.0) + ptc2 *
+ (pt - 25.0) * (pt - 25.0)
// .param pvc1 = 6.04E-07   pvc2 = 7.82E-13   ptc1 = 3.25E-03   ptc2 = -4.18E-07
//
r1 ( n1 n2 ) bsource r=rsh * l * factor / (w * factor - dw) * (1 + pvc1 * (abs(v(n2,n1))
+ / l / factor) + pvc2 * (v(n2,n1) / l / factor) * (v(n2,n1) / l / factor)) * tfac
ends rpodl

//  *********************************     N+POLY silicide resistor (W<2.0um)
//  ***********************************
subckt rnpolys ( n1 n2 )
parameters l=1u w=1u factor=1 pt=temp rsh=r_rnpolys dw=0.0189u + dxw_rnpolys pvc1=1.51e-06
+ pvc2=1.13e-12 ptc1=3.12e-03 ptc2=-1.91e-06 tfac=1.0 + ptc1 * (pt - 25.0)
+ + ptc2 * (pt - 25.0) * (pt - 25.0)
r1 ( n1 n2 ) bsource r=rsh * l * factor / (w * factor - dw) * (1 + pvc1 * (abs(v(n2,n1))
+ / l / factor) + pvc2 * (v(n2,n1) / l / factor) * (v(n2,n1) / l / factor)) * tfac
ends rnpolys

//  *********************************     N+POLY silicide resistor (W>=2.0um)
//   ***********************************
subckt rnpolyl ( n1 n2 )
parameters l=1u w=1u factor=1 pt=temp rsh=r_rnpolyl dw=0.0189u pvc1=3.04e-06 pvc2=3.35e-12
+ ptc1=2.56e-03 ptc2=-4.21e-07 tfac=1.0 + ptc1 * (pt - 25.0) + ptc2 *
+ (pt - 25.0) * (pt - 25.0)
// .param pvc1 = 1.51E-06   pvc2 = 1.13E-12   ptc1 = 3.12E-03   ptc2 = -1.91E-06
//
r1 ( n1 n2 ) bsource r=rsh * l * factor / (w * factor - dw) * (1 + pvc1 * (abs(v(n2,n1))
+ / l / factor) + pvc2 * (v(n2,n1) / l / factor) * (v(n2,n1) / l / factor)) * tfac
ends rnpolyl

//  *********************************     P+POLY silicide resistor (W<2.0um)
//  ***********************************
subckt rppolys ( n1 n2 )
parameters l=1u w=1u factor=1 pt=temp rsh=r_rppolys dw=0.0077u + dxw_rppolys pvc1=1.82e-06
+ pvc2=1.23e-12 ptc1=3.08e-03 ptc2=-1.39e-06 tfac=1.0 + ptc1 * (pt - 25.0)
+ + ptc2 * (pt - 25.0) * (pt - 25.0)
r1 ( n1 n2 ) bsource r=rsh * l * factor / (w * factor - dw) * (1 + pvc1 * (abs(v(n2,n1))
+ / l / factor) + pvc2 * (v(n2,n1) / l / factor) * (v(n2,n1) / l / factor)) * tfac
ends rppolys

//  *********************************     P+POLY silicide resistor (W>=2.0um)
//   ***********************************
subckt rppolyl ( n1 n2 )
parameters l=1u w=1u factor=1 pt=temp rsh=r_rppolyl dw=0.0077u pvc1=2.32e-06 pvc2=5.71e-12
+ ptc1=2.74e-03 ptc2=-1.41e-07 tfac=1.0 + ptc1 * (pt - 25.0) + ptc2 *
+ (pt - 25.0) * (pt - 25.0)
// .param pvc1 = 1.82E-06   pvc2 = 1.23E-12   ptc1 = 3.08E-03   ptc2 = -1.39E-06
//
r1 ( n1 n2 ) bsource r=rsh * l * factor / (w * factor - dw) * (1 + pvc1 * (abs(v(n2,n1))
+ / l / factor) + pvc2 * (v(n2,n1) / l / factor) * (v(n2,n1) / l / factor)) * tfac
ends rppolyl

//  *********************************     N-Well under OD resistor     ***********************************
subckt rnwod ( n1 n2 )
parameters l=1u w=1u factor=1 pt=temp rsh=r_rnwod dw=0.29u pvc1=1.24e-02 pvc2=-2.98e-04
+ ptc1=2.83e-03 ptc2=1.04e-05 tfac=1.0 + ptc1 * (pt - 25.0) + ptc2 * (pt
+ - 25.0) * (pt - 25.0)
r1 ( n1 n2 ) bsource r=rsh * l * factor / (w * factor - dw) * (1 + pvc1 * (abs(v(n2,n1))
+ / factor) + pvc2 * (v(n2,n1) / factor) * (v(n2,n1) / factor)) * tfac
ends rnwod

//  *********************************     N-well under STI resistor     ***********************************
subckt rnwsti ( n1 n2 )
parameters l=1u w=1u factor=1 pt=temp rsh=r_rnwsti dw=0.41u pvc1=1.16e-02 pvc2=-4.57e-04
+ ptc1=1.73e-03 ptc2=9.66e-06 tfac=1.0 + ptc1 * (pt - 25.0) + ptc2 * (pt
+ - 25.0) * (pt - 25.0)
r1 ( n1 n2 ) bsource r=rsh * l * factor / (w * factor - dw) * (1 + pvc1 * (abs(v(n2,n1))
+ / factor) + pvc2 * (v(n2,n1) / factor) * (v(n2,n1) / factor)) * tfac
ends rnwsti

//  *********************************     Metal 1 with W/S=0.12/0.36     ***********************************
subckt rm1l ( n1 n2 )
parameters l=1u w=1u factor=1 pt=temp rsh=r_rm1l dw=0 pvc1=0 pvc2=0 ptc1=2.92e-03 ptc2=-1.22e-07
+ tfac=1.0 + ptc1 * (pt - 25.0) + ptc2 * (pt - 25.0) * (pt - 25.0)
r1 ( n1 n2 ) bsource r=rsh * l * factor / (w * factor - dw) * (1 + pvc1 * (abs(v(n2,n1))
+ / l / factor) + pvc2 * (v(n2,n1) / l / factor) * (v(n2,n1) / l / factor)) * tfac
ends rm1l

//  *********************************     Metal 1 with W/S=0.12/0.12     ***********************************
subckt rm1s ( n1 n2 )
parameters l=1u w=1u factor=1 pt=temp rsh=r_rm1s dw=0 pvc1=0 pvc2=0 ptc1=2.92e-03 ptc2=-1.22e-07
+ tfac=1.0 + ptc1 * (pt - 25.0) + ptc2 * (pt - 25.0) * (pt - 25.0)
r1 ( n1 n2 ) bsource r=rsh * l * factor / (w * factor - dw) * (1 + pvc1 * (abs(v(n2,n1))
+ / l / factor) + pvc2 * (v(n2,n1) / l / factor) * (v(n2,n1) / l / factor)) * tfac
ends rm1s

//  *********************************     Metal 1 with W/S=0.324/0.162     ***********************************
subckt rm1w ( n1 n2 )
parameters l=1u w=1u factor=1 pt=temp rsh=r_rm1w dw=0 pvc1=0 pvc2=0 ptc1=2.92e-03 ptc2=-1.22e-07
+ tfac=1.0 + ptc1 * (pt - 25.0) + ptc2 * (pt - 25.0) * (pt - 25.0)
r1 ( n1 n2 ) bsource r=rsh * l * factor / (w * factor - dw) * (1 + pvc1 * (abs(v(n2,n1))
+ / l / factor) + pvc2 * (v(n2,n1) / l / factor) * (v(n2,n1) / l / factor)) * tfac
ends rm1w

//  *********************************     Metal 2  with W/S=0.14/0.42     ***********************************
subckt rm2l ( n1 n2 )
parameters l=1u w=1u factor=1 pt=temp rsh=r_rm2l dw=0 pvc1=0 pvc2=0 ptc1=3.077e-03
+ ptc2=-1.14e-07 tfac=1.0 + ptc1 * (pt - 25.0) + ptc2 * (pt - 25.0) *
+ (pt - 25.0)
r1 ( n1 n2 ) bsource r=rsh * l * factor / (w * factor - dw) * (1 + pvc1 * (abs(v(n2,n1))
+ / l / factor) + pvc2 * (v(n2,n1) / l / factor) * (v(n2,n1) / l / factor)) * tfac
ends rm2l

//  *********************************     Metal 2  with W/S=0.14/0.14     ***********************************
subckt rm2s ( n1 n2 )
parameters l=1u w=1u factor=1 pt=temp rsh=r_rm2s dw=0 pvc1=0 pvc2=0 ptc1=3.077e-03
+ ptc2=-1.14e-07 tfac=1.0 + ptc1 * (pt - 25.0) + ptc2 * (pt - 25.0) *
+ (pt - 25.0)
r1 ( n1 n2 ) bsource r=rsh * l * factor / (w * factor - dw) * (1 + pvc1 * (abs(v(n2,n1))
+ / l / factor) + pvc2 * (v(n2,n1) / l / factor) * (v(n2,n1) / l / factor)) * tfac
ends rm2s

//  *********************************     Metal 2  with W/S=0.42/0.21     ***********************************
subckt rm2w ( n1 n2 )
parameters l=1u w=1u factor=1 pt=temp rsh=r_rm2w dw=0 pvc1=0 pvc2=0 ptc1=3.077e-03
+ ptc2=-1.14e-07 tfac=1.0 + ptc1 * (pt - 25.0) + ptc2 * (pt - 25.0) *
+ (pt - 25.0)
r1 ( n1 n2 ) bsource r=rsh * l * factor / (w * factor - dw) * (1 + pvc1 * (abs(v(n2,n1))
+ / l / factor) + pvc2 * (v(n2,n1) / l / factor) * (v(n2,n1) / l / factor)) * tfac
ends rm2w

//  *********************************     Metal 3  with W/S=0.14/0.42     ***********************************
subckt rm3l ( n1 n2 )
parameters l=1u w=1u factor=1 pt=temp rsh=r_rm3l dw=0 pvc1=0 pvc2=0 ptc1=3.077e-03
+ ptc2=-1.14e-07 tfac=1.0 + ptc1 * (pt - 25.0) + ptc2 * (pt - 25.0) *
+ (pt - 25.0)
r1 ( n1 n2 ) bsource r=rsh * l * factor / (w * factor - dw) * (1 + pvc1 * (abs(v(n2,n1))
+ / l / factor) + pvc2 * (v(n2,n1) / l / factor) * (v(n2,n1) / l / factor)) * tfac
ends rm3l

//  *********************************     Metal 3 with W/S=0.14/0.14     ***********************************
subckt rm3s ( n1 n2 )
parameters l=1u w=1u factor=1 pt=temp rsh=r_rm3s dw=0 pvc1=0 pvc2=0 ptc1=3.077e-03
+ ptc2=-1.14e-07 tfac=1.0 + ptc1 * (pt - 25.0) + ptc2 * (pt - 25.0) *
+ (pt - 25.0)
r1 ( n1 n2 ) bsource r=rsh * l * factor / (w * factor - dw) * (1 + pvc1 * (abs(v(n2,n1))
+ / l / factor) + pvc2 * (v(n2,n1) / l / factor) * (v(n2,n1) / l / factor)) * tfac
ends rm3s

//  *********************************     Metal 3  with W/S=0.42/0.21     ***********************************
subckt rm3w ( n1 n2 )
parameters l=1u w=1u factor=1 pt=temp rsh=r_rm3w dw=0 pvc1=0 pvc2=0 ptc1=3.077e-03
+ ptc2=-1.14e-07 tfac=1.0 + ptc1 * (pt - 25.0) + ptc2 * (pt - 25.0) *
+ (pt - 25.0)
r1 ( n1 n2 ) bsource r=rsh * l * factor / (w * factor - dw) * (1 + pvc1 * (abs(v(n2,n1))
+ / l / factor) + pvc2 * (v(n2,n1) / l / factor) * (v(n2,n1) / l / factor)) * tfac
ends rm3w

//  *********************************     Metal 4  with W/S=0.14/0.42     ***********************************
subckt rm4l ( n1 n2 )
parameters l=1u w=1u factor=1 pt=temp rsh=r_rm4l dw=0 pvc1=0 pvc2=0 ptc1=3.077e-03
+ ptc2=-1.14e-07 tfac=1.0 + ptc1 * (pt - 25.0) + ptc2 * (pt - 25.0) *
+ (pt - 25.0)
r1 ( n1 n2 ) bsource r=rsh * l * factor / (w * factor - dw) * (1 + pvc1 * (abs(v(n2,n1))
+ / l / factor) + pvc2 * (v(n2,n1) / l / factor) * (v(n2,n1) / l / factor)) * tfac
ends rm4l

//  *********************************     Metal 4 with W/S=0.14/0.14     ***********************************
subckt rm4s ( n1 n2 )
parameters l=1u w=1u factor=1 pt=temp rsh=r_rm4s dw=0 pvc1=0 pvc2=0 ptc1=3.077e-03
+ ptc2=-1.14e-07 tfac=1.0 + ptc1 * (pt - 25.0) + ptc2 * (pt - 25.0) *
+ (pt - 25.0)
r1 ( n1 n2 ) bsource r=rsh * l * factor / (w * factor - dw) * (1 + pvc1 * (abs(v(n2,n1))
+ / l / factor) + pvc2 * (v(n2,n1) / l / factor) * (v(n2,n1) / l / factor)) * tfac
ends rm4s

//  *********************************     Metal 4  with W/S=0.42/0.21     ***********************************
subckt rm4w ( n1 n2 )
parameters l=1u w=1u factor=1 pt=temp rsh=r_rm4w dw=0 pvc1=0 pvc2=0 ptc1=3.077e-03
+ ptc2=-1.14e-07 tfac=1.0 + ptc1 * (pt - 25.0) + ptc2 * (pt - 25.0) *
+ (pt - 25.0)
r1 ( n1 n2 ) bsource r=rsh * l * factor / (w * factor - dw) * (1 + pvc1 * (abs(v(n2,n1))
+ / l / factor) + pvc2 * (v(n2,n1) / l / factor) * (v(n2,n1) / l / factor)) * tfac
ends rm4w

//  *********************************     Metal 5  with W/S=0.14/0.42     ***********************************
subckt rm5l ( n1 n2 )
parameters l=1u w=1u factor=1 pt=temp rsh=r_rm5l dw=0 pvc1=0 pvc2=0 ptc1=3.077e-03
+ ptc2=-1.14e-07 tfac=1.0 + ptc1 * (pt - 25.0) + ptc2 * (pt - 25.0) *
+ (pt - 25.0)
r1 ( n1 n2 ) bsource r=rsh * l * factor / (w * factor - dw) * (1 + pvc1 * (abs(v(n2,n1))
+ / l / factor) + pvc2 * (v(n2,n1) / l / factor) * (v(n2,n1) / l / factor)) * tfac
ends rm5l

//  *********************************     Metal 5 with W/S=0.14/0.14     ***********************************
subckt rm5s ( n1 n2 )
parameters l=1u w=1u factor=1 pt=temp rsh=r_rm5s dw=0 pvc1=0 pvc2=0 ptc1=3.077e-03
+ ptc2=-1.14e-07 tfac=1.0 + ptc1 * (pt - 25.0) + ptc2 * (pt - 25.0) *
+ (pt - 25.0)
r1 ( n1 n2 ) bsource r=rsh * l * factor / (w * factor - dw) * (1 + pvc1 * (abs(v(n2,n1))
+ / l / factor) + pvc2 * (v(n2,n1) / l / factor) * (v(n2,n1) / l / factor)) * tfac
ends rm5s

//  *********************************     Metal 5  with W/S=0.42/0.21     ***********************************
subckt rm5w ( n1 n2 )
parameters l=1u w=1u factor=1 pt=temp rsh=r_rm5w dw=0 pvc1=0 pvc2=0 ptc1=3.077e-03
+ ptc2=-1.14e-07 tfac=1.0 + ptc1 * (pt - 25.0) + ptc2 * (pt - 25.0) *
+ (pt - 25.0)
r1 ( n1 n2 ) bsource r=rsh * l * factor / (w * factor - dw) * (1 + pvc1 * (abs(v(n2,n1))
+ / l / factor) + pvc2 * (v(n2,n1) / l / factor) * (v(n2,n1) / l / factor)) * tfac
ends rm5w

//  *********************************     Metal 6  with W/S=0.14/0.42     ***********************************
subckt rm6l ( n1 n2 )
parameters l=1u w=1u factor=1 pt=temp rsh=r_rm6l dw=0 pvc1=0 pvc2=0 ptc1=3.077e-03
+ ptc2=-1.14e-07 tfac=1.0 + ptc1 * (pt - 25.0) + ptc2 * (pt - 25.0) *
+ (pt - 25.0)
r1 ( n1 n2 ) bsource r=rsh * l * factor / (w * factor - dw) * (1 + pvc1 * (abs(v(n2,n1))
+ / l / factor) + pvc2 * (v(n2,n1) / l / factor) * (v(n2,n1) / l / factor)) * tfac
ends rm6l

//  *********************************     Metal 6 with W/S=0.14/0.14     ***********************************
subckt rm6s ( n1 n2 )
parameters l=1u w=1u factor=1 pt=temp rsh=r_rm6s dw=0 pvc1=0 pvc2=0 ptc1=3.077e-03
+ ptc2=-1.14e-07 tfac=1.0 + ptc1 * (pt - 25.0) + ptc2 * (pt - 25.0) *
+ (pt - 25.0)
r1 ( n1 n2 ) bsource r=rsh * l * factor / (w * factor - dw) * (1 + pvc1 * (abs(v(n2,n1))
+ / l / factor) + pvc2 * (v(n2,n1) / l / factor) * (v(n2,n1) / l / factor)) * tfac
ends rm6s

//  *********************************     Metal 6  with W/S=0.42/0.21     ***********************************
subckt rm6w ( n1 n2 )
parameters l=1u w=1u factor=1 pt=temp rsh=r_rm6w dw=0 pvc1=0 pvc2=0 ptc1=3.077e-03
+ ptc2=-1.14e-07 tfac=1.0 + ptc1 * (pt - 25.0) + ptc2 * (pt - 25.0) *
+ (pt - 25.0)
r1 ( n1 n2 ) bsource r=rsh * l * factor / (w * factor - dw) * (1 + pvc1 * (abs(v(n2,n1))
+ / l / factor) + pvc2 * (v(n2,n1) / l / factor) * (v(n2,n1) / l / factor)) * tfac
ends rm6w

//  *********************************     Metal 7 with W/S=0.14/0.42     ***********************************
subckt rm7l ( n1 n2 )
parameters l=1u w=1u factor=1 pt=temp rsh=r_rm7l dw=0 pvc1=0 pvc2=0 ptc1=3.077e-03
+ ptc2=-1.14e-07 tfac=1.0 + ptc1 * (pt - 25.0) + ptc2 * (pt - 25.0) *
+ (pt - 25.0)
r1 ( n1 n2 ) bsource r=rsh * l * factor / (w * factor - dw) * (1 + pvc1 * (abs(v(n2,n1))
+ / l / factor) + pvc2 * (v(n2,n1) / l / factor) * (v(n2,n1) / l / factor)) * tfac
ends rm7l

//  *********************************     Metal 7 with W/S=0.14/0.14     ***********************************
subckt rm7s ( n1 n2 )
parameters l=1u w=1u factor=1 pt=temp rsh=r_rm7s dw=0 pvc1=0 pvc2=0 ptc1=3.077e-03
+ ptc2=-1.14e-07 tfac=1.0 + ptc1 * (pt - 25.0) + ptc2 * (pt - 25.0) *
+ (pt - 25.0)
r1 ( n1 n2 ) bsource r=rsh * l * factor / (w * factor - dw) * (1 + pvc1 * (abs(v(n2,n1))
+ / l / factor) + pvc2 * (v(n2,n1) / l / factor) * (v(n2,n1) / l / factor)) * tfac
ends rm7s

//  *********************************     Metal 7 with W/S=0.42/0.21     ***********************************
subckt rm7w ( n1 n2 )
parameters l=1u w=1u factor=1 pt=temp rsh=r_rm7w dw=0 pvc1=0 pvc2=0 ptc1=3.077e-03
+ ptc2=-1.14e-07 tfac=1.0 + ptc1 * (pt - 25.0) + ptc2 * (pt - 25.0) *
+ (pt - 25.0)
r1 ( n1 n2 ) bsource r=rsh * l * factor / (w * factor - dw) * (1 + pvc1 * (abs(v(n2,n1))
+ / l / factor) + pvc2 * (v(n2,n1) / l / factor) * (v(n2,n1) / l / factor)) * tfac
ends rm7w

//  *********************************     Metal 8  with W/S=0.42/0.63     ***********************************
subckt rm8l ( n1 n2 )
parameters l=1u w=1u factor=1 pt=temp rsh=r_rm8l dw=0 pvc1=0 pvc2=0 ptc1=3.506e-03
+ ptc2=-3.60e-07 tfac=1.0 + ptc1 * (pt - 25.0) + ptc2 * (pt - 25.0) *
+ (pt - 25.0)
r1 ( n1 n2 ) bsource r=rsh * l * factor / (w * factor - dw) * (1 + pvc1 * (abs(v(n2,n1))
+ / l / factor) + pvc2 * (v(n2,n1) / l / factor) * (v(n2,n1) / l / factor)) * tfac
ends rm8l

//  *********************************     Metal 8  with W/S=0.42/0.42     ***********************************
subckt rm8s ( n1 n2 )
parameters l=1u w=1u factor=1 pt=temp rsh=r_rm8s dw=0 pvc1=0 pvc2=0 ptc1=3.506e-03
+ ptc2=-3.60e-07 tfac=1.0 + ptc1 * (pt - 25.0) + ptc2 * (pt - 25.0) *
+ (pt - 25.0)
r1 ( n1 n2 ) bsource r=rsh * l * factor / (w * factor - dw) * (1 + pvc1 * (abs(v(n2,n1))
+ / l / factor) + pvc2 * (v(n2,n1) / l / factor) * (v(n2,n1) / l / factor)) * tfac
ends rm8s

//  *********************************     Metal 8  with W/S=0.42/1.26     ***********************************
subckt rm8w ( n1 n2 )
parameters l=1u w=1u factor=1 pt=temp rsh=r_rm8w dw=0 pvc1=0 pvc2=0 ptc1=3.506e-03
+ ptc2=-3.60e-07 tfac=1.0 + ptc1 * (pt - 25.0) + ptc2 * (pt - 25.0) *
+ (pt - 25.0)
r1 ( n1 n2 ) bsource r=rsh * l * factor / (w * factor - dw) * (1 + pvc1 * (abs(v(n2,n1))
+ / l / factor) + pvc2 * (v(n2,n1) / l / factor) * (v(n2,n1) / l / factor)) * tfac
ends rm8w
//  *********************************     Metal 9  with W/S=0.42/0.63     ***********************************
subckt rm9l ( n1 n2 )
parameters l=1u w=1u factor=1 pt=temp rsh=r_rm9l dw=0 pvc1=0 pvc2=0 ptc1=3.506e-03
+ ptc2=-3.60e-07 tfac=1.0 + ptc1 * (pt - 25.0) + ptc2 * (pt - 25.0) *
+ (pt - 25.0)
r1 ( n1 n2 ) bsource r=rsh * l * factor / (w * factor - dw) * (1 + pvc1 * (abs(v(n2,n1))
+ / l / factor) + pvc2 * (v(n2,n1) / l / factor) * (v(n2,n1) / l / factor)) * tfac
ends rm9l

//  *********************************     Metal 9  with W/S=0.42/0.42     ***********************************
subckt rm9s ( n1 n2 )
parameters l=1u w=1u factor=1 pt=temp rsh=r_rm9s dw=0 pvc1=0 pvc2=0 ptc1=3.506e-03
+ ptc2=-3.60e-07 tfac=1.0 + ptc1 * (pt - 25.0) + ptc2 * (pt - 25.0) *
+ (pt - 25.0)
r1 ( n1 n2 ) bsource r=rsh * l * factor / (w * factor - dw) * (1 + pvc1 * (abs(v(n2,n1))
+ / l / factor) + pvc2 * (v(n2,n1) / l / factor) * (v(n2,n1) / l / factor)) * tfac
ends rm9s

//  *********************************     Metal 9  with W/S=0.42/1.26     ***********************************
subckt rm9w ( n1 n2 )
parameters l=1u w=1u factor=1 pt=temp rsh=r_rm9w dw=0 pvc1=0 pvc2=0 ptc1=3.506e-03
+ ptc2=-3.60e-07 tfac=1.0 + ptc1 * (pt - 25.0) + ptc2 * (pt - 25.0) *
+ (pt - 25.0)
r1 ( n1 n2 ) bsource r=rsh * l * factor / (w * factor - dw) * (1 + pvc1 * (abs(v(n2,n1))
+ / l / factor) + pvc2 * (v(n2,n1) / l / factor) * (v(n2,n1) / l / factor)) * tfac
ends rm9w

//  *********************************     Metal 10  with W/S=3/4.5     ***********************************
subckt rm10l ( n1 n2 )
parameters l=1u w=1u factor=1 pt=temp rsh=r_rm10l dw=0 pvc1=0 pvc2=0 ptc1=3.89e-03
+ ptc2=-1.50e-07 tfac=1.0 + ptc1 * (pt - 25.0) + ptc2 * (pt - 25.0) *
+ (pt - 25.0)
r1 ( n1 n2 ) bsource r=rsh * l * factor / (w * factor - dw) * (1 + pvc1 * (abs(v(n2,n1))
+ / l / factor) + pvc2 * (v(n2,n1) / l / factor) * (v(n2,n1) / l / factor)) * tfac
ends rm10l

//  *********************************     Metal 10  with W/S=3/2     ***********************************
subckt rm10s ( n1 n2 )
parameters l=1u w=1u factor=1 pt=temp rsh=r_rm10s dw=0 pvc1=0 pvc2=0 ptc1=3.89e-03
+ ptc2=-1.50e-07 tfac=1.0 + ptc1 * (pt - 25.0) + ptc2 * (pt - 25.0) *
+ (pt - 25.0)
r1 ( n1 n2 ) bsource r=rsh * l * factor / (w * factor - dw) * (1 + pvc1 * (abs(v(n2,n1))
+ / l / factor) + pvc2 * (v(n2,n1) / l / factor) * (v(n2,n1) / l / factor)) * tfac
ends rm10s

//  *********************************     Metal 10  with W/S=3/1.5     ***********************************
subckt rm10w ( n1 n2 )
parameters l=1u w=1u factor=1 pt=temp rsh=r_rm10w dw=0 pvc1=0 pvc2=0 ptc1=3.89e-03
+ ptc2=-1.50e-07 tfac=1.0 + ptc1 * (pt - 25.0) + ptc2 * (pt - 25.0) *
+ (pt - 25.0)
r1 ( n1 n2 ) bsource r=rsh * l * factor / (w * factor - dw) * (1 + pvc1 * (abs(v(n2,n1))
+ / l / factor) + pvc2 * (v(n2,n1) / l / factor) * (v(n2,n1) / l / factor)) * tfac
ends rm10w

//  *********************************     Metal 2 to 7 with W/S=0.14/0.42     ***********************************
subckt rm2_7l ( n1 n2 )
parameters l=1u w=1u factor=1 pt=temp rsh=r_rm2_7l dw=0 pvc1=0 pvc2=0 ptc1=3.077e-03
+ ptc2=-1.14e-07 tfac=1.0 + ptc1 * (pt - 25.0) + ptc2 * (pt - 25.0) *
+ (pt - 25.0)
r1 ( n1 n2 ) bsource r=rsh * l * factor / (w * factor - dw) * (1 + pvc1 * (abs(v(n2,n1))
+ / l / factor) + pvc2 * (v(n2,n1) / l / factor) * (v(n2,n1) / l / factor)) * tfac
ends rm2_7l

//  *********************************     Metal 2 to 7 with W/S=0.14/0.14     ***********************************
subckt rm2_7s ( n1 n2 )
parameters l=1u w=1u factor=1 pt=temp rsh=r_rm2_7s dw=0 pvc1=0 pvc2=0 ptc1=3.077e-03
+ ptc2=-1.14e-07 tfac=1.0 + ptc1 * (pt - 25.0) + ptc2 * (pt - 25.0) *
+ (pt - 25.0)
r1 ( n1 n2 ) bsource r=rsh * l * factor / (w * factor - dw) * (1 + pvc1 * (abs(v(n2,n1))
+ / l / factor) + pvc2 * (v(n2,n1) / l / factor) * (v(n2,n1) / l / factor)) * tfac
ends rm2_7s

//  *********************************     Metal 2 to 7 with W/S=0.42/0.21     ***********************************
subckt rm2_7w ( n1 n2 )
parameters l=1u w=1u factor=1 pt=temp rsh=r_rm2_7w dw=0 pvc1=0 pvc2=0 ptc1=3.077e-03
+ ptc2=-1.14e-07 tfac=1.0 + ptc1 * (pt - 25.0) + ptc2 * (pt - 25.0) *
+ (pt - 25.0)
r1 ( n1 n2 ) bsource r=rsh * l * factor / (w * factor - dw) * (1 + pvc1 * (abs(v(n2,n1))
+ / l / factor) + pvc2 * (v(n2,n1) / l / factor) * (v(n2,n1) / l / factor)) * tfac
ends rm2_7w

//  *********************************     Metal 8 to 9 with W/S=0.42/0.63     ***********************************
subckt rm8_9l ( n1 n2 )
parameters l=1u w=1u factor=1 pt=temp rsh=r_rm8_9l dw=0 pvc1=0 pvc2=0 ptc1=3.506e-03
+ ptc2=-3.60e-07 tfac=1.0 + ptc1 * (pt - 25.0) + ptc2 * (pt - 25.0) *
+ (pt - 25.0)
r1 ( n1 n2 ) bsource r=rsh * l * factor / (w * factor - dw) * (1 + pvc1 * (abs(v(n2,n1))
+ / l / factor) + pvc2 * (v(n2,n1) / l / factor) * (v(n2,n1) / l / factor)) * tfac
ends rm8_9l

//  *********************************     Metal 8 to 9  with W/S=0.42/0.42     ***********************************
subckt rm8_9s ( n1 n2 )
parameters l=1u w=1u factor=1 pt=temp rsh=r_rm8_9s dw=0 pvc1=0 pvc2=0 ptc1=3.506e-03
+ ptc2=-3.60e-07 tfac=1.0 + ptc1 * (pt - 25.0) + ptc2 * (pt - 25.0) *
+ (pt - 25.0)
r1 ( n1 n2 ) bsource r=rsh * l * factor / (w * factor - dw) * (1 + pvc1 * (abs(v(n2,n1))
+ / l / factor) + pvc2 * (v(n2,n1) / l / factor) * (v(n2,n1) / l / factor)) * tfac
ends rm8_9s

//  *********************************     Metal 8 to 9  with W/S=0.42/1.26     ***********************************
subckt rm8_9w ( n1 n2 )
parameters l=1u w=1u factor=1 pt=temp rsh=r_rm8_9w dw=0 pvc1=0 pvc2=0 ptc1=3.506e-03
+ ptc2=-3.60e-07 tfac=1.0 + ptc1 * (pt - 25.0) + ptc2 * (pt - 25.0) *
+ (pt - 25.0)
r1 ( n1 n2 ) bsource r=rsh * l * factor / (w * factor - dw) * (1 + pvc1 * (abs(v(n2,n1))
+ / l / factor) + pvc2 * (v(n2,n1) / l / factor) * (v(n2,n1) / l / factor)) * tfac
ends rm8_9w
//
endsection res
endlibrary tsmclib
